* VoxelThermalNetwork
.option klu
RINT0 nd0 nd216 2.418964854698e+00
RINT1 nd1 nd217 3.964969181739e+02
RINT2 nd2 nd218 4.774475759692e+00
RINT3 nd3 nd219 2.395258999122e+06
RINT4 nd4 nd220 3.992098331870e+05
RINT5 nd5 nd221 6.843597140349e+05
RINT6 nd6 nd222 6.843597140349e+05
RINT7 nd7 nd223 6.843597140349e+05
RINT8 nd8 nd224 6.843597140349e+05
RINT9 nd9 nd225 6.843597140349e+05
RINT10 nd10 nd226 6.843597140349e+05
RINT11 nd11 nd227 6.843597140349e+05
RINT12 nd12 nd228 5.771708431619e+04
RINT13 nd13 nd229 1.197629499561e+03
RINT14 nd14 nd230 1.996049165935e+00
RINT15 nd15 nd231 1.996049165935e+00
RINT16 nd16 nd232 1.996049165935e+00
RINT17 nd17 nd233 1.996049165935e+00
RINT18 nd18 nd234 6.144415500567e-02
RINT19 nd19 nd235 1.007142292796e+01
RINT20 nd20 nd236 1.212765154812e-01
RINT21 nd21 nd237 1.834889984701e+04
RINT22 nd22 nd238 3.058149974502e+03
RINT23 nd23 nd239 5.242542813433e+03
RINT24 nd24 nd240 5.242542813433e+03
RINT25 nd25 nd241 5.242542813433e+03
RINT26 nd26 nd242 5.242542813433e+03
RINT27 nd27 nd243 5.242542813433e+03
RINT28 nd28 nd244 5.242542813433e+03
RINT29 nd29 nd245 5.242542813433e+03
RINT30 nd30 nd246 4.421421649883e+02
RINT31 nd31 nd247 3.042100114331e+01
RINT32 nd32 nd248 5.070166857218e-02
RINT33 nd33 nd249 5.070166857218e-02
RINT34 nd34 nd250 5.070166857218e-02
RINT35 nd35 nd251 5.070166857218e-02
RINT36 nd36 nd252 1.629579834371e-02
RINT37 nd37 nd253 2.671073872742e+00
RINT38 nd38 nd254 3.216412757125e-02
RINT39 nd39 nd255 4.866369660521e+03
RINT40 nd40 nd256 8.110616100868e+02
RINT41 nd41 nd257 1.390391331577e+03
RINT42 nd42 nd258 1.390391331577e+03
RINT43 nd43 nd259 1.390391331577e+03
RINT44 nd44 nd260 1.390391331577e+03
RINT45 nd45 nd261 1.390391331577e+03
RINT46 nd46 nd262 1.390391331577e+03
RINT47 nd47 nd263 1.390391331577e+03
RINT48 nd48 nd264 1.172619195306e+02
RINT49 nd49 nd265 8.068049759972e+00
RINT50 nd50 nd266 1.344674959995e-02
RINT51 nd51 nd267 1.344674959995e-02
RINT52 nd52 nd268 1.344674959995e-02
RINT53 nd53 nd269 1.344674959995e-02
RINT54 nd54 nd270 1.629579834371e-02
RINT55 nd55 nd271 2.671073872742e+00
RINT56 nd56 nd272 3.216412757125e-02
RINT57 nd57 nd273 4.866369660521e+03
RINT58 nd58 nd274 8.110616100868e+02
RINT59 nd59 nd275 1.390391331577e+03
RINT60 nd60 nd276 1.390391331577e+03
RINT61 nd61 nd277 1.390391331577e+03
RINT62 nd62 nd278 1.390391331577e+03
RINT63 nd63 nd279 1.390391331577e+03
RINT64 nd64 nd280 1.390391331577e+03
RINT65 nd65 nd281 1.390391331577e+03
RINT66 nd66 nd282 1.172619195306e+02
RINT67 nd67 nd283 8.068049759972e+00
RINT68 nd68 nd284 1.344674959995e-02
RINT69 nd69 nd285 1.344674959995e-02
RINT70 nd70 nd286 1.344674959995e-02
RINT71 nd71 nd287 1.344674959995e-02
RINT72 nd72 nd288 2.657049558799e-01
RINT73 nd73 nd289 4.355218139912e+01
RINT74 nd74 nd290 5.244399763042e-01
RINT75 nd75 nd291 7.934674378460e+04
RINT76 nd76 nd292 1.322445729743e+04
RINT77 nd77 nd293 2.267049822417e+04
RINT78 nd78 nd294 2.267049822417e+04
RINT79 nd79 nd295 2.267049822417e+04
RINT80 nd80 nd296 2.267049822417e+04
RINT81 nd81 nd297 2.267049822417e+04
RINT82 nd82 nd298 2.267049822417e+04
RINT83 nd83 nd299 2.267049822417e+04
RINT84 nd84 nd300 1.911969729749e+03
RINT85 nd85 nd301 1.315505236561e+02
RINT86 nd86 nd302 2.192508727602e-01
RINT87 nd87 nd303 2.192508727602e-01
RINT88 nd88 nd304 2.192508727602e-01
RINT89 nd89 nd305 2.192508727602e-01
RINT90 nd90 nd306 1.438787188000e-02
RINT91 nd91 nd307 2.358342184435e+00
RINT92 nd92 nd308 2.839832310552e-02
RINT93 nd93 nd309 4.141842694694e+03
RINT94 nd94 nd310 6.901300733321e+02
RINT95 nd95 nd311 1.183171370696e+03
RINT96 nd96 nd312 1.183171370696e+03
RINT97 nd97 nd313 1.183171370696e+03
RINT98 nd98 nd314 1.183171370696e+03
RINT99 nd99 nd315 1.183171370696e+03
RINT100 nd100 nd316 1.183171370696e+03
RINT101 nd101 nd317 1.183171370696e+03
RINT102 nd102 nd318 9.977841194551e+01
RINT103 nd103 nd319 7.123435367788e+00
RINT104 nd104 nd320 1.187239227965e-02
RINT105 nd105 nd321 1.187239227965e-02
RINT106 nd106 nd322 1.187239227965e-02
RINT107 nd107 nd323 1.187239227965e-02
RINT108 nd108 nd324 1.438787188000e-02
RINT109 nd109 nd325 2.358342184435e+00
RINT110 nd110 nd326 2.839832310552e-02
RINT111 nd111 nd327 4.141842694694e+03
RINT112 nd112 nd328 6.901300733321e+02
RINT113 nd113 nd329 1.183171370696e+03
RINT114 nd114 nd330 1.183171370696e+03
RINT115 nd115 nd331 1.183171370696e+03
RINT116 nd116 nd332 1.183171370696e+03
RINT117 nd117 nd333 1.183171370696e+03
RINT118 nd118 nd334 1.183171370696e+03
RINT119 nd119 nd335 1.183171370696e+03
RINT120 nd120 nd336 9.977841194551e+01
RINT121 nd121 nd337 7.123435367788e+00
RINT122 nd122 nd338 1.187239227965e-02
RINT123 nd123 nd339 1.187239227965e-02
RINT124 nd124 nd340 1.187239227965e-02
RINT125 nd125 nd341 1.187239227965e-02
RINT126 nd126 nd342 2.657058100142e-01
RINT127 nd127 nd343 4.355232140183e+01
RINT128 nd128 nd344 5.244416621673e-01
RINT129 nd129 nd345 7.934699885239e+04
RINT130 nd130 nd346 1.322449980873e+04
RINT131 nd131 nd347 2.267057110068e+04
RINT132 nd132 nd348 2.267057110068e+04
RINT133 nd133 nd349 2.267057110068e+04
RINT134 nd134 nd350 2.267057110068e+04
RINT135 nd135 nd351 2.267057110068e+04
RINT136 nd136 nd352 2.267057110068e+04
RINT137 nd137 nd353 2.267057110068e+04
RINT138 nd138 nd354 1.911975875961e+03
RINT139 nd139 nd355 1.315509465380e+02
RINT140 nd140 nd356 2.192515775634e-01
RINT141 nd141 nd357 2.192515775634e-01
RINT142 nd142 nd358 2.192515775634e-01
RINT143 nd143 nd359 2.192515775634e-01
RINT144 nd144 nd360 1.629579834371e-02
RINT145 nd145 nd361 2.671073872742e+00
RINT146 nd146 nd362 3.216412757125e-02
RINT147 nd147 nd363 4.866369660521e+03
RINT148 nd148 nd364 8.110616100868e+02
RINT149 nd149 nd365 1.390391331577e+03
RINT150 nd150 nd366 1.390391331577e+03
RINT151 nd151 nd367 1.390391331577e+03
RINT152 nd152 nd368 1.390391331577e+03
RINT153 nd153 nd369 1.390391331577e+03
RINT154 nd154 nd370 1.390391331577e+03
RINT155 nd155 nd371 1.390391331577e+03
RINT156 nd156 nd372 1.172619195306e+02
RINT157 nd157 nd373 8.068049759972e+00
RINT158 nd158 nd374 1.344674959995e-02
RINT159 nd159 nd375 1.344674959995e-02
RINT160 nd160 nd376 1.344674959995e-02
RINT161 nd161 nd377 1.344674959995e-02
RINT162 nd162 nd378 1.629579834371e-02
RINT163 nd163 nd379 2.671073872742e+00
RINT164 nd164 nd380 3.216412757125e-02
RINT165 nd165 nd381 4.866369660521e+03
RINT166 nd166 nd382 8.110616100868e+02
RINT167 nd167 nd383 1.390391331577e+03
RINT168 nd168 nd384 1.390391331577e+03
RINT169 nd169 nd385 1.390391331577e+03
RINT170 nd170 nd386 1.390391331577e+03
RINT171 nd171 nd387 1.390391331577e+03
RINT172 nd172 nd388 1.390391331577e+03
RINT173 nd173 nd389 1.390391331577e+03
RINT174 nd174 nd390 1.172619195306e+02
RINT175 nd175 nd391 8.068049759972e+00
RINT176 nd176 nd392 1.344674959995e-02
RINT177 nd177 nd393 1.344674959995e-02
RINT178 nd178 nd394 1.344674959995e-02
RINT179 nd179 nd395 1.344674959995e-02
RINT180 nd180 nd396 6.144415500567e-02
RINT181 nd181 nd397 1.007142292796e+01
RINT182 nd182 nd398 1.212765154812e-01
RINT183 nd183 nd399 1.834889984701e+04
RINT184 nd184 nd400 3.058149974502e+03
RINT185 nd185 nd401 5.242542813433e+03
RINT186 nd186 nd402 5.242542813433e+03
RINT187 nd187 nd403 5.242542813433e+03
RINT188 nd188 nd404 5.242542813433e+03
RINT189 nd189 nd405 5.242542813433e+03
RINT190 nd190 nd406 5.242542813433e+03
RINT191 nd191 nd407 5.242542813433e+03
RINT192 nd192 nd408 4.421421649883e+02
RINT193 nd193 nd409 3.042100114331e+01
RINT194 nd194 nd410 5.070166857218e-02
RINT195 nd195 nd411 5.070166857218e-02
RINT196 nd196 nd412 5.070166857218e-02
RINT197 nd197 nd413 5.070166857218e-02
RINT198 nd198 nd414 2.418894064705e+00
RINT199 nd199 nd415 3.964853148577e+02
RINT200 nd200 nd416 4.774336036658e+00
RINT201 nd201 nd417 2.395188902871e+06
RINT202 nd202 nd418 3.991981504785e+05
RINT203 nd203 nd419 6.843396865345e+05
RINT204 nd204 nd420 6.843396865345e+05
RINT205 nd205 nd421 6.843396865345e+05
RINT206 nd206 nd422 6.843396865345e+05
RINT207 nd207 nd423 6.843396865345e+05
RINT208 nd208 nd424 6.843396865345e+05
RINT209 nd209 nd425 6.843396865345e+05
RINT210 nd210 nd426 5.771539524990e+04
RINT211 nd211 nd427 1.197594451435e+03
RINT212 nd212 nd428 1.995990752392e+00
RINT213 nd213 nd429 1.995990752392e+00
RINT214 nd214 nd430 1.995990752392e+00
RINT215 nd215 nd431 1.995990752392e+00
RINT216 nd216 nd432 4.468851815394e+02
RINT217 nd217 nd433 7.324976091067e+04
RINT218 nd218 nd434 8.820477331373e+02
RINT219 nd219 nd435 4.425057067603e+08
RINT220 nd220 nd436 7.375095112672e+07
RINT221 nd221 nd437 1.264302019315e+08
RINT222 nd222 nd438 1.264302019315e+08
RINT223 nd223 nd439 1.264302019315e+08
RINT224 nd224 nd440 1.264302019315e+08
RINT225 nd225 nd441 1.264302019315e+08
RINT226 nd226 nd442 1.264302019315e+08
RINT227 nd227 nd443 1.264302019315e+08
RINT228 nd228 nd444 1.066278811471e+07
RINT229 nd229 nd445 2.212528533802e+05
RINT230 nd230 nd446 3.687547556336e+02
RINT231 nd231 nd447 3.687547556336e+02
RINT232 nd232 nd448 3.687547556336e+02
RINT233 nd233 nd449 3.687547556336e+02
RINT234 nd234 nd450 1.135133580420e+01
RINT235 nd235 nd451 1.860618046923e+03
RINT236 nd236 nd452 2.240490494602e+01
RINT237 nd237 nd453 4.188723374767e+03
RINT238 nd238 nd454 5.020093907439e+02
RINT239 nd239 nd455 9.616602401535e+02
RINT240 nd240 nd456 9.616602401535e+02
RINT241 nd241 nd457 9.616602401535e+02
RINT242 nd242 nd458 9.616602401535e+02
RINT243 nd243 nd459 9.616602401535e+02
RINT244 nd244 nd460 9.616602401535e+02
RINT245 nd245 nd461 9.616602401535e+02
RINT246 nd246 nd462 7.321108388708e+01
RINT247 nd247 nd463 5.620046356661e+03
RINT248 nd248 nd464 9.366743927768e+00
RINT249 nd249 nd465 9.366743927768e+00
RINT250 nd250 nd466 9.366743927768e+00
RINT251 nd251 nd467 9.366743927768e+00
RINT252 nd252 nd468 3.010523607656e+00
RINT253 nd253 nd469 4.934603866638e+02
RINT254 nd254 nd470 5.942075578659e+00
RINT255 nd255 nd471 1.110904551076e+03
RINT256 nd256 nd472 1.331394954892e+02
RINT257 nd257 nd473 2.550449484945e+02
RINT258 nd258 nd474 2.550449484945e+02
RINT259 nd259 nd475 2.550449484945e+02
RINT260 nd260 nd476 2.550449484945e+02
RINT261 nd261 nd477 2.550449484945e+02
RINT262 nd262 nd478 2.550449484945e+02
RINT263 nd263 nd479 2.550449484945e+02
RINT264 nd264 nd480 1.941654270351e+01
RINT265 nd265 nd481 1.490510238151e+03
RINT266 nd266 nd482 2.484183730251e+00
RINT267 nd267 nd483 2.484183730251e+00
RINT268 nd268 nd484 2.484183730251e+00
RINT269 nd269 nd485 2.484183730251e+00
RINT270 nd270 nd486 3.010523607656e+00
RINT271 nd271 nd487 4.934603866638e+02
RINT272 nd272 nd488 5.942075578659e+00
RINT273 nd273 nd489 1.110904551076e+03
RINT274 nd274 nd490 1.331394954892e+02
RINT275 nd275 nd491 2.550449484945e+02
RINT276 nd276 nd492 2.550449484945e+02
RINT277 nd277 nd493 2.550449484945e+02
RINT278 nd278 nd494 2.550449484945e+02
RINT279 nd279 nd495 2.550449484945e+02
RINT280 nd280 nd496 2.550449484945e+02
RINT281 nd281 nd497 2.550449484945e+02
RINT282 nd282 nd498 1.941654270351e+01
RINT283 nd283 nd499 1.490510238151e+03
RINT284 nd284 nd500 2.484183730251e+00
RINT285 nd285 nd501 2.484183730251e+00
RINT286 nd286 nd502 2.484183730251e+00
RINT287 nd287 nd503 2.484183730251e+00
RINT288 nd288 nd504 4.908695023563e+01
RINT289 nd289 nd505 8.045931073857e+03
RINT290 nd290 nd506 9.688625841836e+01
RINT291 nd291 nd507 7.594671581769e+05
RINT292 nd292 nd508 1.265778596962e+05
RINT293 nd293 nd509 2.169906166220e+05
RINT294 nd294 nd510 2.169906166220e+05
RINT295 nd295 nd511 2.169906166220e+05
RINT296 nd296 nd512 2.169906166220e+05
RINT297 nd297 nd513 2.169906166220e+05
RINT298 nd298 nd514 2.169906166220e+05
RINT299 nd299 nd515 2.169906166220e+05
RINT300 nd300 nd516 1.830041345005e+04
RINT301 nd301 nd517 2.430294906166e+04
RINT302 nd302 nd518 4.050491510277e+01
RINT303 nd303 nd519 4.050491510277e+01
RINT304 nd304 nd520 4.050491510277e+01
RINT305 nd305 nd521 4.050491510277e+01
RINT306 nd306 nd522 2.658048844559e+00
RINT307 nd307 nd523 4.356856087332e+02
RINT308 nd308 nd524 5.246372121437e+00
RINT309 nd309 nd525 8.260707573614e+02
RINT310 nd310 nd526 9.157967870155e+01
RINT311 nd311 nd527 1.807523449652e+02
RINT312 nd312 nd528 1.807523449652e+02
RINT313 nd313 nd529 1.807523449652e+02
RINT314 nd314 nd530 1.807523449652e+02
RINT315 nd315 nd531 1.807523449652e+02
RINT316 nd316 nd532 1.807523449652e+02
RINT317 nd317 nd533 1.807523449652e+02
RINT318 nd318 nd534 1.338885826145e+01
RINT319 nd319 nd535 1.315999982941e+03
RINT320 nd320 nd536 2.193333304902e+00
RINT321 nd321 nd537 2.193333304902e+00
RINT322 nd322 nd538 2.193333304902e+00
RINT323 nd323 nd539 2.193333304902e+00
RINT324 nd324 nd540 2.658048844559e+00
RINT325 nd325 nd541 4.356856087332e+02
RINT326 nd326 nd542 5.246372121437e+00
RINT327 nd327 nd543 8.260707573614e+02
RINT328 nd328 nd544 9.157967870155e+01
RINT329 nd329 nd545 1.807523449652e+02
RINT330 nd330 nd546 1.807523449652e+02
RINT331 nd331 nd547 1.807523449652e+02
RINT332 nd332 nd548 1.807523449652e+02
RINT333 nd333 nd549 1.807523449652e+02
RINT334 nd334 nd550 1.807523449652e+02
RINT335 nd335 nd551 1.807523449652e+02
RINT336 nd336 nd552 1.338885826145e+01
RINT337 nd337 nd553 1.315999982941e+03
RINT338 nd338 nd554 2.193333304902e+00
RINT339 nd339 nd555 2.193333304902e+00
RINT340 nd340 nd556 2.193333304902e+00
RINT341 nd341 nd557 2.193333304902e+00
RINT342 nd342 nd558 4.908710803039e+01
RINT343 nd343 nd559 8.045956938282e+03
RINT344 nd344 nd560 9.688656986862e+01
RINT345 nd345 nd561 7.594695995577e+05
RINT346 nd346 nd562 1.265782665929e+05
RINT347 nd347 nd563 2.169913141593e+05
RINT348 nd348 nd564 2.169913141593e+05
RINT349 nd349 nd565 2.169913141593e+05
RINT350 nd350 nd566 2.169913141593e+05
RINT351 nd351 nd567 2.169913141593e+05
RINT352 nd352 nd568 2.169913141593e+05
RINT353 nd353 nd569 2.169913141593e+05
RINT354 nd354 nd570 1.830047227850e+04
RINT355 nd355 nd571 2.430302718585e+04
RINT356 nd356 nd572 4.050504530974e+01
RINT357 nd357 nd573 4.050504530974e+01
RINT358 nd358 nd574 4.050504530974e+01
RINT359 nd359 nd575 4.050504530974e+01
RINT360 nd360 nd576 3.010523607656e+00
RINT361 nd361 nd577 4.934603866638e+02
RINT362 nd362 nd578 5.942075578658e+00
RINT363 nd363 nd579 1.110904551076e+03
RINT364 nd364 nd580 1.331394954892e+02
RINT365 nd365 nd581 2.550449484945e+02
RINT366 nd366 nd582 2.550449484945e+02
RINT367 nd367 nd583 2.550449484945e+02
RINT368 nd368 nd584 2.550449484945e+02
RINT369 nd369 nd585 2.550449484945e+02
RINT370 nd370 nd586 2.550449484945e+02
RINT371 nd371 nd587 2.550449484945e+02
RINT372 nd372 nd588 1.941654270351e+01
RINT373 nd373 nd589 1.490510238151e+03
RINT374 nd374 nd590 2.484183730251e+00
RINT375 nd375 nd591 2.484183730251e+00
RINT376 nd376 nd592 2.484183730251e+00
RINT377 nd377 nd593 2.484183730251e+00
RINT378 nd378 nd594 3.010523607656e+00
RINT379 nd379 nd595 4.934603866638e+02
RINT380 nd380 nd596 5.942075578658e+00
RINT381 nd381 nd597 1.110904551076e+03
RINT382 nd382 nd598 1.331394954892e+02
RINT383 nd383 nd599 2.550449484945e+02
RINT384 nd384 nd600 2.550449484945e+02
RINT385 nd385 nd601 2.550449484945e+02
RINT386 nd386 nd602 2.550449484945e+02
RINT387 nd387 nd603 2.550449484945e+02
RINT388 nd388 nd604 2.550449484945e+02
RINT389 nd389 nd605 2.550449484945e+02
RINT390 nd390 nd606 1.941654270351e+01
RINT391 nd391 nd607 1.490510238151e+03
RINT392 nd392 nd608 2.484183730251e+00
RINT393 nd393 nd609 2.484183730251e+00
RINT394 nd394 nd610 2.484183730251e+00
RINT395 nd395 nd611 2.484183730251e+00
RINT396 nd396 nd612 1.135133580420e+01
RINT397 nd397 nd613 1.860618046923e+03
RINT398 nd398 nd614 2.240490494602e+01
RINT399 nd399 nd615 4.188723374767e+03
RINT400 nd400 nd616 5.020093907439e+02
RINT401 nd401 nd617 9.616602401535e+02
RINT402 nd402 nd618 9.616602401535e+02
RINT403 nd403 nd619 9.616602401535e+02
RINT404 nd404 nd620 9.616602401535e+02
RINT405 nd405 nd621 9.616602401535e+02
RINT406 nd406 nd622 9.616602401535e+02
RINT407 nd407 nd623 9.616602401535e+02
RINT408 nd408 nd624 7.321108388708e+01
RINT409 nd409 nd625 5.620046356661e+03
RINT410 nd410 nd626 9.366743927768e+00
RINT411 nd411 nd627 9.366743927768e+00
RINT412 nd412 nd628 9.366743927768e+00
RINT413 nd413 nd629 9.366743927768e+00
RINT414 nd414 nd630 4.468721036318e+02
RINT415 nd415 nd631 7.324761728710e+04
RINT416 nd416 nd632 8.820219203799e+02
RINT417 nd417 nd633 4.424927570162e+08
RINT418 nd418 nd634 7.374879283603e+07
RINT419 nd419 nd635 1.264265020046e+08
RINT420 nd420 nd636 1.264265020046e+08
RINT421 nd421 nd637 1.264265020046e+08
RINT422 nd422 nd638 1.264265020046e+08
RINT423 nd423 nd639 1.264265020046e+08
RINT424 nd424 nd640 1.264265020046e+08
RINT425 nd425 nd641 1.264265020046e+08
RINT426 nd426 nd642 1.066247607268e+07
RINT427 nd427 nd643 2.212463785081e+05
RINT428 nd428 nd644 3.687439641801e+02
RINT429 nd429 nd645 3.687439641801e+02
RINT430 nd430 nd646 3.687439641801e+02
RINT431 nd431 nd647 3.687439641801e+02
RINT432 nd432 nd648 4.468851815394e+02
RINT433 nd433 nd649 7.324976091067e+04
RINT434 nd434 nd650 8.820477331373e+02
RINT435 nd435 nd651 4.425057067603e+08
RINT436 nd436 nd652 7.375095112672e+07
RINT437 nd437 nd653 1.264302019315e+08
RINT438 nd438 nd654 1.264302019315e+08
RINT439 nd439 nd655 1.264302019315e+08
RINT440 nd440 nd656 1.264302019315e+08
RINT441 nd441 nd657 1.264302019315e+08
RINT442 nd442 nd658 1.264302019315e+08
RINT443 nd443 nd659 1.264302019315e+08
RINT444 nd444 nd660 1.066278811471e+07
RINT445 nd445 nd661 2.212528533802e+05
RINT446 nd446 nd662 3.687547556336e+02
RINT447 nd447 nd663 3.687547556336e+02
RINT448 nd448 nd664 3.687547556336e+02
RINT449 nd449 nd665 3.687547556336e+02
RINT450 nd450 nd666 1.135133580420e+01
RINT451 nd451 nd667 1.860618046923e+03
RINT452 nd452 nd668 2.240490494602e+01
RINT453 nd453 nd669 3.527778123429e+03
RINT454 nd454 nd670 3.910957798651e+02
RINT455 nd455 nd671 7.719122879540e+02
RINT456 nd456 nd672 7.719122879540e+02
RINT457 nd457 nd673 7.719122879540e+02
RINT458 nd458 nd674 7.719122879540e+02
RINT459 nd459 nd675 7.719122879540e+02
RINT460 nd460 nd676 7.719122879540e+02
RINT461 nd461 nd677 7.719122879540e+02
RINT462 nd462 nd678 5.717781540082e+01
RINT463 nd463 nd679 5.620046356661e+03
RINT464 nd464 nd680 9.366743927768e+00
RINT465 nd465 nd681 9.366743927768e+00
RINT466 nd466 nd682 9.366743927768e+00
RINT467 nd467 nd683 9.366743927768e+00
RINT468 nd468 nd684 3.010523607656e+00
RINT469 nd469 nd685 4.934603866638e+02
RINT470 nd470 nd686 5.942075578659e+00
RINT471 nd471 nd687 9.356131741980e+02
RINT472 nd472 nd688 1.037237465658e+02
RINT473 nd473 nd689 2.047212950096e+02
RINT474 nd474 nd690 2.047212950096e+02
RINT475 nd475 nd691 2.047212950096e+02
RINT476 nd476 nd692 2.047212950096e+02
RINT477 nd477 nd693 2.047212950096e+02
RINT478 nd478 nd694 2.047212950096e+02
RINT479 nd479 nd695 2.047212950096e+02
RINT480 nd480 nd696 1.516430894720e+01
RINT481 nd481 nd697 1.490510238151e+03
RINT482 nd482 nd698 2.484183730251e+00
RINT483 nd483 nd699 2.484183730251e+00
RINT484 nd484 nd700 2.484183730251e+00
RINT485 nd485 nd701 2.484183730251e+00
RINT486 nd486 nd702 3.010523607656e+00
RINT487 nd487 nd703 4.934603866638e+02
RINT488 nd488 nd704 5.942075578659e+00
RINT489 nd489 nd705 9.356131741980e+02
RINT490 nd490 nd706 1.037237465658e+02
RINT491 nd491 nd707 2.047212950096e+02
RINT492 nd492 nd708 2.047212950096e+02
RINT493 nd493 nd709 2.047212950096e+02
RINT494 nd494 nd710 2.047212950096e+02
RINT495 nd495 nd711 2.047212950096e+02
RINT496 nd496 nd712 2.047212950096e+02
RINT497 nd497 nd713 2.047212950096e+02
RINT498 nd498 nd714 1.516430894720e+01
RINT499 nd499 nd715 1.490510238151e+03
RINT500 nd500 nd716 2.484183730251e+00
RINT501 nd501 nd717 2.484183730251e+00
RINT502 nd502 nd718 2.484183730251e+00
RINT503 nd503 nd719 2.484183730251e+00
RINT504 nd504 nd720 4.908695023563e+01
RINT505 nd505 nd721 8.045931073857e+03
RINT506 nd506 nd722 9.688625841836e+01
RINT507 nd507 nd723 7.594671581769e+05
RINT508 nd508 nd724 1.265778596962e+05
RINT509 nd509 nd725 2.169906166220e+05
RINT510 nd510 nd726 2.169906166220e+05
RINT511 nd511 nd727 2.169906166220e+05
RINT512 nd512 nd728 2.169906166220e+05
RINT513 nd513 nd729 2.169906166220e+05
RINT514 nd514 nd730 2.169906166220e+05
RINT515 nd515 nd731 2.169906166220e+05
RINT516 nd516 nd732 1.830041345005e+04
RINT517 nd517 nd733 2.430294906166e+04
RINT518 nd518 nd734 4.050491510277e+01
RINT519 nd519 nd735 4.050491510277e+01
RINT520 nd520 nd736 4.050491510277e+01
RINT521 nd521 nd737 4.050491510277e+01
RINT522 nd522 nd738 2.658048844559e+00
RINT523 nd523 nd739 4.356856087332e+02
RINT524 nd524 nd740 5.246372121437e+00
RINT525 nd525 nd741 9.808388650042e+02
RINT526 nd526 nd742 1.175514057588e+02
RINT527 nd527 nd743 2.251840606506e+02
RINT528 nd528 nd744 2.251840606506e+02
RINT529 nd529 nd745 2.251840606506e+02
RINT530 nd530 nd746 2.251840606506e+02
RINT531 nd531 nd747 2.251840606506e+02
RINT532 nd532 nd748 2.251840606506e+02
RINT533 nd533 nd749 2.251840606506e+02
RINT534 nd534 nd750 1.714323673368e+01
RINT535 nd535 nd751 1.315999982941e+03
RINT536 nd536 nd752 2.193333304902e+00
RINT537 nd537 nd753 2.193333304902e+00
RINT538 nd538 nd754 2.193333304902e+00
RINT539 nd539 nd755 2.193333304902e+00
RINT540 nd540 nd756 2.658048844559e+00
RINT541 nd541 nd757 4.356856087332e+02
RINT542 nd542 nd758 5.246372121437e+00
RINT543 nd543 nd759 9.808388650042e+02
RINT544 nd544 nd760 1.175514057588e+02
RINT545 nd545 nd761 2.251840606506e+02
RINT546 nd546 nd762 2.251840606506e+02
RINT547 nd547 nd763 2.251840606506e+02
RINT548 nd548 nd764 2.251840606506e+02
RINT549 nd549 nd765 2.251840606506e+02
RINT550 nd550 nd766 2.251840606506e+02
RINT551 nd551 nd767 2.251840606506e+02
RINT552 nd552 nd768 1.714323673368e+01
RINT553 nd553 nd769 1.315999982941e+03
RINT554 nd554 nd770 2.193333304902e+00
RINT555 nd555 nd771 2.193333304902e+00
RINT556 nd556 nd772 2.193333304902e+00
RINT557 nd557 nd773 2.193333304902e+00
RINT558 nd558 nd774 4.908710803039e+01
RINT559 nd559 nd775 8.045956938282e+03
RINT560 nd560 nd776 9.688656986862e+01
RINT561 nd561 nd777 7.594695995577e+05
RINT562 nd562 nd778 1.265782665929e+05
RINT563 nd563 nd779 2.169913141593e+05
RINT564 nd564 nd780 2.169913141593e+05
RINT565 nd565 nd781 2.169913141593e+05
RINT566 nd566 nd782 2.169913141593e+05
RINT567 nd567 nd783 2.169913141593e+05
RINT568 nd568 nd784 2.169913141593e+05
RINT569 nd569 nd785 2.169913141593e+05
RINT570 nd570 nd786 1.830047227850e+04
RINT571 nd571 nd787 2.430302718585e+04
RINT572 nd572 nd788 4.050504530974e+01
RINT573 nd573 nd789 4.050504530974e+01
RINT574 nd574 nd790 4.050504530974e+01
RINT575 nd575 nd791 4.050504530974e+01
RINT576 nd576 nd792 3.010523607656e+00
RINT577 nd577 nd793 4.934603866638e+02
RINT578 nd578 nd794 5.942075578658e+00
RINT579 nd579 nd795 9.356131741980e+02
RINT580 nd580 nd796 1.037237465658e+02
RINT581 nd581 nd797 2.047212950096e+02
RINT582 nd582 nd798 2.047212950096e+02
RINT583 nd583 nd799 2.047212950096e+02
RINT584 nd584 nd800 2.047212950096e+02
RINT585 nd585 nd801 2.047212950096e+02
RINT586 nd586 nd802 2.047212950096e+02
RINT587 nd587 nd803 2.047212950096e+02
RINT588 nd588 nd804 1.516430894720e+01
RINT589 nd589 nd805 1.490510238151e+03
RINT590 nd590 nd806 2.484183730251e+00
RINT591 nd591 nd807 2.484183730251e+00
RINT592 nd592 nd808 2.484183730251e+00
RINT593 nd593 nd809 2.484183730251e+00
RINT594 nd594 nd810 3.010523607656e+00
RINT595 nd595 nd811 4.934603866638e+02
RINT596 nd596 nd812 5.942075578658e+00
RINT597 nd597 nd813 9.356131741980e+02
RINT598 nd598 nd814 1.037237465658e+02
RINT599 nd599 nd815 2.047212950096e+02
RINT600 nd600 nd816 2.047212950096e+02
RINT601 nd601 nd817 2.047212950096e+02
RINT602 nd602 nd818 2.047212950096e+02
RINT603 nd603 nd819 2.047212950096e+02
RINT604 nd604 nd820 2.047212950096e+02
RINT605 nd605 nd821 2.047212950096e+02
RINT606 nd606 nd822 1.516430894720e+01
RINT607 nd607 nd823 1.490510238151e+03
RINT608 nd608 nd824 2.484183730251e+00
RINT609 nd609 nd825 2.484183730251e+00
RINT610 nd610 nd826 2.484183730251e+00
RINT611 nd611 nd827 2.484183730251e+00
RINT612 nd612 nd828 1.135133580420e+01
RINT613 nd613 nd829 1.860618046923e+03
RINT614 nd614 nd830 2.240490494602e+01
RINT615 nd615 nd831 3.527778123429e+03
RINT616 nd616 nd832 3.910957798651e+02
RINT617 nd617 nd833 7.719122879540e+02
RINT618 nd618 nd834 7.719122879540e+02
RINT619 nd619 nd835 7.719122879540e+02
RINT620 nd620 nd836 7.719122879540e+02
RINT621 nd621 nd837 7.719122879540e+02
RINT622 nd622 nd838 7.719122879540e+02
RINT623 nd623 nd839 7.719122879540e+02
RINT624 nd624 nd840 5.717781540082e+01
RINT625 nd625 nd841 5.620046356661e+03
RINT626 nd626 nd842 9.366743927768e+00
RINT627 nd627 nd843 9.366743927768e+00
RINT628 nd628 nd844 9.366743927768e+00
RINT629 nd629 nd845 9.366743927768e+00
RINT630 nd630 nd846 4.468721036318e+02
RINT631 nd631 nd847 7.324761728710e+04
RINT632 nd632 nd848 8.820219203799e+02
RINT633 nd633 nd849 4.424927570162e+08
RINT634 nd634 nd850 7.374879283603e+07
RINT635 nd635 nd851 1.264265020046e+08
RINT636 nd636 nd852 1.264265020046e+08
RINT637 nd637 nd853 1.264265020046e+08
RINT638 nd638 nd854 1.264265020046e+08
RINT639 nd639 nd855 1.264265020046e+08
RINT640 nd640 nd856 1.264265020046e+08
RINT641 nd641 nd857 1.264265020046e+08
RINT642 nd642 nd858 1.066247607268e+07
RINT643 nd643 nd859 2.212463785081e+05
RINT644 nd644 nd860 3.687439641801e+02
RINT645 nd645 nd861 3.687439641801e+02
RINT646 nd646 nd862 3.687439641801e+02
RINT647 nd647 nd863 3.687439641801e+02
RINT648 nd648 nd864 2.184681757134e+01
RINT649 nd649 nd865 3.580951505815e+03
RINT650 nd650 nd866 4.312055246202e+01
RINT651 nd651 nd867 2.163271875915e+07
RINT652 nd652 nd868 3.605453126524e+06
RINT653 nd653 nd869 6.180776788327e+06
RINT654 nd654 nd870 6.180776788327e+06
RINT655 nd655 nd871 6.180776788327e+06
RINT656 nd656 nd872 6.180776788327e+06
RINT657 nd657 nd873 6.180776788327e+06
RINT658 nd658 nd874 6.180776788327e+06
RINT659 nd659 nd875 6.180776788327e+06
RINT660 nd660 nd876 5.212703315457e+05
RINT661 nd661 nd877 1.081635937957e+04
RINT662 nd662 nd878 1.802726563262e+01
RINT663 nd663 nd879 1.802726563262e+01
RINT664 nd664 nd880 1.802726563262e+01
RINT665 nd665 nd881 1.802726563262e+01
RINT666 nd666 nd882 5.549312726173e-01
RINT667 nd667 nd883 9.095979173230e+01
RINT668 nd668 nd884 1.095305665256e+00
RINT669 nd669 nd885 7.924882032189e+03
RINT670 nd670 nd886 1.320057603042e+03
RINT671 nd671 nd887 2.263345557379e+03
RINT672 nd672 nd888 2.263345557379e+03
RINT673 nd673 nd889 2.263345557379e+03
RINT674 nd674 nd890 2.263345557379e+03
RINT675 nd675 nd891 2.263345557379e+03
RINT676 nd676 nd892 2.263345557379e+03
RINT677 nd677 nd893 2.263345557379e+03
RINT678 nd678 nd894 1.908541359361e+02
RINT679 nd679 nd895 2.747464730728e+02
RINT680 nd680 nd896 4.579107884547e-01
RINT681 nd681 nd897 4.579107884547e-01
RINT682 nd682 nd898 4.579107884547e-01
RINT683 nd683 nd899 4.579107884547e-01
RINT684 nd684 nd900 1.471750748685e-01
RINT685 nd685 nd901 2.412373354828e+01
RINT686 nd686 nd902 2.904894736382e-01
RINT687 nd687 nd903 2.101782984604e+03
RINT688 nd688 nd904 3.500966446569e+02
RINT689 nd689 nd905 6.002690212241e+02
RINT690 nd690 nd906 6.002690212241e+02
RINT691 nd691 nd907 6.002690212241e+02
RINT692 nd692 nd908 6.002690212241e+02
RINT693 nd693 nd909 6.002690212241e+02
RINT694 nd694 nd910 6.002690212241e+02
RINT695 nd695 nd911 6.002690212241e+02
RINT696 nd696 nd912 5.061702796614e+01
RINT697 nd697 nd913 7.286637956741e+01
RINT698 nd698 nd914 1.214439659457e-01
RINT699 nd699 nd915 1.214439659457e-01
RINT700 nd700 nd916 1.214439659457e-01
RINT701 nd701 nd917 1.214439659457e-01
RINT702 nd702 nd918 1.471750748685e-01
RINT703 nd703 nd919 2.412373354828e+01
RINT704 nd704 nd920 2.904894736382e-01
RINT705 nd705 nd921 2.101782984604e+03
RINT706 nd706 nd922 3.500966446569e+02
RINT707 nd707 nd923 6.002690212241e+02
RINT708 nd708 nd924 6.002690212241e+02
RINT709 nd709 nd925 6.002690212241e+02
RINT710 nd710 nd926 6.002690212241e+02
RINT711 nd711 nd927 6.002690212241e+02
RINT712 nd712 nd928 6.002690212241e+02
RINT713 nd713 nd929 6.002690212241e+02
RINT714 nd714 nd930 5.061702796614e+01
RINT715 nd715 nd931 7.286637956741e+01
RINT716 nd716 nd932 1.214439659457e-01
RINT717 nd717 nd933 1.214439659457e-01
RINT718 nd718 nd934 1.214439659457e-01
RINT719 nd719 nd935 1.214439659457e-01
RINT720 nd720 nd936 2.399707332513e+00
RINT721 nd721 nd937 3.933403827727e+02
RINT722 nd722 nd938 4.736465875966e+00
RINT723 nd723 nd939 3.712797188523e+04
RINT724 nd724 nd940 6.187995314204e+03
RINT725 nd725 nd941 1.060799196721e+04
RINT726 nd726 nd942 1.060799196721e+04
RINT727 nd727 nd943 1.060799196721e+04
RINT728 nd728 nd944 1.060799196721e+04
RINT729 nd729 nd945 1.060799196721e+04
RINT730 nd730 nd946 1.060799196721e+04
RINT731 nd731 nd947 1.060799196721e+04
RINT732 nd732 nd948 8.946499249452e+02
RINT733 nd733 nd949 1.188095100327e+03
RINT734 nd734 nd950 1.980158500545e+00
RINT735 nd735 nd951 1.980158500545e+00
RINT736 nd736 nd952 1.980158500545e+00
RINT737 nd737 nd953 1.980158500545e+00
RINT738 nd738 nd954 1.299436871072e-01
RINT739 nd739 nd955 2.129930551661e+01
RINT740 nd740 nd956 2.564787094833e-01
RINT741 nd741 nd957 2.010472483962e+03
RINT742 nd742 nd958 3.350787473270e+02
RINT743 nd743 nd959 5.744207097034e+02
RINT744 nd744 nd960 5.744207097034e+02
RINT745 nd745 nd961 5.744207097034e+02
RINT746 nd746 nd962 5.744207097034e+02
RINT747 nd747 nd963 5.744207097034e+02
RINT748 nd748 nd964 5.744207097034e+02
RINT749 nd749 nd965 5.744207097034e+02
RINT750 nd750 nd966 4.844512009547e+01
RINT751 nd751 nd967 6.433511948678e+01
RINT752 nd752 nd968 1.072251991446e-01
RINT753 nd753 nd969 1.072251991446e-01
RINT754 nd754 nd970 1.072251991446e-01
RINT755 nd755 nd971 1.072251991446e-01
RINT756 nd756 nd972 1.299436871072e-01
RINT757 nd757 nd973 2.129930551661e+01
RINT758 nd758 nd974 2.564787094833e-01
RINT759 nd759 nd975 2.010472483962e+03
RINT760 nd760 nd976 3.350787473270e+02
RINT761 nd761 nd977 5.744207097034e+02
RINT762 nd762 nd978 5.744207097034e+02
RINT763 nd763 nd979 5.744207097034e+02
RINT764 nd764 nd980 5.744207097034e+02
RINT765 nd765 nd981 5.744207097034e+02
RINT766 nd766 nd982 5.744207097034e+02
RINT767 nd767 nd983 5.744207097034e+02
RINT768 nd768 nd984 4.844512009547e+01
RINT769 nd769 nd985 6.433511948678e+01
RINT770 nd770 nd986 1.072251991446e-01
RINT771 nd771 nd987 1.072251991446e-01
RINT772 nd772 nd988 1.072251991446e-01
RINT773 nd773 nd989 1.072251991446e-01
RINT774 nd774 nd990 2.399715046605e+00
RINT775 nd775 nd991 3.933416472035e+02
RINT776 nd776 nd992 4.736481101794e+00
RINT777 nd777 nd993 3.712809123669e+04
RINT778 nd778 nd994 6.188015206115e+03
RINT779 nd779 nd995 1.060802606763e+04
RINT780 nd780 nd996 1.060802606763e+04
RINT781 nd781 nd997 1.060802606763e+04
RINT782 nd782 nd998 1.060802606763e+04
RINT783 nd783 nd999 1.060802606763e+04
RINT784 nd784 nd1000 1.060802606763e+04
RINT785 nd785 nd1001 1.060802606763e+04
RINT786 nd786 nd1002 8.946528008840e+02
RINT787 nd787 nd1003 1.188098919574e+03
RINT788 nd788 nd1004 1.980164865957e+00
RINT789 nd789 nd1005 1.980164865957e+00
RINT790 nd790 nd1006 1.980164865957e+00
RINT791 nd791 nd1007 1.980164865957e+00
RINT792 nd792 nd1008 1.471750748685e-01
RINT793 nd793 nd1009 2.412373354828e+01
RINT794 nd794 nd1010 2.904894736382e-01
RINT795 nd795 nd1011 2.101782984604e+03
RINT796 nd796 nd1012 3.500966446569e+02
RINT797 nd797 nd1013 6.002690212241e+02
RINT798 nd798 nd1014 6.002690212241e+02
RINT799 nd799 nd1015 6.002690212241e+02
RINT800 nd800 nd1016 6.002690212241e+02
RINT801 nd801 nd1017 6.002690212241e+02
RINT802 nd802 nd1018 6.002690212241e+02
RINT803 nd803 nd1019 6.002690212241e+02
RINT804 nd804 nd1020 5.061702796614e+01
RINT805 nd805 nd1021 7.286637956741e+01
RINT806 nd806 nd1022 1.214439659457e-01
RINT807 nd807 nd1023 1.214439659457e-01
RINT808 nd808 nd1024 1.214439659457e-01
RINT809 nd809 nd1025 1.214439659457e-01
RINT810 nd810 nd1026 1.471750748685e-01
RINT811 nd811 nd1027 2.412373354828e+01
RINT812 nd812 nd1028 2.904894736382e-01
RINT813 nd813 nd1029 2.101782984604e+03
RINT814 nd814 nd1030 3.500966446569e+02
RINT815 nd815 nd1031 6.002690212241e+02
RINT816 nd816 nd1032 6.002690212241e+02
RINT817 nd817 nd1033 6.002690212241e+02
RINT818 nd818 nd1034 6.002690212241e+02
RINT819 nd819 nd1035 6.002690212241e+02
RINT820 nd820 nd1036 6.002690212241e+02
RINT821 nd821 nd1037 6.002690212241e+02
RINT822 nd822 nd1038 5.061702796614e+01
RINT823 nd823 nd1039 7.286637956741e+01
RINT824 nd824 nd1040 1.214439659457e-01
RINT825 nd825 nd1041 1.214439659457e-01
RINT826 nd826 nd1042 1.214439659457e-01
RINT827 nd827 nd1043 1.214439659457e-01
RINT828 nd828 nd1044 5.549312726173e-01
RINT829 nd829 nd1045 9.095979173230e+01
RINT830 nd830 nd1046 1.095305665256e+00
RINT831 nd831 nd1047 7.924882032189e+03
RINT832 nd832 nd1048 1.320057603042e+03
RINT833 nd833 nd1049 2.263345557379e+03
RINT834 nd834 nd1050 2.263345557379e+03
RINT835 nd835 nd1051 2.263345557379e+03
RINT836 nd836 nd1052 2.263345557379e+03
RINT837 nd837 nd1053 2.263345557379e+03
RINT838 nd838 nd1054 2.263345557379e+03
RINT839 nd839 nd1055 2.263345557379e+03
RINT840 nd840 nd1056 1.908541359361e+02
RINT841 nd841 nd1057 2.747464730728e+02
RINT842 nd842 nd1058 4.579107884547e-01
RINT843 nd843 nd1059 4.579107884547e-01
RINT844 nd844 nd1060 4.579107884547e-01
RINT845 nd845 nd1061 4.579107884547e-01
RINT846 nd846 nd1062 2.184617823338e+01
RINT847 nd847 nd1063 3.580846710770e+03
RINT848 nd848 nd1064 4.311929055711e+01
RINT849 nd849 nd1065 2.163208568669e+07
RINT850 nd850 nd1066 3.605347614449e+06
RINT851 nd851 nd1067 6.180595910484e+06
RINT852 nd852 nd1068 6.180595910484e+06
RINT853 nd853 nd1069 6.180595910484e+06
RINT854 nd854 nd1070 6.180595910484e+06
RINT855 nd855 nd1071 6.180595910484e+06
RINT856 nd856 nd1072 6.180595910484e+06
RINT857 nd857 nd1073 6.180595910484e+06
RINT858 nd858 nd1074 5.212550767878e+05
RINT859 nd859 nd1075 1.081604284335e+04
RINT860 nd860 nd1076 1.802673807224e+01
RINT861 nd861 nd1077 1.802673807224e+01
RINT862 nd862 nd1078 1.802673807224e+01
RINT863 nd863 nd1079 1.802673807224e+01
RINT864 nd864 nd1080 3.969489229746e+02
RINT865 nd865 nd1081 6.506461816764e+04
RINT866 nd866 nd1082 7.834851369985e+02
RINT867 nd867 nd1083 3.930588235294e+08
RINT868 nd868 nd1084 6.550980392157e+07
RINT869 nd869 nd1085 1.123025210084e+08
RINT870 nd870 nd1086 1.123025210084e+08
RINT871 nd871 nd1087 1.123025210084e+08
RINT872 nd872 nd1088 1.123025210084e+08
RINT873 nd873 nd1089 1.123025210084e+08
RINT874 nd874 nd1090 1.123025210084e+08
RINT875 nd875 nd1091 1.123025210084e+08
RINT876 nd876 nd1092 9.471296952516e+06
RINT877 nd877 nd1093 1.965294117647e+05
RINT878 nd878 nd1094 3.275490196078e+02
RINT879 nd879 nd1095 3.275490196078e+02
RINT880 nd880 nd1096 3.275490196078e+02
RINT881 nd881 nd1097 3.275490196078e+02
RINT882 nd882 nd1098 1.008290430727e+01
RINT883 nd883 nd1099 1.652707138887e+03
RINT884 nd884 nd1100 1.990131527082e+01
RINT885 nd885 nd1101 1.560014350791e+05
RINT886 nd886 nd1102 2.600023917985e+04
RINT887 nd887 nd1103 4.457183859403e+04
RINT888 nd888 nd1104 4.457183859403e+04
RINT889 nd889 nd1105 4.457183859403e+04
RINT890 nd890 nd1106 4.457183859403e+04
RINT891 nd891 nd1107 4.457183859403e+04
RINT892 nd892 nd1108 4.457183859403e+04
RINT893 nd893 nd1109 4.457183859403e+04
RINT894 nd894 nd1110 3.759070724798e+03
RINT895 nd895 nd1111 4.992045922532e+03
RINT896 nd896 nd1112 8.320076537553e+00
RINT897 nd897 nd1113 8.320076537553e+00
RINT898 nd898 nd1114 8.320076537553e+00
RINT899 nd899 nd1115 8.320076537553e+00
RINT900 nd900 nd1116 2.674118885599e+00
RINT901 nd901 nd1117 4.383196783166e+02
RINT902 nd902 nd1118 5.278090656434e+00
RINT903 nd903 nd1119 2.885955121870e+03
RINT904 nd904 nd1120 4.494454511947e+02
RINT905 nd905 nd1121 7.704779163337e+02
RINT906 nd906 nd1122 7.704779163337e+02
RINT907 nd907 nd1123 7.704779163337e+02
RINT908 nd908 nd1124 7.704779163337e+02
RINT909 nd909 nd1125 7.704779163337e+02
RINT910 nd910 nd1126 7.704779163337e+02
RINT911 nd911 nd1127 7.704779163337e+02
RINT912 nd912 nd1128 6.500775286230e+01
RINT913 nd913 nd1129 1.323956260260e+03
RINT914 nd914 nd1130 2.206593767100e+00
RINT915 nd915 nd1131 2.206593767100e+00
RINT916 nd916 nd1132 2.206593767100e+00
RINT917 nd917 nd1133 2.206593767100e+00
RINT918 nd918 nd1134 2.674118885599e+00
RINT919 nd919 nd1135 4.383196783166e+02
RINT920 nd920 nd1136 5.278090656434e+00
RINT921 nd921 nd1137 2.885955121870e+03
RINT922 nd922 nd1138 4.494454511947e+02
RINT923 nd923 nd1139 7.704779163337e+02
RINT924 nd924 nd1140 7.704779163337e+02
RINT925 nd925 nd1141 7.704779163337e+02
RINT926 nd926 nd1142 7.704779163337e+02
RINT927 nd927 nd1143 7.704779163337e+02
RINT928 nd928 nd1144 7.704779163337e+02
RINT929 nd929 nd1145 7.704779163337e+02
RINT930 nd930 nd1146 6.500775286230e+01
RINT931 nd931 nd1147 1.323956260260e+03
RINT932 nd932 nd1148 2.206593767100e+00
RINT933 nd933 nd1149 2.206593767100e+00
RINT934 nd934 nd1150 2.206593767100e+00
RINT935 nd935 nd1151 2.206593767100e+00
RINT936 nd936 nd1152 4.360183070072e+01
RINT937 nd937 nd1153 7.146855178982e+03
RINT938 nd938 nd1154 8.605990424145e+01
RINT939 nd939 nd1155 4.705584606253e+04
RINT940 nd940 nd1156 7.328262246580e+03
RINT941 nd941 nd1157 1.256273527985e+04
RINT942 nd942 nd1158 1.256273527985e+04
RINT943 nd943 nd1159 1.256273527985e+04
RINT944 nd944 nd1160 1.256273527985e+04
RINT945 nd945 nd1161 1.256273527985e+04
RINT946 nd946 nd1162 1.256273527985e+04
RINT947 nd947 nd1163 1.256273527985e+04
RINT948 nd948 nd1164 1.059959244819e+03
RINT949 nd949 nd1165 2.158726637993e+04
RINT950 nd950 nd1166 3.597877729988e+01
RINT951 nd951 nd1167 3.597877729988e+01
RINT952 nd952 nd1168 3.597877729988e+01
RINT953 nd953 nd1169 3.597877729988e+01
RINT954 nd954 nd1170 2.361030684497e+00
RINT955 nd955 nd1171 3.870008232236e+02
RINT956 nd956 nd1172 4.660127140386e+00
RINT957 nd957 nd1173 2.548064947116e+03
RINT958 nd958 nd1174 3.968239807860e+02
RINT959 nd959 nd1175 6.802696813474e+02
RINT960 nd960 nd1176 6.802696813474e+02
RINT961 nd961 nd1177 6.802696813474e+02
RINT962 nd962 nd1178 6.802696813474e+02
RINT963 nd963 nd1179 6.802696813474e+02
RINT964 nd964 nd1180 6.802696813474e+02
RINT965 nd965 nd1181 6.802696813474e+02
RINT966 nd966 nd1182 5.739658773762e+01
RINT967 nd967 nd1183 1.168946291894e+03
RINT968 nd968 nd1184 1.948243819824e+00
RINT969 nd969 nd1185 1.948243819824e+00
RINT970 nd970 nd1186 1.948243819824e+00
RINT971 nd971 nd1187 1.948243819824e+00
RINT972 nd972 nd1188 2.361030684497e+00
RINT973 nd973 nd1189 3.870008232236e+02
RINT974 nd974 nd1190 4.660127140386e+00
RINT975 nd975 nd1191 2.548064947116e+03
RINT976 nd976 nd1192 3.968239807860e+02
RINT977 nd977 nd1193 6.802696813474e+02
RINT978 nd978 nd1194 6.802696813474e+02
RINT979 nd979 nd1195 6.802696813474e+02
RINT980 nd980 nd1196 6.802696813474e+02
RINT981 nd981 nd1197 6.802696813474e+02
RINT982 nd982 nd1198 6.802696813474e+02
RINT983 nd983 nd1199 6.802696813474e+02
RINT984 nd984 nd1200 5.739658773762e+01
RINT985 nd985 nd1201 1.168946291894e+03
RINT986 nd986 nd1202 1.948243819824e+00
RINT987 nd987 nd1203 1.948243819824e+00
RINT988 nd988 nd1204 1.948243819824e+00
RINT989 nd989 nd1205 1.948243819824e+00
RINT990 nd990 nd1206 4.360197086303e+01
RINT991 nd991 nd1207 7.146878153240e+03
RINT992 nd992 nd1208 8.606018088935e+01
RINT993 nd993 nd1209 4.705599732811e+04
RINT994 nd994 nd1210 7.328285803988e+03
RINT995 nd995 nd1211 1.256277566398e+04
RINT996 nd996 nd1212 1.256277566398e+04
RINT997 nd997 nd1213 1.256277566398e+04
RINT998 nd998 nd1214 1.256277566398e+04
RINT999 nd999 nd1215 1.256277566398e+04
RINT1000 nd1000 nd1216 1.256277566398e+04
RINT1001 nd1001 nd1217 1.256277566398e+04
RINT1002 nd1002 nd1218 1.059962652161e+03
RINT1003 nd1003 nd1219 2.158733577428e+04
RINT1004 nd1004 nd1220 3.597889295714e+01
RINT1005 nd1005 nd1221 3.597889295714e+01
RINT1006 nd1006 nd1222 3.597889295714e+01
RINT1007 nd1007 nd1223 3.597889295714e+01
RINT1008 nd1008 nd1224 2.674118885599e+00
RINT1009 nd1009 nd1225 4.383196783166e+02
RINT1010 nd1010 nd1226 5.278090656434e+00
RINT1011 nd1011 nd1227 2.885955121870e+03
RINT1012 nd1012 nd1228 4.494454511947e+02
RINT1013 nd1013 nd1229 7.704779163337e+02
RINT1014 nd1014 nd1230 7.704779163337e+02
RINT1015 nd1015 nd1231 7.704779163337e+02
RINT1016 nd1016 nd1232 7.704779163337e+02
RINT1017 nd1017 nd1233 7.704779163337e+02
RINT1018 nd1018 nd1234 7.704779163337e+02
RINT1019 nd1019 nd1235 7.704779163337e+02
RINT1020 nd1020 nd1236 6.500775286230e+01
RINT1021 nd1021 nd1237 1.323956260260e+03
RINT1022 nd1022 nd1238 2.206593767100e+00
RINT1023 nd1023 nd1239 2.206593767100e+00
RINT1024 nd1024 nd1240 2.206593767100e+00
RINT1025 nd1025 nd1241 2.206593767100e+00
RINT1026 nd1026 nd1242 2.674118885599e+00
RINT1027 nd1027 nd1243 4.383196783166e+02
RINT1028 nd1028 nd1244 5.278090656434e+00
RINT1029 nd1029 nd1245 2.885955121870e+03
RINT1030 nd1030 nd1246 4.494454511947e+02
RINT1031 nd1031 nd1247 7.704779163337e+02
RINT1032 nd1032 nd1248 7.704779163337e+02
RINT1033 nd1033 nd1249 7.704779163337e+02
RINT1034 nd1034 nd1250 7.704779163337e+02
RINT1035 nd1035 nd1251 7.704779163337e+02
RINT1036 nd1036 nd1252 7.704779163337e+02
RINT1037 nd1037 nd1253 7.704779163337e+02
RINT1038 nd1038 nd1254 6.500775286230e+01
RINT1039 nd1039 nd1255 1.323956260260e+03
RINT1040 nd1040 nd1256 2.206593767100e+00
RINT1041 nd1041 nd1257 2.206593767100e+00
RINT1042 nd1042 nd1258 2.206593767100e+00
RINT1043 nd1043 nd1259 2.206593767100e+00
RINT1044 nd1044 nd1260 1.008290430727e+01
RINT1045 nd1045 nd1261 1.652707138887e+03
RINT1046 nd1046 nd1262 1.990131527082e+01
RINT1047 nd1047 nd1263 1.560014350791e+05
RINT1048 nd1048 nd1264 2.600023917985e+04
RINT1049 nd1049 nd1265 4.457183859403e+04
RINT1050 nd1050 nd1266 4.457183859403e+04
RINT1051 nd1051 nd1267 4.457183859403e+04
RINT1052 nd1052 nd1268 4.457183859403e+04
RINT1053 nd1053 nd1269 4.457183859403e+04
RINT1054 nd1054 nd1270 4.457183859403e+04
RINT1055 nd1055 nd1271 4.457183859403e+04
RINT1056 nd1056 nd1272 3.759070724798e+03
RINT1057 nd1057 nd1273 4.992045922532e+03
RINT1058 nd1058 nd1274 8.320076537553e+00
RINT1059 nd1059 nd1275 8.320076537553e+00
RINT1060 nd1060 nd1276 8.320076537553e+00
RINT1061 nd1061 nd1277 8.320076537553e+00
RINT1062 nd1062 nd1278 3.969373064306e+02
RINT1063 nd1063 nd1279 6.506271407884e+04
RINT1064 nd1064 nd1280 7.834622086342e+02
RINT1065 nd1065 nd1281 3.930473208276e+08
RINT1066 nd1066 nd1282 6.550788680460e+07
RINT1067 nd1067 nd1283 1.122992345222e+08
RINT1068 nd1068 nd1284 1.122992345222e+08
RINT1069 nd1069 nd1285 1.122992345222e+08
RINT1070 nd1070 nd1286 1.122992345222e+08
RINT1071 nd1071 nd1287 1.122992345222e+08
RINT1072 nd1072 nd1288 1.122992345222e+08
RINT1073 nd1073 nd1289 1.122992345222e+08
RINT1074 nd1074 nd1290 9.471019778978e+06
RINT1075 nd1075 nd1291 1.965236604138e+05
RINT1076 nd1076 nd1292 3.275394340230e+02
RINT1077 nd1077 nd1293 3.275394340230e+02
RINT1078 nd1078 nd1294 3.275394340230e+02
RINT1079 nd1079 nd1295 3.275394340230e+02
RINT1080 nd1080 nd1296 7.536367374812e+02
RINT1081 nd1081 nd1297 1.235299649987e+05
RINT1082 nd1082 nd1298 1.487504180860e+03
RINT1083 nd1083 nd1299 7.462510974539e+08
RINT1084 nd1084 nd1300 1.243751829090e+08
RINT1085 nd1085 nd1301 2.132145992725e+08
RINT1086 nd1086 nd1302 2.132145992725e+08
RINT1087 nd1087 nd1303 2.132145992725e+08
RINT1088 nd1088 nd1304 2.132145992725e+08
RINT1089 nd1089 nd1305 2.132145992725e+08
RINT1090 nd1090 nd1306 2.132145992725e+08
RINT1091 nd1091 nd1307 2.132145992725e+08
RINT1092 nd1092 nd1308 1.798195415552e+07
RINT1093 nd1093 nd1309 3.731255487270e+05
RINT1094 nd1094 nd1310 6.218759145449e+02
RINT1095 nd1095 nd1311 6.218759145449e+02
RINT1096 nd1096 nd1312 6.218759145449e+02
RINT1097 nd1097 nd1313 6.218759145449e+02
RINT1098 nd1098 nd1314 1.914313572015e+01
RINT1099 nd1099 nd1315 3.137786108171e+03
RINT1100 nd1100 nd1316 3.778411136600e+01
RINT1101 nd1101 nd1317 2.961802029702e+05
RINT1102 nd1102 nd1318 4.936336716170e+04
RINT1103 nd1103 nd1319 8.462291513435e+04
RINT1104 nd1104 nd1320 8.462291513435e+04
RINT1105 nd1105 nd1321 8.462291513435e+04
RINT1106 nd1106 nd1322 8.462291513435e+04
RINT1107 nd1107 nd1323 8.462291513435e+04
RINT1108 nd1108 nd1324 8.462291513435e+04
RINT1109 nd1109 nd1325 8.462291513435e+04
RINT1110 nd1110 nd1326 7.136872360728e+03
RINT1111 nd1111 nd1327 9.477766495047e+03
RINT1112 nd1112 nd1328 1.579627749174e+01
RINT1113 nd1113 nd1329 1.579627749174e+01
RINT1114 nd1114 nd1330 1.579627749174e+01
RINT1115 nd1115 nd1331 1.579627749174e+01
RINT1116 nd1116 nd1332 5.077011464038e+00
RINT1117 nd1117 nd1333 8.321821605283e+02
RINT1118 nd1118 nd1334 1.002084346932e+01
RINT1119 nd1119 nd1335 1.575530722663e+03
RINT1120 nd1120 nd1336 1.994943155433e+02
RINT1121 nd1121 nd1337 3.419902552171e+02
RINT1122 nd1122 nd1338 3.419902552171e+02
RINT1123 nd1123 nd1339 3.419902552171e+02
RINT1124 nd1124 nd1340 3.419902552171e+02
RINT1125 nd1125 nd1341 3.419902552171e+02
RINT1126 nd1126 nd1342 3.419902552171e+02
RINT1127 nd1127 nd1343 3.419902552171e+02
RINT1128 nd1128 nd1344 2.889792690348e+01
RINT1129 nd1129 nd1345 2.513628375845e+03
RINT1130 nd1130 nd1346 4.189380626409e+00
RINT1131 nd1131 nd1347 4.189380626409e+00
RINT1132 nd1132 nd1348 4.189380626409e+00
RINT1133 nd1133 nd1349 4.189380626409e+00
RINT1134 nd1134 nd1350 5.077011464038e+00
RINT1135 nd1135 nd1351 8.321821605283e+02
RINT1136 nd1136 nd1352 1.002084346932e+01
RINT1137 nd1137 nd1353 1.575530722663e+03
RINT1138 nd1138 nd1354 1.994943155433e+02
RINT1139 nd1139 nd1355 3.419902552171e+02
RINT1140 nd1140 nd1356 3.419902552171e+02
RINT1141 nd1141 nd1357 3.419902552171e+02
RINT1142 nd1142 nd1358 3.419902552171e+02
RINT1143 nd1143 nd1359 3.419902552171e+02
RINT1144 nd1144 nd1360 3.419902552171e+02
RINT1145 nd1145 nd1361 3.419902552171e+02
RINT1146 nd1146 nd1362 2.889792690348e+01
RINT1147 nd1147 nd1363 2.513628375845e+03
RINT1148 nd1148 nd1364 4.189380626409e+00
RINT1149 nd1149 nd1365 4.189380626409e+00
RINT1150 nd1150 nd1366 4.189380626409e+00
RINT1151 nd1151 nd1367 4.189380626409e+00
RINT1152 nd1152 nd1368 8.278128377641e+01
RINT1153 nd1153 nd1369 1.356883041772e+04
RINT1154 nd1154 nd1370 1.633910604278e+02
RINT1155 nd1155 nd1371 2.568921830787e+04
RINT1156 nd1156 nd1372 3.252778856960e+03
RINT1157 nd1157 nd1373 5.576192326218e+03
RINT1158 nd1158 nd1374 5.576192326218e+03
RINT1159 nd1159 nd1375 5.576192326218e+03
RINT1160 nd1160 nd1376 5.576192326218e+03
RINT1161 nd1161 nd1377 5.576192326218e+03
RINT1162 nd1162 nd1378 5.576192326218e+03
RINT1163 nd1163 nd1379 5.576192326218e+03
RINT1164 nd1164 nd1380 4.711841807905e+02
RINT1165 nd1165 nd1381 4.098501359770e+04
RINT1166 nd1166 nd1382 6.830835599617e+01
RINT1167 nd1167 nd1383 6.830835599617e+01
RINT1168 nd1168 nd1384 6.830835599617e+01
RINT1169 nd1169 nd1385 6.830835599617e+01
RINT1170 nd1170 nd1386 4.482590477444e+00
RINT1171 nd1171 nd1387 7.347495381300e+02
RINT1172 nd1172 nd1388 8.847594264800e+00
RINT1173 nd1173 nd1389 1.391066194031e+03
RINT1174 nd1174 nd1390 1.761373448716e+02
RINT1175 nd1175 nd1391 3.019497340656e+02
RINT1176 nd1176 nd1392 3.019497340656e+02
RINT1177 nd1177 nd1393 3.019497340656e+02
RINT1178 nd1178 nd1394 3.019497340656e+02
RINT1179 nd1179 nd1395 3.019497340656e+02
RINT1180 nd1180 nd1396 3.019497340656e+02
RINT1181 nd1181 nd1397 3.019497340656e+02
RINT1182 nd1182 nd1398 2.551453209687e+01
RINT1183 nd1183 nd1399 2.219330545382e+03
RINT1184 nd1184 nd1400 3.698884242304e+00
RINT1185 nd1185 nd1401 3.698884242304e+00
RINT1186 nd1186 nd1402 3.698884242304e+00
RINT1187 nd1187 nd1403 3.698884242304e+00
RINT1188 nd1188 nd1404 4.482590477444e+00
RINT1189 nd1189 nd1405 7.347495381300e+02
RINT1190 nd1190 nd1406 8.847594264800e+00
RINT1191 nd1191 nd1407 1.391066194031e+03
RINT1192 nd1192 nd1408 1.761373448716e+02
RINT1193 nd1193 nd1409 3.019497340656e+02
RINT1194 nd1194 nd1410 3.019497340656e+02
RINT1195 nd1195 nd1411 3.019497340656e+02
RINT1196 nd1196 nd1412 3.019497340656e+02
RINT1197 nd1197 nd1413 3.019497340656e+02
RINT1198 nd1198 nd1414 3.019497340656e+02
RINT1199 nd1199 nd1415 3.019497340656e+02
RINT1200 nd1200 nd1416 2.551453209687e+01
RINT1201 nd1201 nd1417 2.219330545382e+03
RINT1202 nd1202 nd1418 3.698884242304e+00
RINT1203 nd1203 nd1419 3.698884242304e+00
RINT1204 nd1204 nd1420 3.698884242304e+00
RINT1205 nd1205 nd1421 3.698884242304e+00
RINT1206 nd1206 nd1422 8.278154988486e+01
RINT1207 nd1207 nd1423 1.356887403604e+04
RINT1208 nd1208 nd1424 1.633915856642e+02
RINT1209 nd1209 nd1425 2.568930088835e+04
RINT1210 nd1210 nd1426 3.252789313333e+03
RINT1211 nd1211 nd1427 5.576210251428e+03
RINT1212 nd1212 nd1428 5.576210251428e+03
RINT1213 nd1213 nd1429 5.576210251428e+03
RINT1214 nd1214 nd1430 5.576210251428e+03
RINT1215 nd1215 nd1431 5.576210251428e+03
RINT1216 nd1216 nd1432 5.576210251428e+03
RINT1217 nd1217 nd1433 5.576210251428e+03
RINT1218 nd1218 nd1434 4.711856954577e+02
RINT1219 nd1219 nd1435 4.098514534800e+04
RINT1220 nd1220 nd1436 6.830857557999e+01
RINT1221 nd1221 nd1437 6.830857557999e+01
RINT1222 nd1222 nd1438 6.830857557999e+01
RINT1223 nd1223 nd1439 6.830857557999e+01
RINT1224 nd1224 nd1440 5.077011464038e+00
RINT1225 nd1225 nd1441 8.321821605283e+02
RINT1226 nd1226 nd1442 1.002084346932e+01
RINT1227 nd1227 nd1443 1.575530722663e+03
RINT1228 nd1228 nd1444 1.994943155433e+02
RINT1229 nd1229 nd1445 3.419902552171e+02
RINT1230 nd1230 nd1446 3.419902552171e+02
RINT1231 nd1231 nd1447 3.419902552171e+02
RINT1232 nd1232 nd1448 3.419902552171e+02
RINT1233 nd1233 nd1449 3.419902552171e+02
RINT1234 nd1234 nd1450 3.419902552171e+02
RINT1235 nd1235 nd1451 3.419902552171e+02
RINT1236 nd1236 nd1452 2.889792690348e+01
RINT1237 nd1237 nd1453 2.513628375845e+03
RINT1238 nd1238 nd1454 4.189380626409e+00
RINT1239 nd1239 nd1455 4.189380626409e+00
RINT1240 nd1240 nd1456 4.189380626409e+00
RINT1241 nd1241 nd1457 4.189380626409e+00
RINT1242 nd1242 nd1458 5.077011464038e+00
RINT1243 nd1243 nd1459 8.321821605283e+02
RINT1244 nd1244 nd1460 1.002084346932e+01
RINT1245 nd1245 nd1461 1.575530722663e+03
RINT1246 nd1246 nd1462 1.994943155433e+02
RINT1247 nd1247 nd1463 3.419902552171e+02
RINT1248 nd1248 nd1464 3.419902552171e+02
RINT1249 nd1249 nd1465 3.419902552171e+02
RINT1250 nd1250 nd1466 3.419902552171e+02
RINT1251 nd1251 nd1467 3.419902552171e+02
RINT1252 nd1252 nd1468 3.419902552171e+02
RINT1253 nd1253 nd1469 3.419902552171e+02
RINT1254 nd1254 nd1470 2.889792690348e+01
RINT1255 nd1255 nd1471 2.513628375845e+03
RINT1256 nd1256 nd1472 4.189380626409e+00
RINT1257 nd1257 nd1473 4.189380626409e+00
RINT1258 nd1258 nd1474 4.189380626409e+00
RINT1259 nd1259 nd1475 4.189380626409e+00
RINT1260 nd1260 nd1476 1.914313572015e+01
RINT1261 nd1261 nd1477 3.137786108171e+03
RINT1262 nd1262 nd1478 3.778411136600e+01
RINT1263 nd1263 nd1479 2.961802029702e+05
RINT1264 nd1264 nd1480 4.936336716170e+04
RINT1265 nd1265 nd1481 8.462291513435e+04
RINT1266 nd1266 nd1482 8.462291513435e+04
RINT1267 nd1267 nd1483 8.462291513435e+04
RINT1268 nd1268 nd1484 8.462291513435e+04
RINT1269 nd1269 nd1485 8.462291513435e+04
RINT1270 nd1270 nd1486 8.462291513435e+04
RINT1271 nd1271 nd1487 8.462291513435e+04
RINT1272 nd1272 nd1488 7.136872360728e+03
RINT1273 nd1273 nd1489 9.477766495047e+03
RINT1274 nd1274 nd1490 1.579627749174e+01
RINT1275 nd1275 nd1491 1.579627749174e+01
RINT1276 nd1276 nd1492 1.579627749174e+01
RINT1277 nd1277 nd1493 1.579627749174e+01
RINT1278 nd1278 nd1494 7.536146826178e+02
RINT1279 nd1279 nd1495 1.235263499460e+05
RINT1280 nd1280 nd1496 1.487460649673e+03
RINT1281 nd1281 nd1497 7.462292587281e+08
RINT1282 nd1282 nd1498 1.243715431214e+08
RINT1283 nd1283 nd1499 2.132083596366e+08
RINT1284 nd1284 nd1500 2.132083596366e+08
RINT1285 nd1285 nd1501 2.132083596366e+08
RINT1286 nd1286 nd1502 2.132083596366e+08
RINT1287 nd1287 nd1503 2.132083596366e+08
RINT1288 nd1288 nd1504 2.132083596366e+08
RINT1289 nd1289 nd1505 2.132083596366e+08
RINT1290 nd1290 nd1506 1.798142792116e+07
RINT1291 nd1291 nd1507 3.731146293641e+05
RINT1292 nd1292 nd1508 6.218577156068e+02
RINT1293 nd1293 nd1509 6.218577156068e+02
RINT1294 nd1294 nd1510 6.218577156068e+02
RINT1295 nd1295 nd1511 6.218577156068e+02
RINT1296 nd1296 nd1512 7.536367374812e+02
RINT1297 nd1297 nd1513 1.235299649987e+05
RINT1298 nd1298 nd1514 1.487504180860e+03
RINT1299 nd1299 nd1515 7.462510974539e+08
RINT1300 nd1300 nd1516 1.243751829090e+08
RINT1301 nd1301 nd1517 2.132145992725e+08
RINT1302 nd1302 nd1518 2.132145992725e+08
RINT1303 nd1303 nd1519 2.132145992725e+08
RINT1304 nd1304 nd1520 2.132145992725e+08
RINT1305 nd1305 nd1521 2.132145992725e+08
RINT1306 nd1306 nd1522 2.132145992725e+08
RINT1307 nd1307 nd1523 2.132145992725e+08
RINT1308 nd1308 nd1524 1.798195415552e+07
RINT1309 nd1309 nd1525 3.731255487270e+05
RINT1310 nd1310 nd1526 6.218759145449e+02
RINT1311 nd1311 nd1527 6.218759145449e+02
RINT1312 nd1312 nd1528 6.218759145449e+02
RINT1313 nd1313 nd1529 6.218759145449e+02
RINT1314 nd1314 nd1530 1.914313572015e+01
RINT1315 nd1315 nd1531 3.137786108171e+03
RINT1316 nd1316 nd1532 3.778411136600e+01
RINT1317 nd1317 nd1533 2.961802029702e+05
RINT1318 nd1318 nd1534 4.936336716170e+04
RINT1319 nd1319 nd1535 8.462291513435e+04
RINT1320 nd1320 nd1536 8.462291513435e+04
RINT1321 nd1321 nd1537 8.462291513435e+04
RINT1322 nd1322 nd1538 8.462291513435e+04
RINT1323 nd1323 nd1539 8.462291513435e+04
RINT1324 nd1324 nd1540 8.462291513435e+04
RINT1325 nd1325 nd1541 8.462291513435e+04
RINT1326 nd1326 nd1542 7.136872360728e+03
RINT1327 nd1327 nd1543 9.477766495047e+03
RINT1328 nd1328 nd1544 1.579627749174e+01
RINT1329 nd1329 nd1545 1.579627749174e+01
RINT1330 nd1330 nd1546 1.579627749174e+01
RINT1331 nd1331 nd1547 1.579627749174e+01
RINT1332 nd1332 nd1548 5.077011464038e+00
RINT1333 nd1333 nd1549 8.321821605283e+02
RINT1334 nd1334 nd1550 1.002084346932e+01
RINT1335 nd1335 nd1551 1.575530722663e+03
RINT1336 nd1336 nd1552 1.994943155433e+02
RINT1337 nd1337 nd1553 3.419902552171e+02
RINT1338 nd1338 nd1554 3.419902552171e+02
RINT1339 nd1339 nd1555 3.419902552171e+02
RINT1340 nd1340 nd1556 3.419902552171e+02
RINT1341 nd1341 nd1557 3.419902552171e+02
RINT1342 nd1342 nd1558 3.419902552171e+02
RINT1343 nd1343 nd1559 3.419902552171e+02
RINT1344 nd1344 nd1560 2.889792690348e+01
RINT1345 nd1345 nd1561 2.513628375845e+03
RINT1346 nd1346 nd1562 4.189380626409e+00
RINT1347 nd1347 nd1563 4.189380626409e+00
RINT1348 nd1348 nd1564 4.189380626409e+00
RINT1349 nd1349 nd1565 4.189380626409e+00
RINT1350 nd1350 nd1566 5.077011464038e+00
RINT1351 nd1351 nd1567 8.321821605283e+02
RINT1352 nd1352 nd1568 1.002084346932e+01
RINT1353 nd1353 nd1569 1.575530722663e+03
RINT1354 nd1354 nd1570 1.994943155433e+02
RINT1355 nd1355 nd1571 3.419902552171e+02
RINT1356 nd1356 nd1572 3.419902552171e+02
RINT1357 nd1357 nd1573 3.419902552171e+02
RINT1358 nd1358 nd1574 3.419902552171e+02
RINT1359 nd1359 nd1575 3.419902552171e+02
RINT1360 nd1360 nd1576 3.419902552171e+02
RINT1361 nd1361 nd1577 3.419902552171e+02
RINT1362 nd1362 nd1578 2.889792690348e+01
RINT1363 nd1363 nd1579 2.513628375845e+03
RINT1364 nd1364 nd1580 4.189380626409e+00
RINT1365 nd1365 nd1581 4.189380626409e+00
RINT1366 nd1366 nd1582 4.189380626409e+00
RINT1367 nd1367 nd1583 4.189380626409e+00
RINT1368 nd1368 nd1584 8.278128377641e+01
RINT1369 nd1369 nd1585 1.356883041772e+04
RINT1370 nd1370 nd1586 1.633910604278e+02
RINT1371 nd1371 nd1587 2.568921830787e+04
RINT1372 nd1372 nd1588 3.252778856960e+03
RINT1373 nd1373 nd1589 5.576192326218e+03
RINT1374 nd1374 nd1590 5.576192326218e+03
RINT1375 nd1375 nd1591 5.576192326218e+03
RINT1376 nd1376 nd1592 5.576192326218e+03
RINT1377 nd1377 nd1593 5.576192326218e+03
RINT1378 nd1378 nd1594 5.576192326218e+03
RINT1379 nd1379 nd1595 5.576192326218e+03
RINT1380 nd1380 nd1596 4.711841807905e+02
RINT1381 nd1381 nd1597 4.098501359770e+04
RINT1382 nd1382 nd1598 6.830835599617e+01
RINT1383 nd1383 nd1599 6.830835599617e+01
RINT1384 nd1384 nd1600 6.830835599617e+01
RINT1385 nd1385 nd1601 6.830835599617e+01
RINT1386 nd1386 nd1602 4.482590477444e+00
RINT1387 nd1387 nd1603 7.347495381300e+02
RINT1388 nd1388 nd1604 8.847594264800e+00
RINT1389 nd1389 nd1605 1.391066194031e+03
RINT1390 nd1390 nd1606 1.761373448716e+02
RINT1391 nd1391 nd1607 3.019497340656e+02
RINT1392 nd1392 nd1608 3.019497340656e+02
RINT1393 nd1393 nd1609 3.019497340656e+02
RINT1394 nd1394 nd1610 3.019497340656e+02
RINT1395 nd1395 nd1611 3.019497340656e+02
RINT1396 nd1396 nd1612 3.019497340656e+02
RINT1397 nd1397 nd1613 3.019497340656e+02
RINT1398 nd1398 nd1614 2.551453209687e+01
RINT1399 nd1399 nd1615 2.219330545382e+03
RINT1400 nd1400 nd1616 3.698884242304e+00
RINT1401 nd1401 nd1617 3.698884242304e+00
RINT1402 nd1402 nd1618 3.698884242304e+00
RINT1403 nd1403 nd1619 3.698884242304e+00
RINT1404 nd1404 nd1620 4.482590477444e+00
RINT1405 nd1405 nd1621 7.347495381300e+02
RINT1406 nd1406 nd1622 8.847594264800e+00
RINT1407 nd1407 nd1623 1.391066194031e+03
RINT1408 nd1408 nd1624 1.761373448716e+02
RINT1409 nd1409 nd1625 3.019497340656e+02
RINT1410 nd1410 nd1626 3.019497340656e+02
RINT1411 nd1411 nd1627 3.019497340656e+02
RINT1412 nd1412 nd1628 3.019497340656e+02
RINT1413 nd1413 nd1629 3.019497340656e+02
RINT1414 nd1414 nd1630 3.019497340656e+02
RINT1415 nd1415 nd1631 3.019497340656e+02
RINT1416 nd1416 nd1632 2.551453209687e+01
RINT1417 nd1417 nd1633 2.219330545382e+03
RINT1418 nd1418 nd1634 3.698884242304e+00
RINT1419 nd1419 nd1635 3.698884242304e+00
RINT1420 nd1420 nd1636 3.698884242304e+00
RINT1421 nd1421 nd1637 3.698884242304e+00
RINT1422 nd1422 nd1638 8.278154988486e+01
RINT1423 nd1423 nd1639 1.356887403604e+04
RINT1424 nd1424 nd1640 1.633915856642e+02
RINT1425 nd1425 nd1641 2.568930088835e+04
RINT1426 nd1426 nd1642 3.252789313333e+03
RINT1427 nd1427 nd1643 5.576210251428e+03
RINT1428 nd1428 nd1644 5.576210251428e+03
RINT1429 nd1429 nd1645 5.576210251428e+03
RINT1430 nd1430 nd1646 5.576210251428e+03
RINT1431 nd1431 nd1647 5.576210251428e+03
RINT1432 nd1432 nd1648 5.576210251428e+03
RINT1433 nd1433 nd1649 5.576210251428e+03
RINT1434 nd1434 nd1650 4.711856954577e+02
RINT1435 nd1435 nd1651 4.098514534800e+04
RINT1436 nd1436 nd1652 6.830857557999e+01
RINT1437 nd1437 nd1653 6.830857557999e+01
RINT1438 nd1438 nd1654 6.830857557999e+01
RINT1439 nd1439 nd1655 6.830857557999e+01
RINT1440 nd1440 nd1656 5.077011464038e+00
RINT1441 nd1441 nd1657 8.321821605283e+02
RINT1442 nd1442 nd1658 1.002084346932e+01
RINT1443 nd1443 nd1659 1.575530722663e+03
RINT1444 nd1444 nd1660 1.994943155433e+02
RINT1445 nd1445 nd1661 3.419902552171e+02
RINT1446 nd1446 nd1662 3.419902552171e+02
RINT1447 nd1447 nd1663 3.419902552171e+02
RINT1448 nd1448 nd1664 3.419902552171e+02
RINT1449 nd1449 nd1665 3.419902552171e+02
RINT1450 nd1450 nd1666 3.419902552171e+02
RINT1451 nd1451 nd1667 3.419902552171e+02
RINT1452 nd1452 nd1668 2.889792690348e+01
RINT1453 nd1453 nd1669 2.513628375845e+03
RINT1454 nd1454 nd1670 4.189380626409e+00
RINT1455 nd1455 nd1671 4.189380626409e+00
RINT1456 nd1456 nd1672 4.189380626409e+00
RINT1457 nd1457 nd1673 4.189380626409e+00
RINT1458 nd1458 nd1674 5.077011464038e+00
RINT1459 nd1459 nd1675 8.321821605283e+02
RINT1460 nd1460 nd1676 1.002084346932e+01
RINT1461 nd1461 nd1677 1.575530722663e+03
RINT1462 nd1462 nd1678 1.994943155433e+02
RINT1463 nd1463 nd1679 3.419902552171e+02
RINT1464 nd1464 nd1680 3.419902552171e+02
RINT1465 nd1465 nd1681 3.419902552171e+02
RINT1466 nd1466 nd1682 3.419902552171e+02
RINT1467 nd1467 nd1683 3.419902552171e+02
RINT1468 nd1468 nd1684 3.419902552171e+02
RINT1469 nd1469 nd1685 3.419902552171e+02
RINT1470 nd1470 nd1686 2.889792690348e+01
RINT1471 nd1471 nd1687 2.513628375845e+03
RINT1472 nd1472 nd1688 4.189380626409e+00
RINT1473 nd1473 nd1689 4.189380626409e+00
RINT1474 nd1474 nd1690 4.189380626409e+00
RINT1475 nd1475 nd1691 4.189380626409e+00
RINT1476 nd1476 nd1692 1.914313572015e+01
RINT1477 nd1477 nd1693 3.137786108171e+03
RINT1478 nd1478 nd1694 3.778411136600e+01
RINT1479 nd1479 nd1695 2.961802029702e+05
RINT1480 nd1480 nd1696 4.936336716170e+04
RINT1481 nd1481 nd1697 8.462291513435e+04
RINT1482 nd1482 nd1698 8.462291513435e+04
RINT1483 nd1483 nd1699 8.462291513435e+04
RINT1484 nd1484 nd1700 8.462291513435e+04
RINT1485 nd1485 nd1701 8.462291513435e+04
RINT1486 nd1486 nd1702 8.462291513435e+04
RINT1487 nd1487 nd1703 8.462291513435e+04
RINT1488 nd1488 nd1704 7.136872360728e+03
RINT1489 nd1489 nd1705 9.477766495047e+03
RINT1490 nd1490 nd1706 1.579627749174e+01
RINT1491 nd1491 nd1707 1.579627749174e+01
RINT1492 nd1492 nd1708 1.579627749174e+01
RINT1493 nd1493 nd1709 1.579627749174e+01
RINT1494 nd1494 nd1710 7.536146826178e+02
RINT1495 nd1495 nd1711 1.235263499460e+05
RINT1496 nd1496 nd1712 1.487460649673e+03
RINT1497 nd1497 nd1713 7.462292587281e+08
RINT1498 nd1498 nd1714 1.243715431214e+08
RINT1499 nd1499 nd1715 2.132083596366e+08
RINT1500 nd1500 nd1716 2.132083596366e+08
RINT1501 nd1501 nd1717 2.132083596366e+08
RINT1502 nd1502 nd1718 2.132083596366e+08
RINT1503 nd1503 nd1719 2.132083596366e+08
RINT1504 nd1504 nd1720 2.132083596366e+08
RINT1505 nd1505 nd1721 2.132083596366e+08
RINT1506 nd1506 nd1722 1.798142792116e+07
RINT1507 nd1507 nd1723 3.731146293641e+05
RINT1508 nd1508 nd1724 6.218577156068e+02
RINT1509 nd1509 nd1725 6.218577156068e+02
RINT1510 nd1510 nd1726 6.218577156068e+02
RINT1511 nd1511 nd1727 6.218577156068e+02
RINT1512 nd1512 nd1728 7.536367374812e+02
RINT1513 nd1513 nd1729 1.235299649987e+05
RINT1514 nd1514 nd1730 1.487504180860e+03
RINT1515 nd1515 nd1731 7.462510974539e+08
RINT1516 nd1516 nd1732 1.243751829090e+08
RINT1517 nd1517 nd1733 2.132145992725e+08
RINT1518 nd1518 nd1734 2.132145992725e+08
RINT1519 nd1519 nd1735 2.132145992725e+08
RINT1520 nd1520 nd1736 2.132145992725e+08
RINT1521 nd1521 nd1737 2.132145992725e+08
RINT1522 nd1522 nd1738 2.132145992725e+08
RINT1523 nd1523 nd1739 2.132145992725e+08
RINT1524 nd1524 nd1740 1.798195415552e+07
RINT1525 nd1525 nd1741 3.731255487270e+05
RINT1526 nd1526 nd1742 6.218759145449e+02
RINT1527 nd1527 nd1743 6.218759145449e+02
RINT1528 nd1528 nd1744 6.218759145449e+02
RINT1529 nd1529 nd1745 6.218759145449e+02
RINT1530 nd1530 nd1746 1.914313572015e+01
RINT1531 nd1531 nd1747 3.137786108171e+03
RINT1532 nd1532 nd1748 3.778411136600e+01
RINT1533 nd1533 nd1749 2.961802029702e+05
RINT1534 nd1534 nd1750 4.936336716170e+04
RINT1535 nd1535 nd1751 8.462291513435e+04
RINT1536 nd1536 nd1752 8.462291513435e+04
RINT1537 nd1537 nd1753 8.462291513435e+04
RINT1538 nd1538 nd1754 8.462291513435e+04
RINT1539 nd1539 nd1755 8.462291513435e+04
RINT1540 nd1540 nd1756 8.462291513435e+04
RINT1541 nd1541 nd1757 8.462291513435e+04
RINT1542 nd1542 nd1758 7.136872360728e+03
RINT1543 nd1543 nd1759 9.477766495047e+03
RINT1544 nd1544 nd1760 1.579627749174e+01
RINT1545 nd1545 nd1761 1.579627749174e+01
RINT1546 nd1546 nd1762 1.579627749174e+01
RINT1547 nd1547 nd1763 1.579627749174e+01
RINT1548 nd1548 nd1764 5.077011464038e+00
RINT1549 nd1549 nd1765 8.321821605283e+02
RINT1550 nd1550 nd1766 1.002084346932e+01
RINT1551 nd1551 nd1767 1.575530722663e+03
RINT1552 nd1552 nd1768 1.994943155433e+02
RINT1553 nd1553 nd1769 3.419902552171e+02
RINT1554 nd1554 nd1770 3.419902552171e+02
RINT1555 nd1555 nd1771 3.419902552171e+02
RINT1556 nd1556 nd1772 3.419902552171e+02
RINT1557 nd1557 nd1773 3.419902552171e+02
RINT1558 nd1558 nd1774 3.419902552171e+02
RINT1559 nd1559 nd1775 3.419902552171e+02
RINT1560 nd1560 nd1776 2.889792690348e+01
RINT1561 nd1561 nd1777 2.513628375845e+03
RINT1562 nd1562 nd1778 4.189380626409e+00
RINT1563 nd1563 nd1779 4.189380626409e+00
RINT1564 nd1564 nd1780 4.189380626409e+00
RINT1565 nd1565 nd1781 4.189380626409e+00
RINT1566 nd1566 nd1782 5.077011464038e+00
RINT1567 nd1567 nd1783 8.321821605283e+02
RINT1568 nd1568 nd1784 1.002084346932e+01
RINT1569 nd1569 nd1785 1.575530722663e+03
RINT1570 nd1570 nd1786 1.994943155433e+02
RINT1571 nd1571 nd1787 3.419902552171e+02
RINT1572 nd1572 nd1788 3.419902552171e+02
RINT1573 nd1573 nd1789 3.419902552171e+02
RINT1574 nd1574 nd1790 3.419902552171e+02
RINT1575 nd1575 nd1791 3.419902552171e+02
RINT1576 nd1576 nd1792 3.419902552171e+02
RINT1577 nd1577 nd1793 3.419902552171e+02
RINT1578 nd1578 nd1794 2.889792690348e+01
RINT1579 nd1579 nd1795 2.513628375845e+03
RINT1580 nd1580 nd1796 4.189380626409e+00
RINT1581 nd1581 nd1797 4.189380626409e+00
RINT1582 nd1582 nd1798 4.189380626409e+00
RINT1583 nd1583 nd1799 4.189380626409e+00
RINT1584 nd1584 nd1800 8.278128377641e+01
RINT1585 nd1585 nd1801 1.356883041772e+04
RINT1586 nd1586 nd1802 1.633910604278e+02
RINT1587 nd1587 nd1803 2.568921830787e+04
RINT1588 nd1588 nd1804 3.252778856960e+03
RINT1589 nd1589 nd1805 5.576192326218e+03
RINT1590 nd1590 nd1806 5.576192326218e+03
RINT1591 nd1591 nd1807 5.576192326218e+03
RINT1592 nd1592 nd1808 5.576192326218e+03
RINT1593 nd1593 nd1809 5.576192326218e+03
RINT1594 nd1594 nd1810 5.576192326218e+03
RINT1595 nd1595 nd1811 5.576192326218e+03
RINT1596 nd1596 nd1812 4.711841807905e+02
RINT1597 nd1597 nd1813 4.098501359770e+04
RINT1598 nd1598 nd1814 6.830835599617e+01
RINT1599 nd1599 nd1815 6.830835599617e+01
RINT1600 nd1600 nd1816 6.830835599617e+01
RINT1601 nd1601 nd1817 6.830835599617e+01
RINT1602 nd1602 nd1818 4.482590477444e+00
RINT1603 nd1603 nd1819 7.347495381300e+02
RINT1604 nd1604 nd1820 8.847594264800e+00
RINT1605 nd1605 nd1821 1.391066194031e+03
RINT1606 nd1606 nd1822 1.761373448716e+02
RINT1607 nd1607 nd1823 3.019497340656e+02
RINT1608 nd1608 nd1824 3.019497340656e+02
RINT1609 nd1609 nd1825 3.019497340656e+02
RINT1610 nd1610 nd1826 3.019497340656e+02
RINT1611 nd1611 nd1827 3.019497340656e+02
RINT1612 nd1612 nd1828 3.019497340656e+02
RINT1613 nd1613 nd1829 3.019497340656e+02
RINT1614 nd1614 nd1830 2.551453209687e+01
RINT1615 nd1615 nd1831 2.219330545382e+03
RINT1616 nd1616 nd1832 3.698884242304e+00
RINT1617 nd1617 nd1833 3.698884242304e+00
RINT1618 nd1618 nd1834 3.698884242304e+00
RINT1619 nd1619 nd1835 3.698884242304e+00
RINT1620 nd1620 nd1836 4.482590477444e+00
RINT1621 nd1621 nd1837 7.347495381300e+02
RINT1622 nd1622 nd1838 8.847594264800e+00
RINT1623 nd1623 nd1839 1.391066194031e+03
RINT1624 nd1624 nd1840 1.761373448716e+02
RINT1625 nd1625 nd1841 3.019497340656e+02
RINT1626 nd1626 nd1842 3.019497340656e+02
RINT1627 nd1627 nd1843 3.019497340656e+02
RINT1628 nd1628 nd1844 3.019497340656e+02
RINT1629 nd1629 nd1845 3.019497340656e+02
RINT1630 nd1630 nd1846 3.019497340656e+02
RINT1631 nd1631 nd1847 3.019497340656e+02
RINT1632 nd1632 nd1848 2.551453209687e+01
RINT1633 nd1633 nd1849 2.219330545382e+03
RINT1634 nd1634 nd1850 3.698884242304e+00
RINT1635 nd1635 nd1851 3.698884242304e+00
RINT1636 nd1636 nd1852 3.698884242304e+00
RINT1637 nd1637 nd1853 3.698884242304e+00
RINT1638 nd1638 nd1854 8.278154988486e+01
RINT1639 nd1639 nd1855 1.356887403604e+04
RINT1640 nd1640 nd1856 1.633915856642e+02
RINT1641 nd1641 nd1857 2.568930088835e+04
RINT1642 nd1642 nd1858 3.252789313333e+03
RINT1643 nd1643 nd1859 5.576210251428e+03
RINT1644 nd1644 nd1860 5.576210251428e+03
RINT1645 nd1645 nd1861 5.576210251428e+03
RINT1646 nd1646 nd1862 5.576210251428e+03
RINT1647 nd1647 nd1863 5.576210251428e+03
RINT1648 nd1648 nd1864 5.576210251428e+03
RINT1649 nd1649 nd1865 5.576210251428e+03
RINT1650 nd1650 nd1866 4.711856954577e+02
RINT1651 nd1651 nd1867 4.098514534800e+04
RINT1652 nd1652 nd1868 6.830857557999e+01
RINT1653 nd1653 nd1869 6.830857557999e+01
RINT1654 nd1654 nd1870 6.830857557999e+01
RINT1655 nd1655 nd1871 6.830857557999e+01
RINT1656 nd1656 nd1872 5.077011464038e+00
RINT1657 nd1657 nd1873 8.321821605283e+02
RINT1658 nd1658 nd1874 1.002084346932e+01
RINT1659 nd1659 nd1875 1.575530722663e+03
RINT1660 nd1660 nd1876 1.994943155433e+02
RINT1661 nd1661 nd1877 3.419902552171e+02
RINT1662 nd1662 nd1878 3.419902552171e+02
RINT1663 nd1663 nd1879 3.419902552171e+02
RINT1664 nd1664 nd1880 3.419902552171e+02
RINT1665 nd1665 nd1881 3.419902552171e+02
RINT1666 nd1666 nd1882 3.419902552171e+02
RINT1667 nd1667 nd1883 3.419902552171e+02
RINT1668 nd1668 nd1884 2.889792690348e+01
RINT1669 nd1669 nd1885 2.513628375845e+03
RINT1670 nd1670 nd1886 4.189380626409e+00
RINT1671 nd1671 nd1887 4.189380626409e+00
RINT1672 nd1672 nd1888 4.189380626409e+00
RINT1673 nd1673 nd1889 4.189380626409e+00
RINT1674 nd1674 nd1890 5.077011464038e+00
RINT1675 nd1675 nd1891 8.321821605283e+02
RINT1676 nd1676 nd1892 1.002084346932e+01
RINT1677 nd1677 nd1893 1.575530722663e+03
RINT1678 nd1678 nd1894 1.994943155433e+02
RINT1679 nd1679 nd1895 3.419902552171e+02
RINT1680 nd1680 nd1896 3.419902552171e+02
RINT1681 nd1681 nd1897 3.419902552171e+02
RINT1682 nd1682 nd1898 3.419902552171e+02
RINT1683 nd1683 nd1899 3.419902552171e+02
RINT1684 nd1684 nd1900 3.419902552171e+02
RINT1685 nd1685 nd1901 3.419902552171e+02
RINT1686 nd1686 nd1902 2.889792690348e+01
RINT1687 nd1687 nd1903 2.513628375845e+03
RINT1688 nd1688 nd1904 4.189380626409e+00
RINT1689 nd1689 nd1905 4.189380626409e+00
RINT1690 nd1690 nd1906 4.189380626409e+00
RINT1691 nd1691 nd1907 4.189380626409e+00
RINT1692 nd1692 nd1908 1.914313572015e+01
RINT1693 nd1693 nd1909 3.137786108171e+03
RINT1694 nd1694 nd1910 3.778411136600e+01
RINT1695 nd1695 nd1911 2.961802029702e+05
RINT1696 nd1696 nd1912 4.936336716170e+04
RINT1697 nd1697 nd1913 8.462291513435e+04
RINT1698 nd1698 nd1914 8.462291513435e+04
RINT1699 nd1699 nd1915 8.462291513435e+04
RINT1700 nd1700 nd1916 8.462291513435e+04
RINT1701 nd1701 nd1917 8.462291513435e+04
RINT1702 nd1702 nd1918 8.462291513435e+04
RINT1703 nd1703 nd1919 8.462291513435e+04
RINT1704 nd1704 nd1920 7.136872360728e+03
RINT1705 nd1705 nd1921 9.477766495047e+03
RINT1706 nd1706 nd1922 1.579627749174e+01
RINT1707 nd1707 nd1923 1.579627749174e+01
RINT1708 nd1708 nd1924 1.579627749174e+01
RINT1709 nd1709 nd1925 1.579627749174e+01
RINT1710 nd1710 nd1926 7.536146826178e+02
RINT1711 nd1711 nd1927 1.235263499460e+05
RINT1712 nd1712 nd1928 1.487460649673e+03
RINT1713 nd1713 nd1929 7.462292587281e+08
RINT1714 nd1714 nd1930 1.243715431214e+08
RINT1715 nd1715 nd1931 2.132083596366e+08
RINT1716 nd1716 nd1932 2.132083596366e+08
RINT1717 nd1717 nd1933 2.132083596366e+08
RINT1718 nd1718 nd1934 2.132083596366e+08
RINT1719 nd1719 nd1935 2.132083596366e+08
RINT1720 nd1720 nd1936 2.132083596366e+08
RINT1721 nd1721 nd1937 2.132083596366e+08
RINT1722 nd1722 nd1938 1.798142792116e+07
RINT1723 nd1723 nd1939 3.731146293641e+05
RINT1724 nd1724 nd1940 6.218577156068e+02
RINT1725 nd1725 nd1941 6.218577156068e+02
RINT1726 nd1726 nd1942 6.218577156068e+02
RINT1727 nd1727 nd1943 6.218577156068e+02
RINT1728 nd1728 nd1944 3.969489229746e+02
RINT1729 nd1729 nd1945 6.506461816764e+04
RINT1730 nd1730 nd1946 7.834851369985e+02
RINT1731 nd1731 nd1947 3.930588235294e+08
RINT1732 nd1732 nd1948 6.550980392157e+07
RINT1733 nd1733 nd1949 1.123025210084e+08
RINT1734 nd1734 nd1950 1.123025210084e+08
RINT1735 nd1735 nd1951 1.123025210084e+08
RINT1736 nd1736 nd1952 1.123025210084e+08
RINT1737 nd1737 nd1953 1.123025210084e+08
RINT1738 nd1738 nd1954 1.123025210084e+08
RINT1739 nd1739 nd1955 1.123025210084e+08
RINT1740 nd1740 nd1956 9.471296952516e+06
RINT1741 nd1741 nd1957 1.965294117647e+05
RINT1742 nd1742 nd1958 3.275490196078e+02
RINT1743 nd1743 nd1959 3.275490196078e+02
RINT1744 nd1744 nd1960 3.275490196078e+02
RINT1745 nd1745 nd1961 3.275490196078e+02
RINT1746 nd1746 nd1962 1.008290430727e+01
RINT1747 nd1747 nd1963 1.652707138887e+03
RINT1748 nd1748 nd1964 1.990131527082e+01
RINT1749 nd1749 nd1965 1.560014350791e+05
RINT1750 nd1750 nd1966 2.600023917985e+04
RINT1751 nd1751 nd1967 4.457183859403e+04
RINT1752 nd1752 nd1968 4.457183859403e+04
RINT1753 nd1753 nd1969 4.457183859403e+04
RINT1754 nd1754 nd1970 4.457183859403e+04
RINT1755 nd1755 nd1971 4.457183859403e+04
RINT1756 nd1756 nd1972 4.457183859403e+04
RINT1757 nd1757 nd1973 4.457183859403e+04
RINT1758 nd1758 nd1974 3.759070724798e+03
RINT1759 nd1759 nd1975 4.992045922532e+03
RINT1760 nd1760 nd1976 8.320076537553e+00
RINT1761 nd1761 nd1977 8.320076537553e+00
RINT1762 nd1762 nd1978 8.320076537553e+00
RINT1763 nd1763 nd1979 8.320076537553e+00
RINT1764 nd1764 nd1980 2.674118885599e+00
RINT1765 nd1765 nd1981 4.383196783166e+02
RINT1766 nd1766 nd1982 5.278090656434e+00
RINT1767 nd1767 nd1983 2.885955121870e+03
RINT1768 nd1768 nd1984 4.494454511947e+02
RINT1769 nd1769 nd1985 7.704779163337e+02
RINT1770 nd1770 nd1986 7.704779163337e+02
RINT1771 nd1771 nd1987 7.704779163337e+02
RINT1772 nd1772 nd1988 7.704779163337e+02
RINT1773 nd1773 nd1989 7.704779163337e+02
RINT1774 nd1774 nd1990 7.704779163337e+02
RINT1775 nd1775 nd1991 7.704779163337e+02
RINT1776 nd1776 nd1992 6.500775286230e+01
RINT1777 nd1777 nd1993 1.323956260260e+03
RINT1778 nd1778 nd1994 2.206593767100e+00
RINT1779 nd1779 nd1995 2.206593767100e+00
RINT1780 nd1780 nd1996 2.206593767100e+00
RINT1781 nd1781 nd1997 2.206593767100e+00
RINT1782 nd1782 nd1998 2.674118885599e+00
RINT1783 nd1783 nd1999 4.383196783166e+02
RINT1784 nd1784 nd2000 5.278090656434e+00
RINT1785 nd1785 nd2001 2.885955121870e+03
RINT1786 nd1786 nd2002 4.494454511947e+02
RINT1787 nd1787 nd2003 7.704779163337e+02
RINT1788 nd1788 nd2004 7.704779163337e+02
RINT1789 nd1789 nd2005 7.704779163337e+02
RINT1790 nd1790 nd2006 7.704779163337e+02
RINT1791 nd1791 nd2007 7.704779163337e+02
RINT1792 nd1792 nd2008 7.704779163337e+02
RINT1793 nd1793 nd2009 7.704779163337e+02
RINT1794 nd1794 nd2010 6.500775286230e+01
RINT1795 nd1795 nd2011 1.323956260260e+03
RINT1796 nd1796 nd2012 2.206593767100e+00
RINT1797 nd1797 nd2013 2.206593767100e+00
RINT1798 nd1798 nd2014 2.206593767100e+00
RINT1799 nd1799 nd2015 2.206593767100e+00
RINT1800 nd1800 nd2016 4.360183070072e+01
RINT1801 nd1801 nd2017 7.146855178982e+03
RINT1802 nd1802 nd2018 8.605990424145e+01
RINT1803 nd1803 nd2019 4.705584606253e+04
RINT1804 nd1804 nd2020 7.328262246580e+03
RINT1805 nd1805 nd2021 1.256273527985e+04
RINT1806 nd1806 nd2022 1.256273527985e+04
RINT1807 nd1807 nd2023 1.256273527985e+04
RINT1808 nd1808 nd2024 1.256273527985e+04
RINT1809 nd1809 nd2025 1.256273527985e+04
RINT1810 nd1810 nd2026 1.256273527985e+04
RINT1811 nd1811 nd2027 1.256273527985e+04
RINT1812 nd1812 nd2028 1.059959244819e+03
RINT1813 nd1813 nd2029 2.158726637993e+04
RINT1814 nd1814 nd2030 3.597877729988e+01
RINT1815 nd1815 nd2031 3.597877729988e+01
RINT1816 nd1816 nd2032 3.597877729988e+01
RINT1817 nd1817 nd2033 3.597877729988e+01
RINT1818 nd1818 nd2034 2.361030684497e+00
RINT1819 nd1819 nd2035 3.870008232236e+02
RINT1820 nd1820 nd2036 4.660127140386e+00
RINT1821 nd1821 nd2037 2.548064947116e+03
RINT1822 nd1822 nd2038 3.968239807860e+02
RINT1823 nd1823 nd2039 6.802696813474e+02
RINT1824 nd1824 nd2040 6.802696813474e+02
RINT1825 nd1825 nd2041 6.802696813474e+02
RINT1826 nd1826 nd2042 6.802696813474e+02
RINT1827 nd1827 nd2043 6.802696813474e+02
RINT1828 nd1828 nd2044 6.802696813474e+02
RINT1829 nd1829 nd2045 6.802696813474e+02
RINT1830 nd1830 nd2046 5.739658773762e+01
RINT1831 nd1831 nd2047 1.168946291894e+03
RINT1832 nd1832 nd2048 1.948243819824e+00
RINT1833 nd1833 nd2049 1.948243819824e+00
RINT1834 nd1834 nd2050 1.948243819824e+00
RINT1835 nd1835 nd2051 1.948243819824e+00
RINT1836 nd1836 nd2052 2.361030684497e+00
RINT1837 nd1837 nd2053 3.870008232236e+02
RINT1838 nd1838 nd2054 4.660127140386e+00
RINT1839 nd1839 nd2055 2.548064947116e+03
RINT1840 nd1840 nd2056 3.968239807860e+02
RINT1841 nd1841 nd2057 6.802696813474e+02
RINT1842 nd1842 nd2058 6.802696813474e+02
RINT1843 nd1843 nd2059 6.802696813474e+02
RINT1844 nd1844 nd2060 6.802696813474e+02
RINT1845 nd1845 nd2061 6.802696813474e+02
RINT1846 nd1846 nd2062 6.802696813474e+02
RINT1847 nd1847 nd2063 6.802696813474e+02
RINT1848 nd1848 nd2064 5.739658773762e+01
RINT1849 nd1849 nd2065 1.168946291894e+03
RINT1850 nd1850 nd2066 1.948243819824e+00
RINT1851 nd1851 nd2067 1.948243819824e+00
RINT1852 nd1852 nd2068 1.948243819824e+00
RINT1853 nd1853 nd2069 1.948243819824e+00
RINT1854 nd1854 nd2070 4.360197086303e+01
RINT1855 nd1855 nd2071 7.146878153240e+03
RINT1856 nd1856 nd2072 8.606018088935e+01
RINT1857 nd1857 nd2073 4.705599732811e+04
RINT1858 nd1858 nd2074 7.328285803988e+03
RINT1859 nd1859 nd2075 1.256277566398e+04
RINT1860 nd1860 nd2076 1.256277566398e+04
RINT1861 nd1861 nd2077 1.256277566398e+04
RINT1862 nd1862 nd2078 1.256277566398e+04
RINT1863 nd1863 nd2079 1.256277566398e+04
RINT1864 nd1864 nd2080 1.256277566398e+04
RINT1865 nd1865 nd2081 1.256277566398e+04
RINT1866 nd1866 nd2082 1.059962652161e+03
RINT1867 nd1867 nd2083 2.158733577428e+04
RINT1868 nd1868 nd2084 3.597889295714e+01
RINT1869 nd1869 nd2085 3.597889295714e+01
RINT1870 nd1870 nd2086 3.597889295714e+01
RINT1871 nd1871 nd2087 3.597889295714e+01
RINT1872 nd1872 nd2088 2.674118885599e+00
RINT1873 nd1873 nd2089 4.383196783166e+02
RINT1874 nd1874 nd2090 5.278090656434e+00
RINT1875 nd1875 nd2091 2.885955121870e+03
RINT1876 nd1876 nd2092 4.494454511947e+02
RINT1877 nd1877 nd2093 7.704779163337e+02
RINT1878 nd1878 nd2094 7.704779163337e+02
RINT1879 nd1879 nd2095 7.704779163337e+02
RINT1880 nd1880 nd2096 7.704779163337e+02
RINT1881 nd1881 nd2097 7.704779163337e+02
RINT1882 nd1882 nd2098 7.704779163337e+02
RINT1883 nd1883 nd2099 7.704779163337e+02
RINT1884 nd1884 nd2100 6.500775286230e+01
RINT1885 nd1885 nd2101 1.323956260260e+03
RINT1886 nd1886 nd2102 2.206593767100e+00
RINT1887 nd1887 nd2103 2.206593767100e+00
RINT1888 nd1888 nd2104 2.206593767100e+00
RINT1889 nd1889 nd2105 2.206593767100e+00
RINT1890 nd1890 nd2106 2.674118885599e+00
RINT1891 nd1891 nd2107 4.383196783166e+02
RINT1892 nd1892 nd2108 5.278090656434e+00
RINT1893 nd1893 nd2109 2.885955121870e+03
RINT1894 nd1894 nd2110 4.494454511947e+02
RINT1895 nd1895 nd2111 7.704779163337e+02
RINT1896 nd1896 nd2112 7.704779163337e+02
RINT1897 nd1897 nd2113 7.704779163337e+02
RINT1898 nd1898 nd2114 7.704779163337e+02
RINT1899 nd1899 nd2115 7.704779163337e+02
RINT1900 nd1900 nd2116 7.704779163337e+02
RINT1901 nd1901 nd2117 7.704779163337e+02
RINT1902 nd1902 nd2118 6.500775286230e+01
RINT1903 nd1903 nd2119 1.323956260260e+03
RINT1904 nd1904 nd2120 2.206593767100e+00
RINT1905 nd1905 nd2121 2.206593767100e+00
RINT1906 nd1906 nd2122 2.206593767100e+00
RINT1907 nd1907 nd2123 2.206593767100e+00
RINT1908 nd1908 nd2124 1.008290430727e+01
RINT1909 nd1909 nd2125 1.652707138887e+03
RINT1910 nd1910 nd2126 1.990131527082e+01
RINT1911 nd1911 nd2127 1.560014350791e+05
RINT1912 nd1912 nd2128 2.600023917985e+04
RINT1913 nd1913 nd2129 4.457183859403e+04
RINT1914 nd1914 nd2130 4.457183859403e+04
RINT1915 nd1915 nd2131 4.457183859403e+04
RINT1916 nd1916 nd2132 4.457183859403e+04
RINT1917 nd1917 nd2133 4.457183859403e+04
RINT1918 nd1918 nd2134 4.457183859403e+04
RINT1919 nd1919 nd2135 4.457183859403e+04
RINT1920 nd1920 nd2136 3.759070724798e+03
RINT1921 nd1921 nd2137 4.992045922532e+03
RINT1922 nd1922 nd2138 8.320076537553e+00
RINT1923 nd1923 nd2139 8.320076537553e+00
RINT1924 nd1924 nd2140 8.320076537553e+00
RINT1925 nd1925 nd2141 8.320076537553e+00
RINT1926 nd1926 nd2142 3.969373064306e+02
RINT1927 nd1927 nd2143 6.506271407884e+04
RINT1928 nd1928 nd2144 7.834622086342e+02
RINT1929 nd1929 nd2145 3.930473208276e+08
RINT1930 nd1930 nd2146 6.550788680460e+07
RINT1931 nd1931 nd2147 1.122992345222e+08
RINT1932 nd1932 nd2148 1.122992345222e+08
RINT1933 nd1933 nd2149 1.122992345222e+08
RINT1934 nd1934 nd2150 1.122992345222e+08
RINT1935 nd1935 nd2151 1.122992345222e+08
RINT1936 nd1936 nd2152 1.122992345222e+08
RINT1937 nd1937 nd2153 1.122992345222e+08
RINT1938 nd1938 nd2154 9.471019778978e+06
RINT1939 nd1939 nd2155 1.965236604138e+05
RINT1940 nd1940 nd2156 3.275394340230e+02
RINT1941 nd1941 nd2157 3.275394340230e+02
RINT1942 nd1942 nd2158 3.275394340230e+02
RINT1943 nd1943 nd2159 3.275394340230e+02
RINT1944 nd1944 nd2160 2.184681757134e+01
RINT1945 nd1945 nd2161 3.580951505815e+03
RINT1946 nd1946 nd2162 4.312055246202e+01
RINT1947 nd1947 nd2163 2.163271875915e+07
RINT1948 nd1948 nd2164 3.605453126524e+06
RINT1949 nd1949 nd2165 6.180776788327e+06
RINT1950 nd1950 nd2166 6.180776788327e+06
RINT1951 nd1951 nd2167 6.180776788327e+06
RINT1952 nd1952 nd2168 6.180776788327e+06
RINT1953 nd1953 nd2169 6.180776788327e+06
RINT1954 nd1954 nd2170 6.180776788327e+06
RINT1955 nd1955 nd2171 6.180776788327e+06
RINT1956 nd1956 nd2172 5.212703315457e+05
RINT1957 nd1957 nd2173 1.081635937957e+04
RINT1958 nd1958 nd2174 1.802726563262e+01
RINT1959 nd1959 nd2175 1.802726563262e+01
RINT1960 nd1960 nd2176 1.802726563262e+01
RINT1961 nd1961 nd2177 1.802726563262e+01
RINT1962 nd1962 nd2178 5.549312726173e-01
RINT1963 nd1963 nd2179 9.095979173230e+01
RINT1964 nd1964 nd2180 1.095305665256e+00
RINT1965 nd1965 nd2181 7.924882032189e+03
RINT1966 nd1966 nd2182 1.320057603042e+03
RINT1967 nd1967 nd2183 2.263345557379e+03
RINT1968 nd1968 nd2184 2.263345557379e+03
RINT1969 nd1969 nd2185 2.263345557379e+03
RINT1970 nd1970 nd2186 2.263345557379e+03
RINT1971 nd1971 nd2187 2.263345557379e+03
RINT1972 nd1972 nd2188 2.263345557379e+03
RINT1973 nd1973 nd2189 2.263345557379e+03
RINT1974 nd1974 nd2190 1.908541359361e+02
RINT1975 nd1975 nd2191 2.747464730728e+02
RINT1976 nd1976 nd2192 4.579107884547e-01
RINT1977 nd1977 nd2193 4.579107884547e-01
RINT1978 nd1978 nd2194 4.579107884547e-01
RINT1979 nd1979 nd2195 4.579107884547e-01
RINT1980 nd1980 nd2196 1.471750748685e-01
RINT1981 nd1981 nd2197 2.412373354828e+01
RINT1982 nd1982 nd2198 2.904894736382e-01
RINT1983 nd1983 nd2199 2.101782984604e+03
RINT1984 nd1984 nd2200 3.500966446569e+02
RINT1985 nd1985 nd2201 6.002690212241e+02
RINT1986 nd1986 nd2202 6.002690212241e+02
RINT1987 nd1987 nd2203 6.002690212241e+02
RINT1988 nd1988 nd2204 6.002690212241e+02
RINT1989 nd1989 nd2205 6.002690212241e+02
RINT1990 nd1990 nd2206 6.002690212241e+02
RINT1991 nd1991 nd2207 6.002690212241e+02
RINT1992 nd1992 nd2208 5.061702796614e+01
RINT1993 nd1993 nd2209 7.286637956741e+01
RINT1994 nd1994 nd2210 1.214439659457e-01
RINT1995 nd1995 nd2211 1.214439659457e-01
RINT1996 nd1996 nd2212 1.214439659457e-01
RINT1997 nd1997 nd2213 1.214439659457e-01
RINT1998 nd1998 nd2214 1.471750748685e-01
RINT1999 nd1999 nd2215 2.412373354828e+01
RINT2000 nd2000 nd2216 2.904894736382e-01
RINT2001 nd2001 nd2217 2.101782984604e+03
RINT2002 nd2002 nd2218 3.500966446569e+02
RINT2003 nd2003 nd2219 6.002690212241e+02
RINT2004 nd2004 nd2220 6.002690212241e+02
RINT2005 nd2005 nd2221 6.002690212241e+02
RINT2006 nd2006 nd2222 6.002690212241e+02
RINT2007 nd2007 nd2223 6.002690212241e+02
RINT2008 nd2008 nd2224 6.002690212241e+02
RINT2009 nd2009 nd2225 6.002690212241e+02
RINT2010 nd2010 nd2226 5.061702796614e+01
RINT2011 nd2011 nd2227 7.286637956741e+01
RINT2012 nd2012 nd2228 1.214439659457e-01
RINT2013 nd2013 nd2229 1.214439659457e-01
RINT2014 nd2014 nd2230 1.214439659457e-01
RINT2015 nd2015 nd2231 1.214439659457e-01
RINT2016 nd2016 nd2232 2.399707332513e+00
RINT2017 nd2017 nd2233 3.933403827727e+02
RINT2018 nd2018 nd2234 4.736465875966e+00
RINT2019 nd2019 nd2235 3.712797188523e+04
RINT2020 nd2020 nd2236 6.187995314204e+03
RINT2021 nd2021 nd2237 1.060799196721e+04
RINT2022 nd2022 nd2238 1.060799196721e+04
RINT2023 nd2023 nd2239 1.060799196721e+04
RINT2024 nd2024 nd2240 1.060799196721e+04
RINT2025 nd2025 nd2241 1.060799196721e+04
RINT2026 nd2026 nd2242 1.060799196721e+04
RINT2027 nd2027 nd2243 1.060799196721e+04
RINT2028 nd2028 nd2244 8.946499249452e+02
RINT2029 nd2029 nd2245 1.188095100327e+03
RINT2030 nd2030 nd2246 1.980158500545e+00
RINT2031 nd2031 nd2247 1.980158500545e+00
RINT2032 nd2032 nd2248 1.980158500545e+00
RINT2033 nd2033 nd2249 1.980158500545e+00
RINT2034 nd2034 nd2250 1.299436871072e-01
RINT2035 nd2035 nd2251 2.129930551661e+01
RINT2036 nd2036 nd2252 2.564787094833e-01
RINT2037 nd2037 nd2253 2.010472483962e+03
RINT2038 nd2038 nd2254 3.350787473270e+02
RINT2039 nd2039 nd2255 5.744207097034e+02
RINT2040 nd2040 nd2256 5.744207097034e+02
RINT2041 nd2041 nd2257 5.744207097034e+02
RINT2042 nd2042 nd2258 5.744207097034e+02
RINT2043 nd2043 nd2259 5.744207097034e+02
RINT2044 nd2044 nd2260 5.744207097034e+02
RINT2045 nd2045 nd2261 5.744207097034e+02
RINT2046 nd2046 nd2262 4.844512009547e+01
RINT2047 nd2047 nd2263 6.433511948678e+01
RINT2048 nd2048 nd2264 1.072251991446e-01
RINT2049 nd2049 nd2265 1.072251991446e-01
RINT2050 nd2050 nd2266 1.072251991446e-01
RINT2051 nd2051 nd2267 1.072251991446e-01
RINT2052 nd2052 nd2268 1.299436871072e-01
RINT2053 nd2053 nd2269 2.129930551661e+01
RINT2054 nd2054 nd2270 2.564787094833e-01
RINT2055 nd2055 nd2271 2.010472483962e+03
RINT2056 nd2056 nd2272 3.350787473270e+02
RINT2057 nd2057 nd2273 5.744207097034e+02
RINT2058 nd2058 nd2274 5.744207097034e+02
RINT2059 nd2059 nd2275 5.744207097034e+02
RINT2060 nd2060 nd2276 5.744207097034e+02
RINT2061 nd2061 nd2277 5.744207097034e+02
RINT2062 nd2062 nd2278 5.744207097034e+02
RINT2063 nd2063 nd2279 5.744207097034e+02
RINT2064 nd2064 nd2280 4.844512009547e+01
RINT2065 nd2065 nd2281 6.433511948678e+01
RINT2066 nd2066 nd2282 1.072251991446e-01
RINT2067 nd2067 nd2283 1.072251991446e-01
RINT2068 nd2068 nd2284 1.072251991446e-01
RINT2069 nd2069 nd2285 1.072251991446e-01
RINT2070 nd2070 nd2286 2.399715046605e+00
RINT2071 nd2071 nd2287 3.933416472035e+02
RINT2072 nd2072 nd2288 4.736481101794e+00
RINT2073 nd2073 nd2289 3.712809123669e+04
RINT2074 nd2074 nd2290 6.188015206115e+03
RINT2075 nd2075 nd2291 1.060802606763e+04
RINT2076 nd2076 nd2292 1.060802606762e+04
RINT2077 nd2077 nd2293 1.060802606763e+04
RINT2078 nd2078 nd2294 1.060802606762e+04
RINT2079 nd2079 nd2295 1.060802606763e+04
RINT2080 nd2080 nd2296 1.060802606763e+04
RINT2081 nd2081 nd2297 1.060802606762e+04
RINT2082 nd2082 nd2298 8.946528008840e+02
RINT2083 nd2083 nd2299 1.188098919574e+03
RINT2084 nd2084 nd2300 1.980164865957e+00
RINT2085 nd2085 nd2301 1.980164865957e+00
RINT2086 nd2086 nd2302 1.980164865957e+00
RINT2087 nd2087 nd2303 1.980164865957e+00
RINT2088 nd2088 nd2304 1.471750748685e-01
RINT2089 nd2089 nd2305 2.412373354828e+01
RINT2090 nd2090 nd2306 2.904894736382e-01
RINT2091 nd2091 nd2307 2.101782984604e+03
RINT2092 nd2092 nd2308 3.500966446569e+02
RINT2093 nd2093 nd2309 6.002690212241e+02
RINT2094 nd2094 nd2310 6.002690212241e+02
RINT2095 nd2095 nd2311 6.002690212241e+02
RINT2096 nd2096 nd2312 6.002690212241e+02
RINT2097 nd2097 nd2313 6.002690212241e+02
RINT2098 nd2098 nd2314 6.002690212241e+02
RINT2099 nd2099 nd2315 6.002690212241e+02
RINT2100 nd2100 nd2316 5.061702796614e+01
RINT2101 nd2101 nd2317 7.286637956741e+01
RINT2102 nd2102 nd2318 1.214439659457e-01
RINT2103 nd2103 nd2319 1.214439659457e-01
RINT2104 nd2104 nd2320 1.214439659457e-01
RINT2105 nd2105 nd2321 1.214439659457e-01
RINT2106 nd2106 nd2322 1.471750748685e-01
RINT2107 nd2107 nd2323 2.412373354828e+01
RINT2108 nd2108 nd2324 2.904894736382e-01
RINT2109 nd2109 nd2325 2.101782984604e+03
RINT2110 nd2110 nd2326 3.500966446569e+02
RINT2111 nd2111 nd2327 6.002690212241e+02
RINT2112 nd2112 nd2328 6.002690212241e+02
RINT2113 nd2113 nd2329 6.002690212241e+02
RINT2114 nd2114 nd2330 6.002690212241e+02
RINT2115 nd2115 nd2331 6.002690212241e+02
RINT2116 nd2116 nd2332 6.002690212241e+02
RINT2117 nd2117 nd2333 6.002690212241e+02
RINT2118 nd2118 nd2334 5.061702796614e+01
RINT2119 nd2119 nd2335 7.286637956741e+01
RINT2120 nd2120 nd2336 1.214439659457e-01
RINT2121 nd2121 nd2337 1.214439659457e-01
RINT2122 nd2122 nd2338 1.214439659457e-01
RINT2123 nd2123 nd2339 1.214439659457e-01
RINT2124 nd2124 nd2340 5.549312726173e-01
RINT2125 nd2125 nd2341 9.095979173230e+01
RINT2126 nd2126 nd2342 1.095305665256e+00
RINT2127 nd2127 nd2343 7.924882032189e+03
RINT2128 nd2128 nd2344 1.320057603042e+03
RINT2129 nd2129 nd2345 2.263345557379e+03
RINT2130 nd2130 nd2346 2.263345557379e+03
RINT2131 nd2131 nd2347 2.263345557379e+03
RINT2132 nd2132 nd2348 2.263345557379e+03
RINT2133 nd2133 nd2349 2.263345557379e+03
RINT2134 nd2134 nd2350 2.263345557379e+03
RINT2135 nd2135 nd2351 2.263345557379e+03
RINT2136 nd2136 nd2352 1.908541359361e+02
RINT2137 nd2137 nd2353 2.747464730728e+02
RINT2138 nd2138 nd2354 4.579107884547e-01
RINT2139 nd2139 nd2355 4.579107884547e-01
RINT2140 nd2140 nd2356 4.579107884547e-01
RINT2141 nd2141 nd2357 4.579107884547e-01
RINT2142 nd2142 nd2358 2.184617823338e+01
RINT2143 nd2143 nd2359 3.580846710770e+03
RINT2144 nd2144 nd2360 4.311929055711e+01
RINT2145 nd2145 nd2361 2.163208568669e+07
RINT2146 nd2146 nd2362 3.605347614449e+06
RINT2147 nd2147 nd2363 6.180595910484e+06
RINT2148 nd2148 nd2364 6.180595910484e+06
RINT2149 nd2149 nd2365 6.180595910484e+06
RINT2150 nd2150 nd2366 6.180595910484e+06
RINT2151 nd2151 nd2367 6.180595910484e+06
RINT2152 nd2152 nd2368 6.180595910484e+06
RINT2153 nd2153 nd2369 6.180595910484e+06
RINT2154 nd2154 nd2370 5.212550767878e+05
RINT2155 nd2155 nd2371 1.081604284335e+04
RINT2156 nd2156 nd2372 1.802673807224e+01
RINT2157 nd2157 nd2373 1.802673807224e+01
RINT2158 nd2158 nd2374 1.802673807224e+01
RINT2159 nd2159 nd2375 1.802673807224e+01
RINT2160 nd2160 nd2376 4.468851815394e+02
RINT2161 nd2161 nd2377 7.324976091067e+04
RINT2162 nd2162 nd2378 8.820477331373e+02
RINT2163 nd2163 nd2379 4.425057067603e+08
RINT2164 nd2164 nd2380 7.375095112672e+07
RINT2165 nd2165 nd2381 1.264302019315e+08
RINT2166 nd2166 nd2382 1.264302019315e+08
RINT2167 nd2167 nd2383 1.264302019315e+08
RINT2168 nd2168 nd2384 1.264302019315e+08
RINT2169 nd2169 nd2385 1.264302019315e+08
RINT2170 nd2170 nd2386 1.264302019315e+08
RINT2171 nd2171 nd2387 1.264302019315e+08
RINT2172 nd2172 nd2388 1.066278811471e+07
RINT2173 nd2173 nd2389 2.212528533802e+05
RINT2174 nd2174 nd2390 3.687547556336e+02
RINT2175 nd2175 nd2391 3.687547556336e+02
RINT2176 nd2176 nd2392 3.687547556336e+02
RINT2177 nd2177 nd2393 3.687547556336e+02
RINT2178 nd2178 nd2394 1.135133580420e+01
RINT2179 nd2179 nd2395 1.860618046923e+03
RINT2180 nd2180 nd2396 2.240490494602e+01
RINT2181 nd2181 nd2397 3.527778123429e+03
RINT2182 nd2182 nd2398 3.910957798651e+02
RINT2183 nd2183 nd2399 7.719122879540e+02
RINT2184 nd2184 nd2400 7.719122879540e+02
RINT2185 nd2185 nd2401 7.719122879540e+02
RINT2186 nd2186 nd2402 7.719122879540e+02
RINT2187 nd2187 nd2403 7.719122879540e+02
RINT2188 nd2188 nd2404 7.719122879540e+02
RINT2189 nd2189 nd2405 7.719122879540e+02
RINT2190 nd2190 nd2406 5.717781540082e+01
RINT2191 nd2191 nd2407 5.620046356661e+03
RINT2192 nd2192 nd2408 9.366743927768e+00
RINT2193 nd2193 nd2409 9.366743927768e+00
RINT2194 nd2194 nd2410 9.366743927768e+00
RINT2195 nd2195 nd2411 9.366743927768e+00
RINT2196 nd2196 nd2412 3.010523607656e+00
RINT2197 nd2197 nd2413 4.934603866638e+02
RINT2198 nd2198 nd2414 5.942075578659e+00
RINT2199 nd2199 nd2415 9.356131741980e+02
RINT2200 nd2200 nd2416 1.037237465658e+02
RINT2201 nd2201 nd2417 2.047212950096e+02
RINT2202 nd2202 nd2418 2.047212950096e+02
RINT2203 nd2203 nd2419 2.047212950096e+02
RINT2204 nd2204 nd2420 2.047212950096e+02
RINT2205 nd2205 nd2421 2.047212950096e+02
RINT2206 nd2206 nd2422 2.047212950096e+02
RINT2207 nd2207 nd2423 2.047212950096e+02
RINT2208 nd2208 nd2424 1.516430894720e+01
RINT2209 nd2209 nd2425 1.490510238151e+03
RINT2210 nd2210 nd2426 2.484183730251e+00
RINT2211 nd2211 nd2427 2.484183730251e+00
RINT2212 nd2212 nd2428 2.484183730251e+00
RINT2213 nd2213 nd2429 2.484183730251e+00
RINT2214 nd2214 nd2430 3.010523607656e+00
RINT2215 nd2215 nd2431 4.934603866638e+02
RINT2216 nd2216 nd2432 5.942075578659e+00
RINT2217 nd2217 nd2433 9.356131741980e+02
RINT2218 nd2218 nd2434 1.037237465658e+02
RINT2219 nd2219 nd2435 2.047212950096e+02
RINT2220 nd2220 nd2436 2.047212950096e+02
RINT2221 nd2221 nd2437 2.047212950096e+02
RINT2222 nd2222 nd2438 2.047212950096e+02
RINT2223 nd2223 nd2439 2.047212950096e+02
RINT2224 nd2224 nd2440 2.047212950096e+02
RINT2225 nd2225 nd2441 2.047212950096e+02
RINT2226 nd2226 nd2442 1.516430894720e+01
RINT2227 nd2227 nd2443 1.490510238151e+03
RINT2228 nd2228 nd2444 2.484183730251e+00
RINT2229 nd2229 nd2445 2.484183730251e+00
RINT2230 nd2230 nd2446 2.484183730251e+00
RINT2231 nd2231 nd2447 2.484183730251e+00
RINT2232 nd2232 nd2448 4.908695023563e+01
RINT2233 nd2233 nd2449 8.045931073857e+03
RINT2234 nd2234 nd2450 9.688625841836e+01
RINT2235 nd2235 nd2451 7.594671581769e+05
RINT2236 nd2236 nd2452 1.265778596962e+05
RINT2237 nd2237 nd2453 2.169906166220e+05
RINT2238 nd2238 nd2454 2.169906166220e+05
RINT2239 nd2239 nd2455 2.169906166220e+05
RINT2240 nd2240 nd2456 2.169906166220e+05
RINT2241 nd2241 nd2457 2.169906166220e+05
RINT2242 nd2242 nd2458 2.169906166220e+05
RINT2243 nd2243 nd2459 2.169906166220e+05
RINT2244 nd2244 nd2460 1.830041345005e+04
RINT2245 nd2245 nd2461 2.430294906166e+04
RINT2246 nd2246 nd2462 4.050491510277e+01
RINT2247 nd2247 nd2463 4.050491510277e+01
RINT2248 nd2248 nd2464 4.050491510277e+01
RINT2249 nd2249 nd2465 4.050491510277e+01
RINT2250 nd2250 nd2466 2.658048844559e+00
RINT2251 nd2251 nd2467 4.356856087332e+02
RINT2252 nd2252 nd2468 5.246372121437e+00
RINT2253 nd2253 nd2469 9.808388650042e+02
RINT2254 nd2254 nd2470 1.175514057588e+02
RINT2255 nd2255 nd2471 2.251840606506e+02
RINT2256 nd2256 nd2472 2.251840606506e+02
RINT2257 nd2257 nd2473 2.251840606506e+02
RINT2258 nd2258 nd2474 2.251840606506e+02
RINT2259 nd2259 nd2475 2.251840606506e+02
RINT2260 nd2260 nd2476 2.251840606506e+02
RINT2261 nd2261 nd2477 2.251840606506e+02
RINT2262 nd2262 nd2478 1.714323673368e+01
RINT2263 nd2263 nd2479 1.315999982941e+03
RINT2264 nd2264 nd2480 2.193333304902e+00
RINT2265 nd2265 nd2481 2.193333304902e+00
RINT2266 nd2266 nd2482 2.193333304902e+00
RINT2267 nd2267 nd2483 2.193333304902e+00
RINT2268 nd2268 nd2484 2.658048844559e+00
RINT2269 nd2269 nd2485 4.356856087332e+02
RINT2270 nd2270 nd2486 5.246372121437e+00
RINT2271 nd2271 nd2487 9.808388650042e+02
RINT2272 nd2272 nd2488 1.175514057588e+02
RINT2273 nd2273 nd2489 2.251840606506e+02
RINT2274 nd2274 nd2490 2.251840606506e+02
RINT2275 nd2275 nd2491 2.251840606506e+02
RINT2276 nd2276 nd2492 2.251840606506e+02
RINT2277 nd2277 nd2493 2.251840606506e+02
RINT2278 nd2278 nd2494 2.251840606506e+02
RINT2279 nd2279 nd2495 2.251840606506e+02
RINT2280 nd2280 nd2496 1.714323673368e+01
RINT2281 nd2281 nd2497 1.315999982941e+03
RINT2282 nd2282 nd2498 2.193333304902e+00
RINT2283 nd2283 nd2499 2.193333304902e+00
RINT2284 nd2284 nd2500 2.193333304902e+00
RINT2285 nd2285 nd2501 2.193333304902e+00
RINT2286 nd2286 nd2502 4.908710803039e+01
RINT2287 nd2287 nd2503 8.045956938282e+03
RINT2288 nd2288 nd2504 9.688656986862e+01
RINT2289 nd2289 nd2505 7.594695995577e+05
RINT2290 nd2290 nd2506 1.265782665929e+05
RINT2291 nd2291 nd2507 2.169913141593e+05
RINT2292 nd2292 nd2508 2.169913141593e+05
RINT2293 nd2293 nd2509 2.169913141593e+05
RINT2294 nd2294 nd2510 2.169913141593e+05
RINT2295 nd2295 nd2511 2.169913141593e+05
RINT2296 nd2296 nd2512 2.169913141593e+05
RINT2297 nd2297 nd2513 2.169913141593e+05
RINT2298 nd2298 nd2514 1.830047227850e+04
RINT2299 nd2299 nd2515 2.430302718585e+04
RINT2300 nd2300 nd2516 4.050504530974e+01
RINT2301 nd2301 nd2517 4.050504530974e+01
RINT2302 nd2302 nd2518 4.050504530974e+01
RINT2303 nd2303 nd2519 4.050504530974e+01
RINT2304 nd2304 nd2520 3.010523607656e+00
RINT2305 nd2305 nd2521 4.934603866638e+02
RINT2306 nd2306 nd2522 5.942075578658e+00
RINT2307 nd2307 nd2523 9.356131741980e+02
RINT2308 nd2308 nd2524 1.037237465658e+02
RINT2309 nd2309 nd2525 2.047212950096e+02
RINT2310 nd2310 nd2526 2.047212950096e+02
RINT2311 nd2311 nd2527 2.047212950096e+02
RINT2312 nd2312 nd2528 2.047212950096e+02
RINT2313 nd2313 nd2529 2.047212950096e+02
RINT2314 nd2314 nd2530 2.047212950096e+02
RINT2315 nd2315 nd2531 2.047212950096e+02
RINT2316 nd2316 nd2532 1.516430894720e+01
RINT2317 nd2317 nd2533 1.490510238151e+03
RINT2318 nd2318 nd2534 2.484183730251e+00
RINT2319 nd2319 nd2535 2.484183730251e+00
RINT2320 nd2320 nd2536 2.484183730251e+00
RINT2321 nd2321 nd2537 2.484183730251e+00
RINT2322 nd2322 nd2538 3.010523607656e+00
RINT2323 nd2323 nd2539 4.934603866638e+02
RINT2324 nd2324 nd2540 5.942075578658e+00
RINT2325 nd2325 nd2541 9.356131741980e+02
RINT2326 nd2326 nd2542 1.037237465658e+02
RINT2327 nd2327 nd2543 2.047212950096e+02
RINT2328 nd2328 nd2544 2.047212950096e+02
RINT2329 nd2329 nd2545 2.047212950096e+02
RINT2330 nd2330 nd2546 2.047212950096e+02
RINT2331 nd2331 nd2547 2.047212950096e+02
RINT2332 nd2332 nd2548 2.047212950096e+02
RINT2333 nd2333 nd2549 2.047212950096e+02
RINT2334 nd2334 nd2550 1.516430894720e+01
RINT2335 nd2335 nd2551 1.490510238151e+03
RINT2336 nd2336 nd2552 2.484183730251e+00
RINT2337 nd2337 nd2553 2.484183730251e+00
RINT2338 nd2338 nd2554 2.484183730251e+00
RINT2339 nd2339 nd2555 2.484183730251e+00
RINT2340 nd2340 nd2556 1.135133580420e+01
RINT2341 nd2341 nd2557 1.860618046923e+03
RINT2342 nd2342 nd2558 2.240490494602e+01
RINT2343 nd2343 nd2559 3.527778123429e+03
RINT2344 nd2344 nd2560 3.910957798651e+02
RINT2345 nd2345 nd2561 7.719122879540e+02
RINT2346 nd2346 nd2562 7.719122879540e+02
RINT2347 nd2347 nd2563 7.719122879540e+02
RINT2348 nd2348 nd2564 7.719122879540e+02
RINT2349 nd2349 nd2565 7.719122879540e+02
RINT2350 nd2350 nd2566 7.719122879540e+02
RINT2351 nd2351 nd2567 7.719122879540e+02
RINT2352 nd2352 nd2568 5.717781540082e+01
RINT2353 nd2353 nd2569 5.620046356661e+03
RINT2354 nd2354 nd2570 9.366743927768e+00
RINT2355 nd2355 nd2571 9.366743927768e+00
RINT2356 nd2356 nd2572 9.366743927768e+00
RINT2357 nd2357 nd2573 9.366743927768e+00
RINT2358 nd2358 nd2574 4.468721036318e+02
RINT2359 nd2359 nd2575 7.324761728710e+04
RINT2360 nd2360 nd2576 8.820219203799e+02
RINT2361 nd2361 nd2577 4.424927570162e+08
RINT2362 nd2362 nd2578 7.374879283603e+07
RINT2363 nd2363 nd2579 1.264265020046e+08
RINT2364 nd2364 nd2580 1.264265020046e+08
RINT2365 nd2365 nd2581 1.264265020046e+08
RINT2366 nd2366 nd2582 1.264265020046e+08
RINT2367 nd2367 nd2583 1.264265020046e+08
RINT2368 nd2368 nd2584 1.264265020046e+08
RINT2369 nd2369 nd2585 1.264265020046e+08
RINT2370 nd2370 nd2586 1.066247607268e+07
RINT2371 nd2371 nd2587 2.212463785081e+05
RINT2372 nd2372 nd2588 3.687439641801e+02
RINT2373 nd2373 nd2589 3.687439641801e+02
RINT2374 nd2374 nd2590 3.687439641801e+02
RINT2375 nd2375 nd2591 3.687439641801e+02
RINT2376 nd2376 nd2592 4.468851815394e+02
RINT2377 nd2377 nd2593 7.324976091067e+04
RINT2378 nd2378 nd2594 8.820477331373e+02
RINT2379 nd2379 nd2595 4.425057067603e+08
RINT2380 nd2380 nd2596 7.375095112672e+07
RINT2381 nd2381 nd2597 1.264302019315e+08
RINT2382 nd2382 nd2598 1.264302019315e+08
RINT2383 nd2383 nd2599 1.264302019315e+08
RINT2384 nd2384 nd2600 1.264302019315e+08
RINT2385 nd2385 nd2601 1.264302019315e+08
RINT2386 nd2386 nd2602 1.264302019315e+08
RINT2387 nd2387 nd2603 1.264302019315e+08
RINT2388 nd2388 nd2604 1.066278811471e+07
RINT2389 nd2389 nd2605 2.212528533802e+05
RINT2390 nd2390 nd2606 3.687547556336e+02
RINT2391 nd2391 nd2607 3.687547556336e+02
RINT2392 nd2392 nd2608 3.687547556336e+02
RINT2393 nd2393 nd2609 3.687547556336e+02
RINT2394 nd2394 nd2610 1.135133580420e+01
RINT2395 nd2395 nd2611 1.860618046923e+03
RINT2396 nd2396 nd2612 2.240490494602e+01
RINT2397 nd2397 nd2613 4.188723374767e+03
RINT2398 nd2398 nd2614 5.020093907439e+02
RINT2399 nd2399 nd2615 9.616602401535e+02
RINT2400 nd2400 nd2616 9.616602401535e+02
RINT2401 nd2401 nd2617 9.616602401535e+02
RINT2402 nd2402 nd2618 9.616602401535e+02
RINT2403 nd2403 nd2619 9.616602401535e+02
RINT2404 nd2404 nd2620 9.616602401535e+02
RINT2405 nd2405 nd2621 9.616602401535e+02
RINT2406 nd2406 nd2622 7.321108388708e+01
RINT2407 nd2407 nd2623 5.620046356661e+03
RINT2408 nd2408 nd2624 9.366743927768e+00
RINT2409 nd2409 nd2625 9.366743927768e+00
RINT2410 nd2410 nd2626 9.366743927768e+00
RINT2411 nd2411 nd2627 9.366743927768e+00
RINT2412 nd2412 nd2628 3.010523607656e+00
RINT2413 nd2413 nd2629 4.934603866638e+02
RINT2414 nd2414 nd2630 5.942075578659e+00
RINT2415 nd2415 nd2631 1.110904551076e+03
RINT2416 nd2416 nd2632 1.331394954892e+02
RINT2417 nd2417 nd2633 2.550449484945e+02
RINT2418 nd2418 nd2634 2.550449484945e+02
RINT2419 nd2419 nd2635 2.550449484945e+02
RINT2420 nd2420 nd2636 2.550449484945e+02
RINT2421 nd2421 nd2637 2.550449484945e+02
RINT2422 nd2422 nd2638 2.550449484945e+02
RINT2423 nd2423 nd2639 2.550449484945e+02
RINT2424 nd2424 nd2640 1.941654270351e+01
RINT2425 nd2425 nd2641 1.490510238151e+03
RINT2426 nd2426 nd2642 2.484183730251e+00
RINT2427 nd2427 nd2643 2.484183730251e+00
RINT2428 nd2428 nd2644 2.484183730251e+00
RINT2429 nd2429 nd2645 2.484183730251e+00
RINT2430 nd2430 nd2646 3.010523607656e+00
RINT2431 nd2431 nd2647 4.934603866638e+02
RINT2432 nd2432 nd2648 5.942075578659e+00
RINT2433 nd2433 nd2649 1.110904551076e+03
RINT2434 nd2434 nd2650 1.331394954892e+02
RINT2435 nd2435 nd2651 2.550449484945e+02
RINT2436 nd2436 nd2652 2.550449484945e+02
RINT2437 nd2437 nd2653 2.550449484945e+02
RINT2438 nd2438 nd2654 2.550449484945e+02
RINT2439 nd2439 nd2655 2.550449484945e+02
RINT2440 nd2440 nd2656 2.550449484945e+02
RINT2441 nd2441 nd2657 2.550449484945e+02
RINT2442 nd2442 nd2658 1.941654270351e+01
RINT2443 nd2443 nd2659 1.490510238151e+03
RINT2444 nd2444 nd2660 2.484183730251e+00
RINT2445 nd2445 nd2661 2.484183730251e+00
RINT2446 nd2446 nd2662 2.484183730251e+00
RINT2447 nd2447 nd2663 2.484183730251e+00
RINT2448 nd2448 nd2664 4.908695023563e+01
RINT2449 nd2449 nd2665 8.045931073857e+03
RINT2450 nd2450 nd2666 9.688625841836e+01
RINT2451 nd2451 nd2667 7.594671581769e+05
RINT2452 nd2452 nd2668 1.265778596962e+05
RINT2453 nd2453 nd2669 2.169906166220e+05
RINT2454 nd2454 nd2670 2.169906166220e+05
RINT2455 nd2455 nd2671 2.169906166220e+05
RINT2456 nd2456 nd2672 2.169906166220e+05
RINT2457 nd2457 nd2673 2.169906166220e+05
RINT2458 nd2458 nd2674 2.169906166220e+05
RINT2459 nd2459 nd2675 2.169906166220e+05
RINT2460 nd2460 nd2676 1.830041345005e+04
RINT2461 nd2461 nd2677 2.430294906166e+04
RINT2462 nd2462 nd2678 4.050491510277e+01
RINT2463 nd2463 nd2679 4.050491510277e+01
RINT2464 nd2464 nd2680 4.050491510277e+01
RINT2465 nd2465 nd2681 4.050491510277e+01
RINT2466 nd2466 nd2682 2.658048844559e+00
RINT2467 nd2467 nd2683 4.356856087332e+02
RINT2468 nd2468 nd2684 5.246372121437e+00
RINT2469 nd2469 nd2685 8.260707573614e+02
RINT2470 nd2470 nd2686 9.157967870155e+01
RINT2471 nd2471 nd2687 1.807523449652e+02
RINT2472 nd2472 nd2688 1.807523449652e+02
RINT2473 nd2473 nd2689 1.807523449652e+02
RINT2474 nd2474 nd2690 1.807523449652e+02
RINT2475 nd2475 nd2691 1.807523449652e+02
RINT2476 nd2476 nd2692 1.807523449652e+02
RINT2477 nd2477 nd2693 1.807523449652e+02
RINT2478 nd2478 nd2694 1.338885826145e+01
RINT2479 nd2479 nd2695 1.315999982941e+03
RINT2480 nd2480 nd2696 2.193333304902e+00
RINT2481 nd2481 nd2697 2.193333304902e+00
RINT2482 nd2482 nd2698 2.193333304902e+00
RINT2483 nd2483 nd2699 2.193333304902e+00
RINT2484 nd2484 nd2700 2.658048844559e+00
RINT2485 nd2485 nd2701 4.356856087332e+02
RINT2486 nd2486 nd2702 5.246372121437e+00
RINT2487 nd2487 nd2703 8.260707573614e+02
RINT2488 nd2488 nd2704 9.157967870155e+01
RINT2489 nd2489 nd2705 1.807523449652e+02
RINT2490 nd2490 nd2706 1.807523449652e+02
RINT2491 nd2491 nd2707 1.807523449652e+02
RINT2492 nd2492 nd2708 1.807523449652e+02
RINT2493 nd2493 nd2709 1.807523449652e+02
RINT2494 nd2494 nd2710 1.807523449652e+02
RINT2495 nd2495 nd2711 1.807523449652e+02
RINT2496 nd2496 nd2712 1.338885826145e+01
RINT2497 nd2497 nd2713 1.315999982941e+03
RINT2498 nd2498 nd2714 2.193333304902e+00
RINT2499 nd2499 nd2715 2.193333304902e+00
RINT2500 nd2500 nd2716 2.193333304902e+00
RINT2501 nd2501 nd2717 2.193333304902e+00
RINT2502 nd2502 nd2718 4.908710803039e+01
RINT2503 nd2503 nd2719 8.045956938282e+03
RINT2504 nd2504 nd2720 9.688656986862e+01
RINT2505 nd2505 nd2721 7.594695995577e+05
RINT2506 nd2506 nd2722 1.265782665929e+05
RINT2507 nd2507 nd2723 2.169913141593e+05
RINT2508 nd2508 nd2724 2.169913141593e+05
RINT2509 nd2509 nd2725 2.169913141593e+05
RINT2510 nd2510 nd2726 2.169913141593e+05
RINT2511 nd2511 nd2727 2.169913141593e+05
RINT2512 nd2512 nd2728 2.169913141593e+05
RINT2513 nd2513 nd2729 2.169913141593e+05
RINT2514 nd2514 nd2730 1.830047227850e+04
RINT2515 nd2515 nd2731 2.430302718585e+04
RINT2516 nd2516 nd2732 4.050504530974e+01
RINT2517 nd2517 nd2733 4.050504530974e+01
RINT2518 nd2518 nd2734 4.050504530974e+01
RINT2519 nd2519 nd2735 4.050504530974e+01
RINT2520 nd2520 nd2736 3.010523607656e+00
RINT2521 nd2521 nd2737 4.934603866638e+02
RINT2522 nd2522 nd2738 5.942075578658e+00
RINT2523 nd2523 nd2739 1.110904551076e+03
RINT2524 nd2524 nd2740 1.331394954892e+02
RINT2525 nd2525 nd2741 2.550449484945e+02
RINT2526 nd2526 nd2742 2.550449484945e+02
RINT2527 nd2527 nd2743 2.550449484945e+02
RINT2528 nd2528 nd2744 2.550449484945e+02
RINT2529 nd2529 nd2745 2.550449484945e+02
RINT2530 nd2530 nd2746 2.550449484945e+02
RINT2531 nd2531 nd2747 2.550449484945e+02
RINT2532 nd2532 nd2748 1.941654270351e+01
RINT2533 nd2533 nd2749 1.490510238151e+03
RINT2534 nd2534 nd2750 2.484183730251e+00
RINT2535 nd2535 nd2751 2.484183730251e+00
RINT2536 nd2536 nd2752 2.484183730251e+00
RINT2537 nd2537 nd2753 2.484183730251e+00
RINT2538 nd2538 nd2754 3.010523607656e+00
RINT2539 nd2539 nd2755 4.934603866638e+02
RINT2540 nd2540 nd2756 5.942075578658e+00
RINT2541 nd2541 nd2757 1.110904551076e+03
RINT2542 nd2542 nd2758 1.331394954892e+02
RINT2543 nd2543 nd2759 2.550449484945e+02
RINT2544 nd2544 nd2760 2.550449484945e+02
RINT2545 nd2545 nd2761 2.550449484945e+02
RINT2546 nd2546 nd2762 2.550449484945e+02
RINT2547 nd2547 nd2763 2.550449484945e+02
RINT2548 nd2548 nd2764 2.550449484945e+02
RINT2549 nd2549 nd2765 2.550449484945e+02
RINT2550 nd2550 nd2766 1.941654270351e+01
RINT2551 nd2551 nd2767 1.490510238151e+03
RINT2552 nd2552 nd2768 2.484183730251e+00
RINT2553 nd2553 nd2769 2.484183730251e+00
RINT2554 nd2554 nd2770 2.484183730251e+00
RINT2555 nd2555 nd2771 2.484183730251e+00
RINT2556 nd2556 nd2772 1.135133580420e+01
RINT2557 nd2557 nd2773 1.860618046923e+03
RINT2558 nd2558 nd2774 2.240490494602e+01
RINT2559 nd2559 nd2775 4.188723374767e+03
RINT2560 nd2560 nd2776 5.020093907439e+02
RINT2561 nd2561 nd2777 9.616602401535e+02
RINT2562 nd2562 nd2778 9.616602401535e+02
RINT2563 nd2563 nd2779 9.616602401535e+02
RINT2564 nd2564 nd2780 9.616602401535e+02
RINT2565 nd2565 nd2781 9.616602401535e+02
RINT2566 nd2566 nd2782 9.616602401535e+02
RINT2567 nd2567 nd2783 9.616602401535e+02
RINT2568 nd2568 nd2784 7.321108388708e+01
RINT2569 nd2569 nd2785 5.620046356661e+03
RINT2570 nd2570 nd2786 9.366743927768e+00
RINT2571 nd2571 nd2787 9.366743927768e+00
RINT2572 nd2572 nd2788 9.366743927768e+00
RINT2573 nd2573 nd2789 9.366743927768e+00
RINT2574 nd2574 nd2790 4.468721036318e+02
RINT2575 nd2575 nd2791 7.324761728710e+04
RINT2576 nd2576 nd2792 8.820219203799e+02
RINT2577 nd2577 nd2793 4.424927570162e+08
RINT2578 nd2578 nd2794 7.374879283603e+07
RINT2579 nd2579 nd2795 1.264265020046e+08
RINT2580 nd2580 nd2796 1.264265020046e+08
RINT2581 nd2581 nd2797 1.264265020046e+08
RINT2582 nd2582 nd2798 1.264265020046e+08
RINT2583 nd2583 nd2799 1.264265020046e+08
RINT2584 nd2584 nd2800 1.264265020046e+08
RINT2585 nd2585 nd2801 1.264265020046e+08
RINT2586 nd2586 nd2802 1.066247607268e+07
RINT2587 nd2587 nd2803 2.212463785081e+05
RINT2588 nd2588 nd2804 3.687439641801e+02
RINT2589 nd2589 nd2805 3.687439641801e+02
RINT2590 nd2590 nd2806 3.687439641801e+02
RINT2591 nd2591 nd2807 3.687439641801e+02
RINT2592 nd2592 nd2808 2.418964854698e+00
RINT2593 nd2593 nd2809 3.964969181740e+02
RINT2594 nd2594 nd2810 4.774475759692e+00
RINT2595 nd2595 nd2811 2.395258999122e+06
RINT2596 nd2596 nd2812 3.992098331871e+05
RINT2597 nd2597 nd2813 6.843597140350e+05
RINT2598 nd2598 nd2814 6.843597140350e+05
RINT2599 nd2599 nd2815 6.843597140350e+05
RINT2600 nd2600 nd2816 6.843597140350e+05
RINT2601 nd2601 nd2817 6.843597140350e+05
RINT2602 nd2602 nd2818 6.843597140350e+05
RINT2603 nd2603 nd2819 6.843597140350e+05
RINT2604 nd2604 nd2820 5.771708431620e+04
RINT2605 nd2605 nd2821 1.197629499561e+03
RINT2606 nd2606 nd2822 1.996049165935e+00
RINT2607 nd2607 nd2823 1.996049165935e+00
RINT2608 nd2608 nd2824 1.996049165935e+00
RINT2609 nd2609 nd2825 1.996049165935e+00
RINT2610 nd2610 nd2826 6.144415500568e-02
RINT2611 nd2611 nd2827 1.007142292797e+01
RINT2612 nd2612 nd2828 1.212765154812e-01
RINT2613 nd2613 nd2829 1.834889984702e+04
RINT2614 nd2614 nd2830 3.058149974504e+03
RINT2615 nd2615 nd2831 5.242542813435e+03
RINT2616 nd2616 nd2832 5.242542813435e+03
RINT2617 nd2617 nd2833 5.242542813435e+03
RINT2618 nd2618 nd2834 5.242542813435e+03
RINT2619 nd2619 nd2835 5.242542813435e+03
RINT2620 nd2620 nd2836 5.242542813435e+03
RINT2621 nd2621 nd2837 5.242542813435e+03
RINT2622 nd2622 nd2838 4.421421649885e+02
RINT2623 nd2623 nd2839 3.042100114331e+01
RINT2624 nd2624 nd2840 5.070166857218e-02
RINT2625 nd2625 nd2841 5.070166857218e-02
RINT2626 nd2626 nd2842 5.070166857218e-02
RINT2627 nd2627 nd2843 5.070166857218e-02
RINT2628 nd2628 nd2844 1.629579834372e-02
RINT2629 nd2629 nd2845 2.671073872743e+00
RINT2630 nd2630 nd2846 3.216412757126e-02
RINT2631 nd2631 nd2847 4.866369660523e+03
RINT2632 nd2632 nd2848 8.110616100872e+02
RINT2633 nd2633 nd2849 1.390391331578e+03
RINT2634 nd2634 nd2850 1.390391331578e+03
RINT2635 nd2635 nd2851 1.390391331578e+03
RINT2636 nd2636 nd2852 1.390391331578e+03
RINT2637 nd2637 nd2853 1.390391331578e+03
RINT2638 nd2638 nd2854 1.390391331578e+03
RINT2639 nd2639 nd2855 1.390391331578e+03
RINT2640 nd2640 nd2856 1.172619195307e+02
RINT2641 nd2641 nd2857 8.068049759974e+00
RINT2642 nd2642 nd2858 1.344674959996e-02
RINT2643 nd2643 nd2859 1.344674959996e-02
RINT2644 nd2644 nd2860 1.344674959996e-02
RINT2645 nd2645 nd2861 1.344674959996e-02
RINT2646 nd2646 nd2862 1.629579834372e-02
RINT2647 nd2647 nd2863 2.671073872743e+00
RINT2648 nd2648 nd2864 3.216412757126e-02
RINT2649 nd2649 nd2865 4.866369660523e+03
RINT2650 nd2650 nd2866 8.110616100872e+02
RINT2651 nd2651 nd2867 1.390391331578e+03
RINT2652 nd2652 nd2868 1.390391331578e+03
RINT2653 nd2653 nd2869 1.390391331578e+03
RINT2654 nd2654 nd2870 1.390391331578e+03
RINT2655 nd2655 nd2871 1.390391331578e+03
RINT2656 nd2656 nd2872 1.390391331578e+03
RINT2657 nd2657 nd2873 1.390391331578e+03
RINT2658 nd2658 nd2874 1.172619195307e+02
RINT2659 nd2659 nd2875 8.068049759974e+00
RINT2660 nd2660 nd2876 1.344674959996e-02
RINT2661 nd2661 nd2877 1.344674959996e-02
RINT2662 nd2662 nd2878 1.344674959996e-02
RINT2663 nd2663 nd2879 1.344674959996e-02
RINT2664 nd2664 nd2880 2.657049558800e-01
RINT2665 nd2665 nd2881 4.355218139913e+01
RINT2666 nd2666 nd2882 5.244399763043e-01
RINT2667 nd2667 nd2883 7.934674378464e+04
RINT2668 nd2668 nd2884 1.322445729744e+04
RINT2669 nd2669 nd2885 2.267049822418e+04
RINT2670 nd2670 nd2886 2.267049822418e+04
RINT2671 nd2671 nd2887 2.267049822418e+04
RINT2672 nd2672 nd2888 2.267049822418e+04
RINT2673 nd2673 nd2889 2.267049822418e+04
RINT2674 nd2674 nd2890 2.267049822418e+04
RINT2675 nd2675 nd2891 2.267049822418e+04
RINT2676 nd2676 nd2892 1.911969729750e+03
RINT2677 nd2677 nd2893 1.315505236562e+02
RINT2678 nd2678 nd2894 2.192508727603e-01
RINT2679 nd2679 nd2895 2.192508727603e-01
RINT2680 nd2680 nd2896 2.192508727603e-01
RINT2681 nd2681 nd2897 2.192508727603e-01
RINT2682 nd2682 nd2898 1.438787188000e-02
RINT2683 nd2683 nd2899 2.358342184436e+00
RINT2684 nd2684 nd2900 2.839832310552e-02
RINT2685 nd2685 nd2901 4.141842694696e+03
RINT2686 nd2686 nd2902 6.901300733325e+02
RINT2687 nd2687 nd2903 1.183171370697e+03
RINT2688 nd2688 nd2904 1.183171370697e+03
RINT2689 nd2689 nd2905 1.183171370697e+03
RINT2690 nd2690 nd2906 1.183171370697e+03
RINT2691 nd2691 nd2907 1.183171370697e+03
RINT2692 nd2692 nd2908 1.183171370697e+03
RINT2693 nd2693 nd2909 1.183171370697e+03
RINT2694 nd2694 nd2910 9.977841194556e+01
RINT2695 nd2695 nd2911 7.123435367789e+00
RINT2696 nd2696 nd2912 1.187239227965e-02
RINT2697 nd2697 nd2913 1.187239227965e-02
RINT2698 nd2698 nd2914 1.187239227965e-02
RINT2699 nd2699 nd2915 1.187239227965e-02
RINT2700 nd2700 nd2916 1.438787188000e-02
RINT2701 nd2701 nd2917 2.358342184436e+00
RINT2702 nd2702 nd2918 2.839832310552e-02
RINT2703 nd2703 nd2919 4.141842694696e+03
RINT2704 nd2704 nd2920 6.901300733325e+02
RINT2705 nd2705 nd2921 1.183171370697e+03
RINT2706 nd2706 nd2922 1.183171370697e+03
RINT2707 nd2707 nd2923 1.183171370697e+03
RINT2708 nd2708 nd2924 1.183171370697e+03
RINT2709 nd2709 nd2925 1.183171370697e+03
RINT2710 nd2710 nd2926 1.183171370697e+03
RINT2711 nd2711 nd2927 1.183171370697e+03
RINT2712 nd2712 nd2928 9.977841194556e+01
RINT2713 nd2713 nd2929 7.123435367789e+00
RINT2714 nd2714 nd2930 1.187239227965e-02
RINT2715 nd2715 nd2931 1.187239227965e-02
RINT2716 nd2716 nd2932 1.187239227965e-02
RINT2717 nd2717 nd2933 1.187239227965e-02
RINT2718 nd2718 nd2934 2.657058100143e-01
RINT2719 nd2719 nd2935 4.355232140183e+01
RINT2720 nd2720 nd2936 5.244416621674e-01
RINT2721 nd2721 nd2937 7.934699885243e+04
RINT2722 nd2722 nd2938 1.322449980874e+04
RINT2723 nd2723 nd2939 2.267057110069e+04
RINT2724 nd2724 nd2940 2.267057110069e+04
RINT2725 nd2725 nd2941 2.267057110069e+04
RINT2726 nd2726 nd2942 2.267057110069e+04
RINT2727 nd2727 nd2943 2.267057110069e+04
RINT2728 nd2728 nd2944 2.267057110069e+04
RINT2729 nd2729 nd2945 2.267057110069e+04
RINT2730 nd2730 nd2946 1.911975875962e+03
RINT2731 nd2731 nd2947 1.315509465381e+02
RINT2732 nd2732 nd2948 2.192515775634e-01
RINT2733 nd2733 nd2949 2.192515775634e-01
RINT2734 nd2734 nd2950 2.192515775634e-01
RINT2735 nd2735 nd2951 2.192515775634e-01
RINT2736 nd2736 nd2952 1.629579834372e-02
RINT2737 nd2737 nd2953 2.671073872743e+00
RINT2738 nd2738 nd2954 3.216412757126e-02
RINT2739 nd2739 nd2955 4.866369660523e+03
RINT2740 nd2740 nd2956 8.110616100872e+02
RINT2741 nd2741 nd2957 1.390391331578e+03
RINT2742 nd2742 nd2958 1.390391331578e+03
RINT2743 nd2743 nd2959 1.390391331578e+03
RINT2744 nd2744 nd2960 1.390391331578e+03
RINT2745 nd2745 nd2961 1.390391331578e+03
RINT2746 nd2746 nd2962 1.390391331578e+03
RINT2747 nd2747 nd2963 1.390391331578e+03
RINT2748 nd2748 nd2964 1.172619195307e+02
RINT2749 nd2749 nd2965 8.068049759974e+00
RINT2750 nd2750 nd2966 1.344674959996e-02
RINT2751 nd2751 nd2967 1.344674959996e-02
RINT2752 nd2752 nd2968 1.344674959996e-02
RINT2753 nd2753 nd2969 1.344674959996e-02
RINT2754 nd2754 nd2970 1.629579834372e-02
RINT2755 nd2755 nd2971 2.671073872743e+00
RINT2756 nd2756 nd2972 3.216412757126e-02
RINT2757 nd2757 nd2973 4.866369660523e+03
RINT2758 nd2758 nd2974 8.110616100872e+02
RINT2759 nd2759 nd2975 1.390391331578e+03
RINT2760 nd2760 nd2976 1.390391331578e+03
RINT2761 nd2761 nd2977 1.390391331578e+03
RINT2762 nd2762 nd2978 1.390391331578e+03
RINT2763 nd2763 nd2979 1.390391331578e+03
RINT2764 nd2764 nd2980 1.390391331578e+03
RINT2765 nd2765 nd2981 1.390391331578e+03
RINT2766 nd2766 nd2982 1.172619195307e+02
RINT2767 nd2767 nd2983 8.068049759974e+00
RINT2768 nd2768 nd2984 1.344674959996e-02
RINT2769 nd2769 nd2985 1.344674959996e-02
RINT2770 nd2770 nd2986 1.344674959996e-02
RINT2771 nd2771 nd2987 1.344674959996e-02
RINT2772 nd2772 nd2988 6.144415500568e-02
RINT2773 nd2773 nd2989 1.007142292797e+01
RINT2774 nd2774 nd2990 1.212765154812e-01
RINT2775 nd2775 nd2991 1.834889984702e+04
RINT2776 nd2776 nd2992 3.058149974504e+03
RINT2777 nd2777 nd2993 5.242542813435e+03
RINT2778 nd2778 nd2994 5.242542813435e+03
RINT2779 nd2779 nd2995 5.242542813435e+03
RINT2780 nd2780 nd2996 5.242542813435e+03
RINT2781 nd2781 nd2997 5.242542813435e+03
RINT2782 nd2782 nd2998 5.242542813435e+03
RINT2783 nd2783 nd2999 5.242542813435e+03
RINT2784 nd2784 nd3000 4.421421649885e+02
RINT2785 nd2785 nd3001 3.042100114331e+01
RINT2786 nd2786 nd3002 5.070166857218e-02
RINT2787 nd2787 nd3003 5.070166857218e-02
RINT2788 nd2788 nd3004 5.070166857218e-02
RINT2789 nd2789 nd3005 5.070166857218e-02
RINT2790 nd2790 nd3006 2.418894064705e+00
RINT2791 nd2791 nd3007 3.964853148577e+02
RINT2792 nd2792 nd3008 4.774336036659e+00
RINT2793 nd2793 nd3009 2.395188902871e+06
RINT2794 nd2794 nd3010 3.991981504785e+05
RINT2795 nd2795 nd3011 6.843396865346e+05
RINT2796 nd2796 nd3012 6.843396865346e+05
RINT2797 nd2797 nd3013 6.843396865346e+05
RINT2798 nd2798 nd3014 6.843396865346e+05
RINT2799 nd2799 nd3015 6.843396865346e+05
RINT2800 nd2800 nd3016 6.843396865346e+05
RINT2801 nd2801 nd3017 6.843396865346e+05
RINT2802 nd2802 nd3018 5.771539524991e+04
RINT2803 nd2803 nd3019 1.197594451436e+03
RINT2804 nd2804 nd3020 1.995990752393e+00
RINT2805 nd2805 nd3021 1.995990752393e+00
RINT2806 nd2806 nd3022 1.995990752393e+00
RINT2807 nd2807 nd3023 1.995990752393e+00
RINT2808 nd0 nd18 2.343613441335e+02
RINT2809 nd1 nd19 3.841459312959e+04
RINT2810 nd2 nd20 4.625749540762e+02
RINT2811 nd3 nd21 2.320646029610e+08
RINT2812 nd4 nd22 3.867743382683e+07
RINT2813 nd5 nd23 6.630417227456e+07
RINT2814 nd6 nd24 6.630417227456e+07
RINT2815 nd7 nd25 6.630417227456e+07
RINT2816 nd8 nd26 6.630417227456e+07
RINT2817 nd9 nd27 6.630417227456e+07
RINT2818 nd10 nd28 6.630417227456e+07
RINT2819 nd11 nd29 6.630417227456e+07
RINT2820 nd12 nd30 5.591918143638e+06
RINT2821 nd13 nd31 1.160323014805e+05
RINT2822 nd14 nd32 1.933871691341e+02
RINT2823 nd15 nd33 1.933871691341e+02
RINT2824 nd16 nd34 1.933871691341e+02
RINT2825 nd17 nd35 1.933871691341e+02
RINT2826 nd18 nd36 1.090337307634e+03
RINT2827 nd19 nd37 1.787191663439e+05
RINT2828 nd20 nd38 2.152073038628e+03
RINT2829 nd21 nd39 1.079652002019e+09
RINT2830 nd22 nd40 1.799420003365e+08
RINT2831 nd23 nd41 3.084720005768e+08
RINT2832 nd24 nd42 3.084720005768e+08
RINT2833 nd25 nd43 3.084720005768e+08
RINT2834 nd26 nd44 3.084720005768e+08
RINT2835 nd27 nd45 3.084720005768e+08
RINT2836 nd28 nd46 3.084720005768e+08
RINT2837 nd29 nd47 3.084720005768e+08
RINT2838 nd30 nd48 2.601571089202e+07
RINT2839 nd31 nd49 5.398260010094e+05
RINT2840 nd32 nd50 8.997100016824e+02
RINT2841 nd33 nd51 8.997100016824e+02
RINT2842 nd34 nd52 8.997100016824e+02
RINT2843 nd35 nd53 8.997100016824e+02
RINT2844 nd36 nd54 1.723563023961e+03
RINT2845 nd37 nd55 2.825123423978e+05
RINT2846 nd38 nd56 3.401913782343e+03
RINT2847 nd39 nd57 1.706672106326e+09
RINT2848 nd40 nd58 2.844453510543e+08
RINT2849 nd41 nd59 4.876206018073e+08
RINT2850 nd42 nd60 4.876206018073e+08
RINT2851 nd43 nd61 4.876206018073e+08
RINT2852 nd44 nd62 4.876206018073e+08
RINT2853 nd45 nd63 4.876206018073e+08
RINT2854 nd46 nd64 4.876206018073e+08
RINT2855 nd47 nd65 4.876206018073e+08
RINT2856 nd48 nd66 4.112462906809e+07
RINT2857 nd49 nd67 8.533360531629e+05
RINT2858 nd50 nd68 1.422226755271e+03
RINT2859 nd51 nd69 1.422226755271e+03
RINT2860 nd52 nd70 1.422226755271e+03
RINT2861 nd53 nd71 1.422226755271e+03
RINT2862 nd54 nd72 9.146349399077e+02
RINT2863 nd55 nd73 1.499194724649e+05
RINT2864 nd56 nd74 1.805277303254e+03
RINT2865 nd57 nd75 9.056715174966e+08
RINT2866 nd58 nd76 1.509452529161e+08
RINT2867 nd59 nd77 2.587632907133e+08
RINT2868 nd60 nd78 2.587632907133e+08
RINT2869 nd61 nd79 2.587632907133e+08
RINT2870 nd62 nd80 2.587632907133e+08
RINT2871 nd63 nd81 2.587632907133e+08
RINT2872 nd64 nd82 2.587632907133e+08
RINT2873 nd65 nd83 2.587632907133e+08
RINT2874 nd66 nd84 2.182341006016e+07
RINT2875 nd67 nd85 4.528357587483e+05
RINT2876 nd68 nd86 7.547262645805e+02
RINT2877 nd69 nd87 7.547262645805e+02
RINT2878 nd70 nd88 7.547262645805e+02
RINT2879 nd71 nd89 7.547262645805e+02
RINT2880 nd72 nd90 1.028912837734e+03
RINT2881 nd73 nd91 1.686509700374e+05
RINT2882 nd74 nd92 2.030835376983e+03
RINT2883 nd75 nd93 1.018829491925e+09
RINT2884 nd76 nd94 1.698049153208e+08
RINT2885 nd77 nd95 2.910941405499e+08
RINT2886 nd78 nd96 2.910941405499e+08
RINT2887 nd79 nd97 2.910941405499e+08
RINT2888 nd80 nd98 2.910941405499e+08
RINT2889 nd81 nd99 2.910941405499e+08
RINT2890 nd82 nd100 2.910941405499e+08
RINT2891 nd83 nd101 2.910941405499e+08
RINT2892 nd84 nd102 2.455010823915e+07
RINT2893 nd85 nd103 5.094147459623e+05
RINT2894 nd86 nd104 8.490245766039e+02
RINT2895 nd87 nd105 8.490245766039e+02
RINT2896 nd88 nd106 8.490245766039e+02
RINT2897 nd89 nd107 8.490245766039e+02
RINT2898 nd90 nd108 1.952118819614e+03
RINT2899 nd91 nd109 3.199753375428e+05
RINT2900 nd92 nd110 3.853029929799e+03
RINT2901 nd93 nd111 1.932988055182e+09
RINT2902 nd94 nd112 3.221646758636e+08
RINT2903 nd95 nd113 5.522823014805e+08
RINT2904 nd96 nd114 5.522823014805e+08
RINT2905 nd97 nd115 5.522823014805e+08
RINT2906 nd98 nd116 5.522823014805e+08
RINT2907 nd99 nd117 5.522823014805e+08
RINT2908 nd100 nd118 5.522823014805e+08
RINT2909 nd101 nd119 5.522823014805e+08
RINT2910 nd102 nd120 4.657802542606e+07
RINT2911 nd103 nd121 9.664940275908e+05
RINT2912 nd104 nd122 1.610823379318e+03
RINT2913 nd105 nd123 1.610823379318e+03
RINT2914 nd106 nd124 1.610823379318e+03
RINT2915 nd107 nd125 1.610823379318e+03
RINT2916 nd108 nd126 1.028912667833e+03
RINT2917 nd109 nd127 1.686509421885e+05
RINT2918 nd110 nd128 2.030835041636e+03
RINT2919 nd111 nd129 1.018829323688e+09
RINT2920 nd112 nd130 1.698048872813e+08
RINT2921 nd113 nd131 2.910940924822e+08
RINT2922 nd114 nd132 2.910940924822e+08
RINT2923 nd115 nd133 2.910940924822e+08
RINT2924 nd116 nd134 2.910940924822e+08
RINT2925 nd117 nd135 2.910940924822e+08
RINT2926 nd118 nd136 2.910940924822e+08
RINT2927 nd119 nd137 2.910940924822e+08
RINT2928 nd120 nd138 2.455010418525e+07
RINT2929 nd121 nd139 5.094146618439e+05
RINT2930 nd122 nd140 8.490244364065e+02
RINT2931 nd123 nd141 8.490244364065e+02
RINT2932 nd124 nd142 8.490244364065e+02
RINT2933 nd125 nd143 8.490244364065e+02
RINT2934 nd126 nd144 9.146347700058e+02
RINT2935 nd127 nd145 1.499194446160e+05
RINT2936 nd128 nd146 1.805276967907e+03
RINT2937 nd129 nd147 9.056713492598e+08
RINT2938 nd130 nd148 1.509452248766e+08
RINT2939 nd131 nd149 2.587632426456e+08
RINT2940 nd132 nd150 2.587632426456e+08
RINT2941 nd133 nd151 2.587632426456e+08
RINT2942 nd134 nd152 2.587632426456e+08
RINT2943 nd135 nd153 2.587632426456e+08
RINT2944 nd136 nd154 2.587632426456e+08
RINT2945 nd137 nd155 2.587632426456e+08
RINT2946 nd138 nd156 2.182340600626e+07
RINT2947 nd139 nd157 4.528356746299e+05
RINT2948 nd140 nd158 7.547261243831e+02
RINT2949 nd141 nd159 7.547261243831e+02
RINT2950 nd142 nd160 7.547261243831e+02
RINT2951 nd143 nd161 7.547261243831e+02
RINT2952 nd144 nd162 1.723563023961e+03
RINT2953 nd145 nd163 2.825123423978e+05
RINT2954 nd146 nd164 3.401913782343e+03
RINT2955 nd147 nd165 1.706672106326e+09
RINT2956 nd148 nd166 2.844453510543e+08
RINT2957 nd149 nd167 4.876206018073e+08
RINT2958 nd150 nd168 4.876206018073e+08
RINT2959 nd151 nd169 4.876206018073e+08
RINT2960 nd152 nd170 4.876206018073e+08
RINT2961 nd153 nd171 4.876206018073e+08
RINT2962 nd154 nd172 4.876206018073e+08
RINT2963 nd155 nd173 4.876206018073e+08
RINT2964 nd156 nd174 4.112462906809e+07
RINT2965 nd157 nd175 8.533360531629e+05
RINT2966 nd158 nd176 1.422226755271e+03
RINT2967 nd159 nd177 1.422226755271e+03
RINT2968 nd160 nd178 1.422226755271e+03
RINT2969 nd161 nd179 1.422226755271e+03
RINT2970 nd162 nd180 1.090337307634e+03
RINT2971 nd163 nd181 1.787191663439e+05
RINT2972 nd164 nd182 2.152073038628e+03
RINT2973 nd165 nd183 1.079652002019e+09
RINT2974 nd166 nd184 1.799420003365e+08
RINT2975 nd167 nd185 3.084720005768e+08
RINT2976 nd168 nd186 3.084720005768e+08
RINT2977 nd169 nd187 3.084720005768e+08
RINT2978 nd170 nd188 3.084720005768e+08
RINT2979 nd171 nd189 3.084720005768e+08
RINT2980 nd172 nd190 3.084720005768e+08
RINT2981 nd173 nd191 3.084720005768e+08
RINT2982 nd174 nd192 2.601571089202e+07
RINT2983 nd175 nd193 5.398260010094e+05
RINT2984 nd176 nd194 8.997100016824e+02
RINT2985 nd177 nd195 8.997100016824e+02
RINT2986 nd178 nd196 8.997100016824e+02
RINT2987 nd179 nd197 8.997100016824e+02
RINT2988 nd180 nd198 2.343615140354e+02
RINT2989 nd181 nd199 3.841462097853e+04
RINT2990 nd182 nd200 4.625752894232e+02
RINT2991 nd183 nd201 2.320647711978e+08
RINT2992 nd184 nd202 3.867746186631e+07
RINT2993 nd185 nd203 6.630422034224e+07
RINT2994 nd186 nd204 6.630422034224e+07
RINT2995 nd187 nd205 6.630422034224e+07
RINT2996 nd188 nd206 6.630422034224e+07
RINT2997 nd189 nd207 6.630422034224e+07
RINT2998 nd190 nd208 6.630422034224e+07
RINT2999 nd191 nd209 6.630422034224e+07
RINT3000 nd192 nd210 5.591922197538e+06
RINT3001 nd193 nd211 1.160323855989e+05
RINT3002 nd194 nd212 1.933873093315e+02
RINT3003 nd195 nd213 1.933873093315e+02
RINT3004 nd196 nd214 1.933873093315e+02
RINT3005 nd197 nd215 1.933873093315e+02
RINT3006 nd216 nd234 9.595617906178e+01
RINT3007 nd217 nd235 1.572835140777e+04
RINT3008 nd218 nd236 1.893952489774e+02
RINT3009 nd219 nd237 3.801556311348e+06
RINT3010 nd220 nd238 6.335927185581e+05
RINT3011 nd221 nd239 1.086158946100e+06
RINT3012 nd222 nd240 1.086158946100e+06
RINT3013 nd223 nd241 1.086158946100e+06
RINT3014 nd224 nd242 1.086158946100e+06
RINT3015 nd225 nd243 1.086158946100e+06
RINT3016 nd226 nd244 1.086158946100e+06
RINT3017 nd227 nd245 1.086158946100e+06
RINT3018 nd228 nd246 9.160376653852e+04
RINT3019 nd229 nd247 4.750790425349e+04
RINT3020 nd230 nd248 7.917984042248e+01
RINT3021 nd231 nd249 7.917984042248e+01
RINT3022 nd232 nd250 7.917984042248e+01
RINT3023 nd233 nd251 7.917984042248e+01
RINT3024 nd234 nd252 4.464243124901e+02
RINT3025 nd235 nd253 7.317421902862e+04
RINT3026 nd236 nd254 8.811380844914e+02
RINT3027 nd237 nd255 6.907021159807e+06
RINT3028 nd238 nd256 1.151170193301e+06
RINT3029 nd239 nd257 1.973434617088e+06
RINT3030 nd240 nd258 1.973434617088e+06
RINT3031 nd241 nd259 1.973434617088e+06
RINT3032 nd242 nd260 1.973434617088e+06
RINT3033 nd243 nd261 1.973434617088e+06
RINT3034 nd244 nd262 1.973434617088e+06
RINT3035 nd245 nd263 1.973434617088e+06
RINT3036 nd246 nd264 1.664342448146e+05
RINT3037 nd247 nd265 2.210246771138e+05
RINT3038 nd248 nd266 3.683744618564e+02
RINT3039 nd249 nd267 3.683744618564e+02
RINT3040 nd250 nd268 3.683744618564e+02
RINT3041 nd251 nd269 3.683744618564e+02
RINT3042 nd252 nd270 7.056902782450e+02
RINT3043 nd253 nd271 1.156709738738e+05
RINT3044 nd254 nd272 1.392868987239e+03
RINT3045 nd255 nd273 1.091835177372e+07
RINT3046 nd256 nd274 1.819725295620e+06
RINT3047 nd257 nd275 3.119529078206e+06
RINT3048 nd258 nd276 3.119529078206e+06
RINT3049 nd259 nd277 3.119529078206e+06
RINT3050 nd260 nd278 3.119529078206e+06
RINT3051 nd261 nd279 3.119529078206e+06
RINT3052 nd262 nd280 3.119529078206e+06
RINT3053 nd263 nd281 3.119529078206e+06
RINT3054 nd264 nd282 2.630928138246e+05
RINT3055 nd265 nd283 3.493872567591e+05
RINT3056 nd266 nd284 5.823120945985e+02
RINT3057 nd267 nd285 5.823120945985e+02
RINT3058 nd268 nd286 5.823120945985e+02
RINT3059 nd269 nd287 5.823120945985e+02
RINT3060 nd270 nd288 3.744852820948e+02
RINT3061 nd271 nd289 6.138256203421e+04
RINT3062 nd272 nd290 7.391471183429e+02
RINT3063 nd273 nd291 5.793989473911e+06
RINT3064 nd274 nd292 9.656649123185e+05
RINT3065 nd275 nd293 1.655425563975e+06
RINT3066 nd276 nd294 1.655425563975e+06
RINT3067 nd277 nd295 1.655425563975e+06
RINT3068 nd278 nd296 1.655425563975e+06
RINT3069 nd279 nd297 1.655425563975e+06
RINT3070 nd280 nd298 1.655425563975e+06
RINT3071 nd281 nd299 1.655425563975e+06
RINT3072 nd282 nd300 1.396142041906e+05
RINT3073 nd283 nd301 1.854076631651e+05
RINT3074 nd284 nd302 3.090127719419e+02
RINT3075 nd285 nd303 3.090127719419e+02
RINT3076 nd286 nd304 3.090127719419e+02
RINT3077 nd287 nd305 3.090127719419e+02
RINT3078 nd288 nd306 4.212748687786e+02
RINT3079 nd289 nd307 6.905192808007e+04
RINT3080 nd290 nd308 8.314989137789e+02
RINT3081 nd291 nd309 4.590124185691e+05
RINT3082 nd292 nd310 6.957116866609e+04
RINT3083 nd293 nd311 1.228369415093e+05
RINT3084 nd294 nd312 1.228369415093e+05
RINT3085 nd295 nd313 1.228369415093e+05
RINT3086 nd296 nd314 1.228369415093e+05
RINT3087 nd297 nd315 1.228369415093e+05
RINT3088 nd298 nd316 1.228369415093e+05
RINT3089 nd299 nd317 1.228369415093e+05
RINT3090 nd300 nd318 1.008079741980e+04
RINT3091 nd301 nd319 2.085731875323e+05
RINT3092 nd302 nd320 3.476219792205e+02
RINT3093 nd303 nd321 3.476219792205e+02
RINT3094 nd304 nd322 3.476219792205e+02
RINT3095 nd305 nd323 3.476219792205e+02
RINT3096 nd306 nd324 7.992694516125e+02
RINT3097 nd307 nd325 1.310097059655e+05
RINT3098 nd308 nd326 1.577572578111e+03
RINT3099 nd309 nd327 2.483976630380e+05
RINT3100 nd310 nd328 2.753780831547e+04
RINT3101 nd311 nd329 5.435183327565e+04
RINT3102 nd312 nd330 5.435183327565e+04
RINT3103 nd313 nd331 5.435183327565e+04
RINT3104 nd314 nd332 5.435183327565e+04
RINT3105 nd315 nd333 5.435183327565e+04
RINT3106 nd316 nd334 5.435183327565e+04
RINT3107 nd317 nd335 5.435183327565e+04
RINT3108 nd318 nd336 4.026000282971e+03
RINT3109 nd319 nd337 3.957183054934e+05
RINT3110 nd320 nd338 6.595305091556e+02
RINT3111 nd321 nd339 6.595305091556e+02
RINT3112 nd322 nd340 6.595305091556e+02
RINT3113 nd323 nd341 6.595305091556e+02
RINT3114 nd324 nd342 4.212747992145e+02
RINT3115 nd325 nd343 6.905191667769e+04
RINT3116 nd326 nd344 8.314987764754e+02
RINT3117 nd327 nd345 4.590113422819e+05
RINT3118 nd328 nd346 6.957098928488e+04
RINT3119 nd329 nd347 1.228366339986e+05
RINT3120 nd330 nd348 1.228366339986e+05
RINT3121 nd331 nd349 1.228366339986e+05
RINT3122 nd332 nd350 1.228366339986e+05
RINT3123 nd333 nd351 1.228366339986e+05
RINT3124 nd334 nd352 1.228366339986e+05
RINT3125 nd335 nd353 1.228366339986e+05
RINT3126 nd336 nd354 1.008077148517e+04
RINT3127 nd337 nd355 2.085731530911e+05
RINT3128 nd338 nd356 3.476219218185e+02
RINT3129 nd339 nd357 3.476219218185e+02
RINT3130 nd340 nd358 3.476219218185e+02
RINT3131 nd341 nd359 3.476219218185e+02
RINT3132 nd342 nd360 3.744852125307e+02
RINT3133 nd343 nd361 6.138255063183e+04
RINT3134 nd344 nd362 7.391469810395e+02
RINT3135 nd345 nd363 5.793988397624e+06
RINT3136 nd346 nd364 9.656647329373e+05
RINT3137 nd347 nd365 1.655425256464e+06
RINT3138 nd348 nd366 1.655425256464e+06
RINT3139 nd349 nd367 1.655425256464e+06
RINT3140 nd350 nd368 1.655425256464e+06
RINT3141 nd351 nd369 1.655425256464e+06
RINT3142 nd352 nd370 1.655425256464e+06
RINT3143 nd353 nd371 1.655425256464e+06
RINT3144 nd354 nd372 1.396141782560e+05
RINT3145 nd355 nd373 1.854076287240e+05
RINT3146 nd356 nd374 3.090127145399e+02
RINT3147 nd357 nd375 3.090127145399e+02
RINT3148 nd358 nd376 3.090127145399e+02
RINT3149 nd359 nd377 3.090127145399e+02
RINT3150 nd360 nd378 7.056902782450e+02
RINT3151 nd361 nd379 1.156709738738e+05
RINT3152 nd362 nd380 1.392868987239e+03
RINT3153 nd363 nd381 1.091835177372e+07
RINT3154 nd364 nd382 1.819725295620e+06
RINT3155 nd365 nd383 3.119529078206e+06
RINT3156 nd366 nd384 3.119529078206e+06
RINT3157 nd367 nd385 3.119529078206e+06
RINT3158 nd368 nd386 3.119529078206e+06
RINT3159 nd369 nd387 3.119529078206e+06
RINT3160 nd370 nd388 3.119529078206e+06
RINT3161 nd371 nd389 3.119529078206e+06
RINT3162 nd372 nd390 2.630928138246e+05
RINT3163 nd373 nd391 3.493872567591e+05
RINT3164 nd374 nd392 5.823120945985e+02
RINT3165 nd375 nd393 5.823120945985e+02
RINT3166 nd376 nd394 5.823120945985e+02
RINT3167 nd377 nd395 5.823120945985e+02
RINT3168 nd378 nd396 4.464243124901e+02
RINT3169 nd379 nd397 7.317421902862e+04
RINT3170 nd380 nd398 8.811380844914e+02
RINT3171 nd381 nd399 6.907021159807e+06
RINT3172 nd382 nd400 1.151170193301e+06
RINT3173 nd383 nd401 1.973434617088e+06
RINT3174 nd384 nd402 1.973434617088e+06
RINT3175 nd385 nd403 1.973434617088e+06
RINT3176 nd386 nd404 1.973434617088e+06
RINT3177 nd387 nd405 1.973434617088e+06
RINT3178 nd388 nd406 1.973434617088e+06
RINT3179 nd389 nd407 1.973434617088e+06
RINT3180 nd390 nd408 1.664342448146e+05
RINT3181 nd391 nd409 2.210246771138e+05
RINT3182 nd392 nd410 3.683744618564e+02
RINT3183 nd393 nd411 3.683744618564e+02
RINT3184 nd394 nd412 3.683744618564e+02
RINT3185 nd395 nd413 3.683744618564e+02
RINT3186 nd396 nd414 9.595624862589e+01
RINT3187 nd397 nd415 1.572836281015e+04
RINT3188 nd398 nd416 1.893953862808e+02
RINT3189 nd399 nd417 3.801625193732e+06
RINT3190 nd400 nd418 6.336041989553e+05
RINT3191 nd401 nd419 1.086178626781e+06
RINT3192 nd402 nd420 1.086178626780e+06
RINT3193 nd403 nd421 1.086178626781e+06
RINT3194 nd404 nd422 1.086178626780e+06
RINT3195 nd405 nd423 1.086178626781e+06
RINT3196 nd406 nd424 1.086178626781e+06
RINT3197 nd407 nd425 1.086178626780e+06
RINT3198 nd408 nd426 9.160542635498e+04
RINT3199 nd409 nd427 4.750793869468e+04
RINT3200 nd410 nd428 7.917989782446e+01
RINT3201 nd411 nd429 7.917989782446e+01
RINT3202 nd412 nd430 7.917989782446e+01
RINT3203 nd413 nd431 7.917989782446e+01
RINT3204 nd432 nd450 3.699406346365e-01
RINT3205 nd433 nd451 6.063764062376e+01
RINT3206 nd434 nd452 7.301770379866e-01
RINT3207 nd435 nd453 9.186403689673e+03
RINT3208 nd436 nd454 1.524810301446e+03
RINT3209 nd437 nd455 2.617185269113e+03
RINT3210 nd438 nd456 2.617185269113e+03
RINT3211 nd439 nd457 2.617185269113e+03
RINT3212 nd440 nd458 2.617185269113e+03
RINT3213 nd441 nd459 2.617185269113e+03
RINT3214 nd442 nd460 2.617185269113e+03
RINT3215 nd443 nd461 2.617185269113e+03
RINT3216 nd444 nd462 2.204746468150e+02
RINT3217 nd445 nd463 1.831576082085e+02
RINT3218 nd446 nd464 3.052626803476e-01
RINT3219 nd447 nd465 3.052626803476e-01
RINT3220 nd448 nd466 3.052626803476e-01
RINT3221 nd449 nd467 3.052626803476e-01
RINT3222 nd450 nd468 1.721103269164e+00
RINT3223 nd451 nd469 2.821091595264e+02
RINT3224 nd452 nd470 3.397058796696e+00
RINT3225 nd453 nd471 5.348859875040e+02
RINT3226 nd454 nd472 5.929841534887e+01
RINT3227 nd455 nd473 1.170382750737e+02
RINT3228 nd456 nd474 1.170382750737e+02
RINT3229 nd457 nd475 1.170382750737e+02
RINT3230 nd458 nd476 1.170382750737e+02
RINT3231 nd459 nd477 1.170382750737e+02
RINT3232 nd460 nd478 1.170382750737e+02
RINT3233 nd461 nd479 1.170382750737e+02
RINT3234 nd462 nd480 8.669369553281e+00
RINT3235 nd463 nd481 8.521182285633e+02
RINT3236 nd464 nd482 1.420197047605e+00
RINT3237 nd465 nd483 1.420197047605e+00
RINT3238 nd466 nd484 1.420197047605e+00
RINT3239 nd467 nd485 1.420197047605e+00
RINT3240 nd468 nd486 2.720653447681e+00
RINT3241 nd469 nd487 4.459472428174e+02
RINT3242 nd470 nd488 5.369939092438e+00
RINT3243 nd471 nd489 8.455270709734e+02
RINT3244 nd472 nd490 9.373664035818e+01
RINT3245 nd473 nd491 1.850095762960e+02
RINT3246 nd474 nd492 1.850095762960e+02
RINT3247 nd475 nd493 1.850095762960e+02
RINT3248 nd476 nd494 1.850095762960e+02
RINT3249 nd477 nd495 1.850095762960e+02
RINT3250 nd478 nd496 1.850095762960e+02
RINT3251 nd479 nd497 1.850095762960e+02
RINT3252 nd480 nd498 1.370420391788e+01
RINT3253 nd481 nd499 1.346995521947e+03
RINT3254 nd482 nd500 2.244992536579e+00
RINT3255 nd483 nd501 2.244992536579e+00
RINT3256 nd484 nd502 2.244992536579e+00
RINT3257 nd485 nd503 2.244992536579e+00
RINT3258 nd486 nd504 1.443756142385e+00
RINT3259 nd487 nd505 2.366486887721e+02
RINT3260 nd488 nd506 2.849639874400e+00
RINT3261 nd489 nd507 1.713573070519e+03
RINT3262 nd490 nd508 2.620032426845e+02
RINT3263 nd491 nd509 4.613075124431e+02
RINT3264 nd492 nd510 4.613075124431e+02
RINT3265 nd493 nd511 4.613075124431e+02
RINT3266 nd494 nd512 4.613075124431e+02
RINT3267 nd495 nd513 4.613075124431e+02
RINT3268 nd496 nd514 4.613075124431e+02
RINT3269 nd497 nd515 4.613075124431e+02
RINT3270 nd498 nd516 3.795594617660e+01
RINT3271 nd499 nd517 7.148036660946e+02
RINT3272 nd500 nd518 1.191339443491e+00
RINT3273 nd501 nd519 1.191339443491e+00
RINT3274 nd502 nd520 1.191339443491e+00
RINT3275 nd503 nd521 1.191339443491e+00
RINT3276 nd504 nd522 1.624144415046e+00
RINT3277 nd505 nd523 2.662164578309e+02
RINT3278 nd506 nd524 3.205684499639e+00
RINT3279 nd507 nd525 1.769634296528e+03
RINT3280 nd508 nd526 2.682182902694e+02
RINT3281 nd509 nd527 4.735742559059e+02
RINT3282 nd510 nd528 4.735742559059e+02
RINT3283 nd511 nd529 4.735742559059e+02
RINT3284 nd512 nd530 4.735742559059e+02
RINT3285 nd513 nd531 4.735742559059e+02
RINT3286 nd514 nd532 4.735742559059e+02
RINT3287 nd515 nd533 4.735742559059e+02
RINT3288 nd516 nd534 3.886457997377e+01
RINT3289 nd517 nd535 8.041138998895e+02
RINT3290 nd518 nd536 1.340189833149e+00
RINT3291 nd519 nd537 1.340189833149e+00
RINT3292 nd520 nd538 1.340189833149e+00
RINT3293 nd521 nd539 1.340189833149e+00
RINT3294 nd522 nd540 3.081429993005e+00
RINT3295 nd523 nd541 5.050827809351e+02
RINT3296 nd524 nd542 6.082028342915e+00
RINT3297 nd525 nd543 9.576495229907e+02
RINT3298 nd526 nd544 1.061667355280e+02
RINT3299 nd527 nd545 2.095430632217e+02
RINT3300 nd528 nd546 2.095430632217e+02
RINT3301 nd529 nd547 2.095430632217e+02
RINT3302 nd530 nd548 2.095430632217e+02
RINT3303 nd531 nd549 2.095430632217e+02
RINT3304 nd532 nd550 2.095430632217e+02
RINT3305 nd533 nd551 2.095430632217e+02
RINT3306 nd534 nd552 1.552147151222e+01
RINT3307 nd535 nd553 1.525615989537e+03
RINT3308 nd536 nd554 2.542693315895e+00
RINT3309 nd537 nd555 2.542693315895e+00
RINT3310 nd538 nd556 2.542693315895e+00
RINT3311 nd539 nd557 2.542693315895e+00
RINT3312 nd540 nd558 1.624144146855e+00
RINT3313 nd541 nd559 2.662164138712e+02
RINT3314 nd542 nd560 3.205683970292e+00
RINT3315 nd543 nd561 1.769630147109e+03
RINT3316 nd544 nd562 2.682175986996e+02
RINT3317 nd545 nd563 4.735730703576e+02
RINT3318 nd546 nd564 4.735730703576e+02
RINT3319 nd547 nd565 4.735730703576e+02
RINT3320 nd548 nd566 4.735730703576e+02
RINT3321 nd549 nd567 4.735730703576e+02
RINT3322 nd550 nd568 4.735730703576e+02
RINT3323 nd551 nd569 4.735730703576e+02
RINT3324 nd552 nd570 3.886447998777e+01
RINT3325 nd553 nd571 8.041137671081e+02
RINT3326 nd554 nd572 1.340189611847e+00
RINT3327 nd555 nd573 1.340189611847e+00
RINT3328 nd556 nd574 1.340189611847e+00
RINT3329 nd557 nd575 1.340189611847e+00
RINT3330 nd558 nd576 1.443755874193e+00
RINT3331 nd559 nd577 2.366486448124e+02
RINT3332 nd560 nd578 2.849639345053e+00
RINT3333 nd561 nd579 1.713568921100e+03
RINT3334 nd562 nd580 2.620025511147e+02
RINT3335 nd563 nd581 4.613063268948e+02
RINT3336 nd564 nd582 4.613063268948e+02
RINT3337 nd565 nd583 4.613063268948e+02
RINT3338 nd566 nd584 4.613063268948e+02
RINT3339 nd567 nd585 4.613063268948e+02
RINT3340 nd568 nd586 4.613063268948e+02
RINT3341 nd569 nd587 4.613063268948e+02
RINT3342 nd570 nd588 3.795584619060e+01
RINT3343 nd571 nd589 7.148035333132e+02
RINT3344 nd572 nd590 1.191339222189e+00
RINT3345 nd573 nd591 1.191339222189e+00
RINT3346 nd574 nd592 1.191339222189e+00
RINT3347 nd575 nd593 1.191339222189e+00
RINT3348 nd576 nd594 2.720653447681e+00
RINT3349 nd577 nd595 4.459472428174e+02
RINT3350 nd578 nd596 5.369939092438e+00
RINT3351 nd579 nd597 8.455270709734e+02
RINT3352 nd580 nd598 9.373664035818e+01
RINT3353 nd581 nd599 1.850095762960e+02
RINT3354 nd582 nd600 1.850095762960e+02
RINT3355 nd583 nd601 1.850095762960e+02
RINT3356 nd584 nd602 1.850095762960e+02
RINT3357 nd585 nd603 1.850095762960e+02
RINT3358 nd586 nd604 1.850095762960e+02
RINT3359 nd587 nd605 1.850095762960e+02
RINT3360 nd588 nd606 1.370420391788e+01
RINT3361 nd589 nd607 1.346995521947e+03
RINT3362 nd590 nd608 2.244992536579e+00
RINT3363 nd591 nd609 2.244992536579e+00
RINT3364 nd592 nd610 2.244992536579e+00
RINT3365 nd593 nd611 2.244992536579e+00
RINT3366 nd594 nd612 1.721103269164e+00
RINT3367 nd595 nd613 2.821091595264e+02
RINT3368 nd596 nd614 3.397058796696e+00
RINT3369 nd597 nd615 5.348859875040e+02
RINT3370 nd598 nd616 5.929841534887e+01
RINT3371 nd599 nd617 1.170382750737e+02
RINT3372 nd600 nd618 1.170382750737e+02
RINT3373 nd601 nd619 1.170382750737e+02
RINT3374 nd602 nd620 1.170382750737e+02
RINT3375 nd603 nd621 1.170382750737e+02
RINT3376 nd604 nd622 1.170382750737e+02
RINT3377 nd605 nd623 1.170382750737e+02
RINT3378 nd606 nd624 8.669369553281e+00
RINT3379 nd607 nd625 8.521182285633e+02
RINT3380 nd608 nd626 1.420197047605e+00
RINT3381 nd609 nd627 1.420197047605e+00
RINT3382 nd610 nd628 1.420197047605e+00
RINT3383 nd611 nd629 1.420197047605e+00
RINT3384 nd612 nd630 3.699409028276e-01
RINT3385 nd613 nd631 6.063768458344e+01
RINT3386 nd614 nd632 7.301775673336e-01
RINT3387 nd615 nd633 9.186669252484e+03
RINT3388 nd616 nd634 1.524854561914e+03
RINT3389 nd617 nd635 2.617261144202e+03
RINT3390 nd618 nd636 2.617261144202e+03
RINT3391 nd619 nd637 2.617261144202e+03
RINT3392 nd620 nd638 2.617261144202e+03
RINT3393 nd621 nd639 2.617261144202e+03
RINT3394 nd622 nd640 2.617261144202e+03
RINT3395 nd623 nd641 2.617261144202e+03
RINT3396 nd624 nd642 2.204810459188e+02
RINT3397 nd625 nd643 1.831577409900e+02
RINT3398 nd626 nd644 3.052629016499e-01
RINT3399 nd627 nd645 3.052629016499e-01
RINT3400 nd628 nd646 3.052629016499e-01
RINT3401 nd629 nd647 3.052629016499e-01
RINT3402 nd648 nd666 9.595617906178e+01
RINT3403 nd649 nd667 1.572835140777e+04
RINT3404 nd650 nd668 1.893952489774e+02
RINT3405 nd651 nd669 2.382793656193e+06
RINT3406 nd652 nd670 3.955093239880e+05
RINT3407 nd653 nd671 6.788524287622e+05
RINT3408 nd654 nd672 6.788524287622e+05
RINT3409 nd655 nd673 6.788524287622e+05
RINT3410 nd656 nd674 6.788524287622e+05
RINT3411 nd657 nd675 6.788524287622e+05
RINT3412 nd658 nd676 6.788524287622e+05
RINT3413 nd659 nd677 6.788524287622e+05
RINT3414 nd660 nd678 5.718729630538e+04
RINT3415 nd661 nd679 4.750790425349e+04
RINT3416 nd662 nd680 7.917984042248e+01
RINT3417 nd663 nd681 7.917984042248e+01
RINT3418 nd664 nd682 7.917984042248e+01
RINT3419 nd665 nd683 7.917984042248e+01
RINT3420 nd666 nd684 4.464243124901e+02
RINT3421 nd667 nd685 7.317421902862e+04
RINT3422 nd668 nd686 8.811380844914e+02
RINT3423 nd669 nd687 1.387401404147e+05
RINT3424 nd670 nd688 1.538097961822e+04
RINT3425 nd671 nd689 3.035769696152e+04
RINT3426 nd672 nd690 3.035769696152e+04
RINT3427 nd673 nd691 3.035769696152e+04
RINT3428 nd674 nd692 3.035769696152e+04
RINT3429 nd675 nd693 3.035769696152e+04
RINT3430 nd676 nd694 3.035769696152e+04
RINT3431 nd677 nd695 3.035769696152e+04
RINT3432 nd678 nd696 2.248683976078e+03
RINT3433 nd679 nd697 2.210246771138e+05
RINT3434 nd680 nd698 3.683744618564e+02
RINT3435 nd681 nd699 3.683744618564e+02
RINT3436 nd682 nd700 3.683744618564e+02
RINT3437 nd683 nd701 3.683744618564e+02
RINT3438 nd684 nd702 7.056902782450e+02
RINT3439 nd685 nd703 1.156709738738e+05
RINT3440 nd686 nd704 1.392868987239e+03
RINT3441 nd687 nd705 2.193150452467e+05
RINT3442 nd688 nd706 2.431365739451e+04
RINT3443 nd689 nd707 4.798827262826e+04
RINT3444 nd690 nd708 4.798827262826e+04
RINT3445 nd691 nd709 4.798827262826e+04
RINT3446 nd692 nd710 4.798827262826e+04
RINT3447 nd693 nd711 4.798827262826e+04
RINT3448 nd694 nd712 4.798827262826e+04
RINT3449 nd695 nd713 4.798827262826e+04
RINT3450 nd696 nd714 3.554632613785e+03
RINT3451 nd697 nd715 3.493872567591e+05
RINT3452 nd698 nd716 5.823120945985e+02
RINT3453 nd699 nd717 5.823120945985e+02
RINT3454 nd700 nd718 5.823120945985e+02
RINT3455 nd701 nd719 5.823120945985e+02
RINT3456 nd702 nd720 3.744852820948e+02
RINT3457 nd703 nd721 6.138256203421e+04
RINT3458 nd704 nd722 7.391471183430e+02
RINT3459 nd705 nd723 4.444711096735e+05
RINT3460 nd706 nd724 6.795909320561e+04
RINT3461 nd707 nd725 1.196551611856e+05
RINT3462 nd708 nd726 1.196551611856e+05
RINT3463 nd709 nd727 1.196551611856e+05
RINT3464 nd710 nd728 1.196551611856e+05
RINT3465 nd711 nd729 1.196551611856e+05
RINT3466 nd712 nd730 1.196551611856e+05
RINT3467 nd713 nd731 1.196551611856e+05
RINT3468 nd714 nd732 9.845113585208e+03
RINT3469 nd715 nd733 1.854076631651e+05
RINT3470 nd716 nd734 3.090127719419e+02
RINT3471 nd717 nd735 3.090127719419e+02
RINT3472 nd718 nd736 3.090127719419e+02
RINT3473 nd719 nd737 3.090127719419e+02
RINT3474 nd720 nd738 4.212748687786e+02
RINT3475 nd721 nd739 6.905192808007e+04
RINT3476 nd722 nd740 8.314989137789e+02
RINT3477 nd723 nd741 6.517912110384e+06
RINT3478 nd724 nd742 1.086318685064e+06
RINT3479 nd725 nd743 1.862260602967e+06
RINT3480 nd726 nd744 1.862260602967e+06
RINT3481 nd727 nd745 1.862260602967e+06
RINT3482 nd728 nd746 1.862260602967e+06
RINT3483 nd729 nd747 1.862260602967e+06
RINT3484 nd730 nd748 1.862260602967e+06
RINT3485 nd731 nd749 1.862260602967e+06
RINT3486 nd732 nd750 1.570581231418e+05
RINT3487 nd733 nd751 2.085731875323e+05
RINT3488 nd734 nd752 3.476219792205e+02
RINT3489 nd735 nd753 3.476219792205e+02
RINT3490 nd736 nd754 3.476219792205e+02
RINT3491 nd737 nd755 3.476219792205e+02
RINT3492 nd738 nd756 7.992694516126e+02
RINT3493 nd739 nd757 1.310097059655e+05
RINT3494 nd740 nd758 1.577572578111e+03
RINT3495 nd741 nd759 1.236619704667e+07
RINT3496 nd742 nd760 2.061032841111e+06
RINT3497 nd743 nd761 3.533199156191e+06
RINT3498 nd744 nd762 3.533199156191e+06
RINT3499 nd745 nd763 3.533199156191e+06
RINT3500 nd746 nd764 3.533199156191e+06
RINT3501 nd747 nd765 3.533199156191e+06
RINT3502 nd748 nd766 3.533199156191e+06
RINT3503 nd749 nd767 3.533199156191e+06
RINT3504 nd750 nd768 2.979806517269e+05
RINT3505 nd751 nd769 3.957183054934e+05
RINT3506 nd752 nd770 6.595305091556e+02
RINT3507 nd753 nd771 6.595305091556e+02
RINT3508 nd754 nd772 6.595305091556e+02
RINT3509 nd755 nd773 6.595305091556e+02
RINT3510 nd756 nd774 4.212747992145e+02
RINT3511 nd757 nd775 6.905191667769e+04
RINT3512 nd758 nd776 8.314987764754e+02
RINT3513 nd759 nd777 6.517911034097e+06
RINT3514 nd760 nd778 1.086318505683e+06
RINT3515 nd761 nd779 1.862260295456e+06
RINT3516 nd762 nd780 1.862260295456e+06
RINT3517 nd763 nd781 1.862260295456e+06
RINT3518 nd764 nd782 1.862260295456e+06
RINT3519 nd765 nd783 1.862260295456e+06
RINT3520 nd766 nd784 1.862260295456e+06
RINT3521 nd767 nd785 1.862260295456e+06
RINT3522 nd768 nd786 1.570580972072e+05
RINT3523 nd769 nd787 2.085731530911e+05
RINT3524 nd770 nd788 3.476219218185e+02
RINT3525 nd771 nd789 3.476219218185e+02
RINT3526 nd772 nd790 3.476219218185e+02
RINT3527 nd773 nd791 3.476219218185e+02
RINT3528 nd774 nd792 3.744852125307e+02
RINT3529 nd775 nd793 6.138255063183e+04
RINT3530 nd776 nd794 7.391469810395e+02
RINT3531 nd777 nd795 4.444700333862e+05
RINT3532 nd778 nd796 6.795891382440e+04
RINT3533 nd779 nd797 1.196548536749e+05
RINT3534 nd780 nd798 1.196548536749e+05
RINT3535 nd781 nd799 1.196548536749e+05
RINT3536 nd782 nd800 1.196548536749e+05
RINT3537 nd783 nd801 1.196548536749e+05
RINT3538 nd784 nd802 1.196548536749e+05
RINT3539 nd785 nd803 1.196548536749e+05
RINT3540 nd786 nd804 9.845087650576e+03
RINT3541 nd787 nd805 1.854076287240e+05
RINT3542 nd788 nd806 3.090127145399e+02
RINT3543 nd789 nd807 3.090127145399e+02
RINT3544 nd790 nd808 3.090127145399e+02
RINT3545 nd791 nd809 3.090127145399e+02
RINT3546 nd792 nd810 7.056902782450e+02
RINT3547 nd793 nd811 1.156709738738e+05
RINT3548 nd794 nd812 1.392868987239e+03
RINT3549 nd795 nd813 2.193150452467e+05
RINT3550 nd796 nd814 2.431365739451e+04
RINT3551 nd797 nd815 4.798827262826e+04
RINT3552 nd798 nd816 4.798827262826e+04
RINT3553 nd799 nd817 4.798827262826e+04
RINT3554 nd800 nd818 4.798827262826e+04
RINT3555 nd801 nd819 4.798827262826e+04
RINT3556 nd802 nd820 4.798827262826e+04
RINT3557 nd803 nd821 4.798827262826e+04
RINT3558 nd804 nd822 3.554632613785e+03
RINT3559 nd805 nd823 3.493872567591e+05
RINT3560 nd806 nd824 5.823120945985e+02
RINT3561 nd807 nd825 5.823120945985e+02
RINT3562 nd808 nd826 5.823120945985e+02
RINT3563 nd809 nd827 5.823120945985e+02
RINT3564 nd810 nd828 4.464243124901e+02
RINT3565 nd811 nd829 7.317421902862e+04
RINT3566 nd812 nd830 8.811380844914e+02
RINT3567 nd813 nd831 1.387401404147e+05
RINT3568 nd814 nd832 1.538097961822e+04
RINT3569 nd815 nd833 3.035769696152e+04
RINT3570 nd816 nd834 3.035769696152e+04
RINT3571 nd817 nd835 3.035769696152e+04
RINT3572 nd818 nd836 3.035769696152e+04
RINT3573 nd819 nd837 3.035769696152e+04
RINT3574 nd820 nd838 3.035769696152e+04
RINT3575 nd821 nd839 3.035769696152e+04
RINT3576 nd822 nd840 2.248683976078e+03
RINT3577 nd823 nd841 2.210246771138e+05
RINT3578 nd824 nd842 3.683744618564e+02
RINT3579 nd825 nd843 3.683744618564e+02
RINT3580 nd826 nd844 3.683744618564e+02
RINT3581 nd827 nd845 3.683744618564e+02
RINT3582 nd828 nd846 9.595624862589e+01
RINT3583 nd829 nd847 1.572836281015e+04
RINT3584 nd830 nd848 1.893953862808e+02
RINT3585 nd831 nd849 2.382862538577e+06
RINT3586 nd832 nd850 3.955208043852e+05
RINT3587 nd833 nd851 6.788721094432e+05
RINT3588 nd834 nd852 6.788721094432e+05
RINT3589 nd835 nd853 6.788721094432e+05
RINT3590 nd836 nd854 6.788721094432e+05
RINT3591 nd837 nd855 6.788721094432e+05
RINT3592 nd838 nd856 6.788721094432e+05
RINT3593 nd839 nd857 6.788721094432e+05
RINT3594 nd840 nd858 5.718895612184e+04
RINT3595 nd841 nd859 4.750793869468e+04
RINT3596 nd842 nd860 7.917989782447e+01
RINT3597 nd843 nd861 7.917989782447e+01
RINT3598 nd844 nd862 7.917989782447e+01
RINT3599 nd845 nd863 7.917989782447e+01
RINT3600 nd864 nd882 8.180901042573e+00
RINT3601 nd865 nd883 1.340946332877e+03
RINT3602 nd866 nd884 1.614720182657e+01
RINT3603 nd867 nd885 3.241079031595e+05
RINT3604 nd868 nd886 5.401798385992e+04
RINT3605 nd869 nd887 9.260225804557e+04
RINT3606 nd870 nd888 9.260225804557e+04
RINT3607 nd871 nd889 9.260225804557e+04
RINT3608 nd872 nd890 9.260225804557e+04
RINT3609 nd873 nd891 9.260225804557e+04
RINT3610 nd874 nd892 9.260225804557e+04
RINT3611 nd875 nd893 9.260225804557e+04
RINT3612 nd876 nd894 7.809828991795e+03
RINT3613 nd877 nd895 4.050364106178e+03
RINT3614 nd878 nd896 6.750606843630e+00
RINT3615 nd879 nd897 6.750606843630e+00
RINT3616 nd880 nd898 6.750606843630e+00
RINT3617 nd881 nd899 6.750606843630e+00
RINT3618 nd882 nd900 3.806063516898e+01
RINT3619 nd883 nd901 6.238587765727e+03
RINT3620 nd884 nd902 7.512286904865e+01
RINT3621 nd885 nd903 5.888693897551e+05
RINT3622 nd886 nd904 9.814489829252e+04
RINT3623 nd887 nd905 1.682483970729e+05
RINT3624 nd888 nd906 1.682483970729e+05
RINT3625 nd889 nd907 1.682483970729e+05
RINT3626 nd890 nd908 1.682483970729e+05
RINT3627 nd891 nd909 1.682483970729e+05
RINT3628 nd892 nd910 1.682483970729e+05
RINT3629 nd893 nd911 1.682483970729e+05
RINT3630 nd894 nd912 1.418962384952e+04
RINT3631 nd895 nd913 1.884382047216e+04
RINT3632 nd896 nd914 3.140636745361e+01
RINT3633 nd897 nd915 3.140636745361e+01
RINT3634 nd898 nd916 3.140636745361e+01
RINT3635 nd899 nd917 3.140636745361e+01
RINT3636 nd900 nd918 6.016477927191e+01
RINT3637 nd901 nd919 9.861718130214e+03
RINT3638 nd902 nd920 1.187513244200e+02
RINT3639 nd903 nd921 9.308619442976e+05
RINT3640 nd904 nd922 1.551436573829e+05
RINT3641 nd905 nd923 2.659605555136e+05
RINT3642 nd906 nd924 2.659605555136e+05
RINT3643 nd907 nd925 2.659605555136e+05
RINT3644 nd908 nd926 2.659605555136e+05
RINT3645 nd909 nd927 2.659605555136e+05
RINT3646 nd910 nd928 2.659605555136e+05
RINT3647 nd911 nd929 2.659605555136e+05
RINT3648 nd912 nd930 2.243040829633e+04
RINT3649 nd913 nd931 2.978758221752e+04
RINT3650 nd914 nd932 4.964597036254e+01
RINT3651 nd915 nd933 4.964597036254e+01
RINT3652 nd916 nd934 4.964597036254e+01
RINT3653 nd917 nd935 4.964597036254e+01
RINT3654 nd918 nd936 3.192735543112e+01
RINT3655 nd919 nd937 5.233270756000e+03
RINT3656 nd920 nd938 6.301719691416e+01
RINT3657 nd921 nd939 4.939760523109e+05
RINT3658 nd922 nd940 8.232934205182e+04
RINT3659 nd923 nd941 1.411360149460e+05
RINT3660 nd924 nd942 1.411360149460e+05
RINT3661 nd925 nd943 1.411360149460e+05
RINT3662 nd926 nd944 1.411360149460e+05
RINT3663 nd927 nd945 1.411360149460e+05
RINT3664 nd928 nd946 1.411360149460e+05
RINT3665 nd929 nd947 1.411360149460e+05
RINT3666 nd930 nd948 1.190303740508e+04
RINT3667 nd931 nd949 1.580723367395e+04
RINT3668 nd932 nd950 2.634538945658e+01
RINT3669 nd933 nd951 2.634538945658e+01
RINT3670 nd934 nd952 2.634538945658e+01
RINT3671 nd935 nd953 2.634538945658e+01
RINT3672 nd936 nd954 3.591647819764e+01
RINT3673 nd937 nd955 5.887135106310e+03
RINT3674 nd938 nd956 7.089080033348e+01
RINT3675 nd939 nd957 5.556952611140e+05
RINT3676 nd940 nd958 9.261587685234e+04
RINT3677 nd941 nd959 1.587700746040e+05
RINT3678 nd942 nd960 1.587700746040e+05
RINT3679 nd943 nd961 1.587700746040e+05
RINT3680 nd944 nd962 1.587700746040e+05
RINT3681 nd945 nd963 1.587700746040e+05
RINT3682 nd946 nd964 1.587700746040e+05
RINT3683 nd947 nd965 1.587700746040e+05
RINT3684 nd948 nd966 1.339024725576e+04
RINT3685 nd949 nd967 1.778224835565e+04
RINT3686 nd950 nd968 2.963708059275e+01
RINT3687 nd951 nd969 2.963708059275e+01
RINT3688 nd952 nd970 2.963708059275e+01
RINT3689 nd953 nd971 2.963708059275e+01
RINT3690 nd954 nd972 6.814302480494e+01
RINT3691 nd955 nd973 1.116944683083e+04
RINT3692 nd956 nd974 1.344985312587e+02
RINT3693 nd957 nd975 1.054300361904e+06
RINT3694 nd958 nd976 1.757167269840e+05
RINT3695 nd959 nd977 3.012286748297e+05
RINT3696 nd960 nd978 3.012286748297e+05
RINT3697 nd961 nd979 3.012286748297e+05
RINT3698 nd962 nd980 3.012286748297e+05
RINT3699 nd963 nd981 3.012286748297e+05
RINT3700 nd964 nd982 3.012286748297e+05
RINT3701 nd965 nd983 3.012286748297e+05
RINT3702 nd966 nd984 2.540482799768e+04
RINT3703 nd967 nd985 3.373761158093e+04
RINT3704 nd968 nd986 5.622935263488e+01
RINT3705 nd969 nd987 5.622935263488e+01
RINT3706 nd970 nd988 5.622935263488e+01
RINT3707 nd971 nd989 5.622935263488e+01
RINT3708 nd972 nd990 3.591647226683e+01
RINT3709 nd973 nd991 5.887134134181e+03
RINT3710 nd974 nd992 7.089078862745e+01
RINT3711 nd975 nd993 5.556951693534e+05
RINT3712 nd976 nd994 9.261586155890e+04
RINT3713 nd977 nd995 1.587700483867e+05
RINT3714 nd978 nd996 1.587700483867e+05
RINT3715 nd979 nd997 1.587700483867e+05
RINT3716 nd980 nd998 1.587700483867e+05
RINT3717 nd981 nd999 1.587700483867e+05
RINT3718 nd982 nd1000 1.587700483867e+05
RINT3719 nd983 nd1001 1.587700483867e+05
RINT3720 nd984 nd1002 1.339024504466e+04
RINT3721 nd985 nd1003 1.778224541931e+04
RINT3722 nd986 nd1004 2.963707569885e+01
RINT3723 nd987 nd1005 2.963707569885e+01
RINT3724 nd988 nd1006 2.963707569885e+01
RINT3725 nd989 nd1007 2.963707569885e+01
RINT3726 nd990 nd1008 3.192734950032e+01
RINT3727 nd991 nd1009 5.233269783871e+03
RINT3728 nd992 nd1010 6.301718520814e+01
RINT3729 nd993 nd1011 4.939759605503e+05
RINT3730 nd994 nd1012 8.232932675838e+04
RINT3731 nd995 nd1013 1.411359887286e+05
RINT3732 nd996 nd1014 1.411359887286e+05
RINT3733 nd997 nd1015 1.411359887286e+05
RINT3734 nd998 nd1016 1.411359887286e+05
RINT3735 nd999 nd1017 1.411359887286e+05
RINT3736 nd1000 nd1018 1.411359887286e+05
RINT3737 nd1001 nd1019 1.411359887286e+05
RINT3738 nd1002 nd1020 1.190303519398e+04
RINT3739 nd1003 nd1021 1.580723073761e+04
RINT3740 nd1004 nd1022 2.634538456268e+01
RINT3741 nd1005 nd1023 2.634538456268e+01
RINT3742 nd1006 nd1024 2.634538456268e+01
RINT3743 nd1007 nd1025 2.634538456268e+01
RINT3744 nd1008 nd1026 6.016477927191e+01
RINT3745 nd1009 nd1027 9.861718130214e+03
RINT3746 nd1010 nd1028 1.187513244200e+02
RINT3747 nd1011 nd1029 9.308619442976e+05
RINT3748 nd1012 nd1030 1.551436573829e+05
RINT3749 nd1013 nd1031 2.659605555136e+05
RINT3750 nd1014 nd1032 2.659605555136e+05
RINT3751 nd1015 nd1033 2.659605555136e+05
RINT3752 nd1016 nd1034 2.659605555136e+05
RINT3753 nd1017 nd1035 2.659605555136e+05
RINT3754 nd1018 nd1036 2.659605555136e+05
RINT3755 nd1019 nd1037 2.659605555136e+05
RINT3756 nd1020 nd1038 2.243040829633e+04
RINT3757 nd1021 nd1039 2.978758221752e+04
RINT3758 nd1022 nd1040 4.964597036254e+01
RINT3759 nd1023 nd1041 4.964597036254e+01
RINT3760 nd1024 nd1042 4.964597036254e+01
RINT3761 nd1025 nd1043 4.964597036254e+01
RINT3762 nd1026 nd1044 3.806063516898e+01
RINT3763 nd1027 nd1045 6.238587765727e+03
RINT3764 nd1028 nd1046 7.512286904865e+01
RINT3765 nd1029 nd1047 5.888693897551e+05
RINT3766 nd1030 nd1048 9.814489829252e+04
RINT3767 nd1031 nd1049 1.682483970729e+05
RINT3768 nd1032 nd1050 1.682483970729e+05
RINT3769 nd1033 nd1051 1.682483970729e+05
RINT3770 nd1034 nd1052 1.682483970729e+05
RINT3771 nd1035 nd1053 1.682483970729e+05
RINT3772 nd1036 nd1054 1.682483970729e+05
RINT3773 nd1037 nd1055 1.682483970729e+05
RINT3774 nd1038 nd1056 1.418962384952e+04
RINT3775 nd1039 nd1057 1.884382047216e+04
RINT3776 nd1040 nd1058 3.140636745361e+01
RINT3777 nd1041 nd1059 3.140636745361e+01
RINT3778 nd1042 nd1060 3.140636745361e+01
RINT3779 nd1043 nd1061 3.140636745361e+01
RINT3780 nd1044 nd1062 8.180906973375e+00
RINT3781 nd1045 nd1063 1.340947305006e+03
RINT3782 nd1046 nd1064 1.614721353260e+01
RINT3783 nd1047 nd1065 3.241137758398e+05
RINT3784 nd1048 nd1066 5.401896263997e+04
RINT3785 nd1049 nd1067 9.260393595423e+04
RINT3786 nd1050 nd1068 9.260393595423e+04
RINT3787 nd1051 nd1069 9.260393595423e+04
RINT3788 nd1052 nd1070 9.260393595423e+04
RINT3789 nd1053 nd1071 9.260393595423e+04
RINT3790 nd1054 nd1072 9.260393595423e+04
RINT3791 nd1055 nd1073 9.260393595423e+04
RINT3792 nd1056 nd1074 7.809970502164e+03
RINT3793 nd1057 nd1075 4.050367042518e+03
RINT3794 nd1058 nd1076 6.750611737530e+00
RINT3795 nd1059 nd1077 6.750611737530e+00
RINT3796 nd1060 nd1078 6.750611737530e+00
RINT3797 nd1061 nd1079 6.750611737530e+00
RINT3798 nd1080 nd1098 4.370436416635e-01
RINT3799 nd1081 nd1099 7.163661625366e+01
RINT3800 nd1082 nd1100 8.626228152911e-01
RINT3801 nd1083 nd1101 1.731463289332e+04
RINT3802 nd1084 nd1102 2.885772148887e+03
RINT3803 nd1085 nd1103 4.947037969521e+03
RINT3804 nd1086 nd1104 4.947037969521e+03
RINT3805 nd1087 nd1105 4.947037969521e+03
RINT3806 nd1088 nd1106 4.947037969521e+03
RINT3807 nd1089 nd1107 4.947037969521e+03
RINT3808 nd1090 nd1108 4.947037969521e+03
RINT3809 nd1091 nd1109 4.947037969521e+03
RINT3810 nd1092 nd1110 4.172200697186e+02
RINT3811 nd1093 nd1111 2.163803069876e+02
RINT3812 nd1094 nd1112 3.606338449794e-01
RINT3813 nd1095 nd1113 3.606338449794e-01
RINT3814 nd1096 nd1114 3.606338449794e-01
RINT3815 nd1097 nd1115 3.606338449794e-01
RINT3816 nd1098 nd1116 2.033291750104e+00
RINT3817 nd1099 nd1117 3.332805398552e+02
RINT3818 nd1100 nd1118 4.013246473754e+00
RINT3819 nd1101 nd1119 7.093098293676e+03
RINT3820 nd1102 nd1120 1.162211264604e+03
RINT3821 nd1103 nd1121 1.992362167892e+03
RINT3822 nd1104 nd1122 1.992362167892e+03
RINT3823 nd1105 nd1123 1.992362167892e+03
RINT3824 nd1106 nd1124 1.992362167892e+03
RINT3825 nd1107 nd1125 1.992362167892e+03
RINT3826 nd1108 nd1126 1.992362167892e+03
RINT3827 nd1109 nd1127 1.992362167892e+03
RINT3828 nd1110 nd1128 1.680480727344e+02
RINT3829 nd1111 nd1129 1.006682745476e+03
RINT3830 nd1112 nd1130 1.677804575794e+00
RINT3831 nd1113 nd1131 1.677804575794e+00
RINT3832 nd1114 nd1132 1.677804575794e+00
RINT3833 nd1115 nd1133 1.677804575794e+00
RINT3834 nd1116 nd1134 3.214148917832e+00
RINT3835 nd1117 nd1135 5.268369807016e+02
RINT3836 nd1118 nd1136 6.343984728188e+00
RINT3837 nd1119 nd1137 9.974352831641e+02
RINT3838 nd1120 nd1138 1.262956451761e+02
RINT3839 nd1121 nd1139 2.165068203019e+02
RINT3840 nd1122 nd1140 2.165068203019e+02
RINT3841 nd1123 nd1141 2.165068203019e+02
RINT3842 nd1124 nd1142 2.165068203019e+02
RINT3843 nd1125 nd1143 2.165068203019e+02
RINT3844 nd1126 nd1144 2.165068203019e+02
RINT3845 nd1127 nd1145 2.165068203019e+02
RINT3846 nd1128 nd1146 1.829466825953e+01
RINT3847 nd1129 nd1147 1.591325129219e+03
RINT3848 nd1130 nd1148 2.652208548698e+00
RINT3849 nd1131 nd1149 2.652208548698e+00
RINT3850 nd1132 nd1150 2.652208548698e+00
RINT3851 nd1133 nd1151 2.652208548698e+00
RINT3852 nd1134 nd1152 1.705637021361e+00
RINT3853 nd1135 nd1153 2.795740587878e+02
RINT3854 nd1136 nd1154 3.366532009551e+00
RINT3855 nd1137 nd1155 5.293042073868e+02
RINT3856 nd1138 nd1156 6.702070549808e+01
RINT3857 nd1139 nd1157 1.148926379967e+02
RINT3858 nd1140 nd1158 1.148926379967e+02
RINT3859 nd1141 nd1159 1.148926379967e+02
RINT3860 nd1142 nd1160 1.148926379967e+02
RINT3861 nd1143 nd1161 1.148926379967e+02
RINT3862 nd1144 nd1162 1.148926379967e+02
RINT3863 nd1145 nd1163 1.148926379967e+02
RINT3864 nd1146 nd1164 9.708344035913e+00
RINT3865 nd1147 nd1165 8.444608892758e+02
RINT3866 nd1148 nd1166 1.407434815460e+00
RINT3867 nd1149 nd1167 1.407434815460e+00
RINT3868 nd1150 nd1168 1.407434815460e+00
RINT3869 nd1151 nd1169 1.407434815460e+00
RINT3870 nd1152 nd1170 1.918745666955e+00
RINT3871 nd1153 nd1171 3.145050835400e+02
RINT3872 nd1154 nd1172 3.787159064381e+00
RINT3873 nd1155 nd1173 5.954374475373e+02
RINT3874 nd1156 nd1174 7.539452219915e+01
RINT3875 nd1157 nd1175 1.292477523414e+02
RINT3876 nd1158 nd1176 1.292477523414e+02
RINT3877 nd1159 nd1177 1.292477523414e+02
RINT3878 nd1160 nd1178 1.292477523414e+02
RINT3879 nd1161 nd1179 1.292477523414e+02
RINT3880 nd1162 nd1180 1.292477523414e+02
RINT3881 nd1163 nd1181 1.292477523414e+02
RINT3882 nd1164 nd1182 1.092134071841e+01
RINT3883 nd1165 nd1183 9.499709797093e+02
RINT3884 nd1166 nd1184 1.583284966182e+00
RINT3885 nd1167 nd1185 1.583284966182e+00
RINT3886 nd1168 nd1186 1.583284966182e+00
RINT3887 nd1169 nd1187 1.583284966182e+00
RINT3888 nd1170 nd1188 3.640366209020e+00
RINT3889 nd1171 nd1189 5.966990302060e+02
RINT3890 nd1172 nd1190 7.185238837848e+00
RINT3891 nd1173 nd1191 1.129701763465e+03
RINT3892 nd1174 nd1192 1.430432785782e+02
RINT3893 nd1175 nd1193 2.452170489913e+02
RINT3894 nd1176 nd1194 2.452170489913e+02
RINT3895 nd1177 nd1195 2.452170489913e+02
RINT3896 nd1178 nd1196 2.452170489913e+02
RINT3897 nd1179 nd1197 2.452170489913e+02
RINT3898 nd1180 nd1198 2.452170489913e+02
RINT3899 nd1181 nd1199 2.452170489913e+02
RINT3900 nd1182 nd1200 2.072066162452e+01
RINT3901 nd1183 nd1201 1.802345310086e+03
RINT3902 nd1184 nd1202 3.003908850143e+00
RINT3903 nd1185 nd1203 3.003908850143e+00
RINT3904 nd1186 nd1204 3.003908850143e+00
RINT3905 nd1187 nd1205 3.003908850143e+00
RINT3906 nd1188 nd1206 1.918745350117e+00
RINT3907 nd1189 nd1207 3.145050316065e+02
RINT3908 nd1190 nd1208 3.787158439016e+00
RINT3909 nd1191 nd1209 5.954373492142e+02
RINT3910 nd1192 nd1210 7.539450974944e+01
RINT3911 nd1193 nd1211 1.292477309990e+02
RINT3912 nd1194 nd1212 1.292477309990e+02
RINT3913 nd1195 nd1213 1.292477309990e+02
RINT3914 nd1196 nd1214 1.292477309990e+02
RINT3915 nd1197 nd1215 1.292477309990e+02
RINT3916 nd1198 nd1216 1.292477309990e+02
RINT3917 nd1199 nd1217 1.292477309990e+02
RINT3918 nd1200 nd1218 1.092133891499e+01
RINT3919 nd1201 nd1219 9.499708228429e+02
RINT3920 nd1202 nd1220 1.583284704738e+00
RINT3921 nd1203 nd1221 1.583284704738e+00
RINT3922 nd1204 nd1222 1.583284704738e+00
RINT3923 nd1205 nd1223 1.583284704738e+00
RINT3924 nd1206 nd1224 1.705636704523e+00
RINT3925 nd1207 nd1225 2.795740068543e+02
RINT3926 nd1208 nd1226 3.366531384187e+00
RINT3927 nd1209 nd1227 5.293041090636e+02
RINT3928 nd1210 nd1228 6.702069304836e+01
RINT3929 nd1211 nd1229 1.148926166543e+02
RINT3930 nd1212 nd1230 1.148926166543e+02
RINT3931 nd1213 nd1231 1.148926166543e+02
RINT3932 nd1214 nd1232 1.148926166543e+02
RINT3933 nd1215 nd1233 1.148926166543e+02
RINT3934 nd1216 nd1234 1.148926166543e+02
RINT3935 nd1217 nd1235 1.148926166543e+02
RINT3936 nd1218 nd1236 9.708342232498e+00
RINT3937 nd1219 nd1237 8.444607324094e+02
RINT3938 nd1220 nd1238 1.407434554016e+00
RINT3939 nd1221 nd1239 1.407434554016e+00
RINT3940 nd1222 nd1240 1.407434554016e+00
RINT3941 nd1223 nd1241 1.407434554016e+00
RINT3942 nd1224 nd1242 3.214148917832e+00
RINT3943 nd1225 nd1243 5.268369807016e+02
RINT3944 nd1226 nd1244 6.343984728188e+00
RINT3945 nd1227 nd1245 9.974352831641e+02
RINT3946 nd1228 nd1246 1.262956451761e+02
RINT3947 nd1229 nd1247 2.165068203019e+02
RINT3948 nd1230 nd1248 2.165068203019e+02
RINT3949 nd1231 nd1249 2.165068203019e+02
RINT3950 nd1232 nd1250 2.165068203019e+02
RINT3951 nd1233 nd1251 2.165068203019e+02
RINT3952 nd1234 nd1252 2.165068203019e+02
RINT3953 nd1235 nd1253 2.165068203019e+02
RINT3954 nd1236 nd1254 1.829466825953e+01
RINT3955 nd1237 nd1255 1.591325129219e+03
RINT3956 nd1238 nd1256 2.652208548698e+00
RINT3957 nd1239 nd1257 2.652208548698e+00
RINT3958 nd1240 nd1258 2.652208548698e+00
RINT3959 nd1241 nd1259 2.652208548698e+00
RINT3960 nd1242 nd1260 2.033291750104e+00
RINT3961 nd1243 nd1261 3.332805398552e+02
RINT3962 nd1244 nd1262 4.013246473754e+00
RINT3963 nd1245 nd1263 7.093098293676e+03
RINT3964 nd1246 nd1264 1.162211264604e+03
RINT3965 nd1247 nd1265 1.992362167892e+03
RINT3966 nd1248 nd1266 1.992362167892e+03
RINT3967 nd1249 nd1267 1.992362167892e+03
RINT3968 nd1250 nd1268 1.992362167892e+03
RINT3969 nd1251 nd1269 1.992362167892e+03
RINT3970 nd1252 nd1270 1.992362167892e+03
RINT3971 nd1253 nd1271 1.992362167892e+03
RINT3972 nd1254 nd1272 1.680480727344e+02
RINT3973 nd1255 nd1273 1.006682745476e+03
RINT3974 nd1256 nd1274 1.677804575794e+00
RINT3975 nd1257 nd1275 1.677804575794e+00
RINT3976 nd1258 nd1276 1.677804575794e+00
RINT3977 nd1259 nd1277 1.677804575794e+00
RINT3978 nd1260 nd1278 4.370439585014e-01
RINT3979 nd1261 nd1279 7.163666818713e+01
RINT3980 nd1262 nd1280 8.626234406556e-01
RINT3981 nd1263 nd1281 1.731494662620e+04
RINT3982 nd1264 nd1282 2.885824437699e+03
RINT3983 nd1265 nd1283 4.947127607484e+03
RINT3984 nd1266 nd1284 4.947127607484e+03
RINT3985 nd1267 nd1285 4.947127607484e+03
RINT3986 nd1268 nd1286 4.947127607484e+03
RINT3987 nd1269 nd1287 4.947127607484e+03
RINT3988 nd1270 nd1288 4.947127607484e+03
RINT3989 nd1271 nd1289 4.947127607484e+03
RINT3990 nd1272 nd1290 4.172276295469e+02
RINT3991 nd1273 nd1291 2.163804638541e+02
RINT3992 nd1274 nd1292 3.606341064234e-01
RINT3993 nd1275 nd1293 3.606341064234e-01
RINT3994 nd1276 nd1294 3.606341064234e-01
RINT3995 nd1277 nd1295 3.606341064234e-01
RINT3996 nd1296 nd1314 4.370436416635e-01
RINT3997 nd1297 nd1315 7.163661625366e+01
RINT3998 nd1298 nd1316 8.626228152911e-01
RINT3999 nd1299 nd1317 1.731463289332e+04
RINT4000 nd1300 nd1318 2.885772148887e+03
RINT4001 nd1301 nd1319 4.947037969521e+03
RINT4002 nd1302 nd1320 4.947037969521e+03
RINT4003 nd1303 nd1321 4.947037969521e+03
RINT4004 nd1304 nd1322 4.947037969521e+03
RINT4005 nd1305 nd1323 4.947037969521e+03
RINT4006 nd1306 nd1324 4.947037969521e+03
RINT4007 nd1307 nd1325 4.947037969521e+03
RINT4008 nd1308 nd1326 4.172200697186e+02
RINT4009 nd1309 nd1327 2.163803069876e+02
RINT4010 nd1310 nd1328 3.606338449794e-01
RINT4011 nd1311 nd1329 3.606338449794e-01
RINT4012 nd1312 nd1330 3.606338449794e-01
RINT4013 nd1313 nd1331 3.606338449794e-01
RINT4014 nd1314 nd1332 2.033291750104e+00
RINT4015 nd1315 nd1333 3.332805398552e+02
RINT4016 nd1316 nd1334 4.013246473754e+00
RINT4017 nd1317 nd1335 7.093098293676e+03
RINT4018 nd1318 nd1336 1.162211264604e+03
RINT4019 nd1319 nd1337 1.992362167892e+03
RINT4020 nd1320 nd1338 1.992362167892e+03
RINT4021 nd1321 nd1339 1.992362167892e+03
RINT4022 nd1322 nd1340 1.992362167892e+03
RINT4023 nd1323 nd1341 1.992362167892e+03
RINT4024 nd1324 nd1342 1.992362167892e+03
RINT4025 nd1325 nd1343 1.992362167892e+03
RINT4026 nd1326 nd1344 1.680480727344e+02
RINT4027 nd1327 nd1345 1.006682745476e+03
RINT4028 nd1328 nd1346 1.677804575794e+00
RINT4029 nd1329 nd1347 1.677804575794e+00
RINT4030 nd1330 nd1348 1.677804575794e+00
RINT4031 nd1331 nd1349 1.677804575794e+00
RINT4032 nd1332 nd1350 3.214148917832e+00
RINT4033 nd1333 nd1351 5.268369807016e+02
RINT4034 nd1334 nd1352 6.343984728188e+00
RINT4035 nd1335 nd1353 9.974352831641e+02
RINT4036 nd1336 nd1354 1.262956451761e+02
RINT4037 nd1337 nd1355 2.165068203019e+02
RINT4038 nd1338 nd1356 2.165068203019e+02
RINT4039 nd1339 nd1357 2.165068203019e+02
RINT4040 nd1340 nd1358 2.165068203019e+02
RINT4041 nd1341 nd1359 2.165068203019e+02
RINT4042 nd1342 nd1360 2.165068203019e+02
RINT4043 nd1343 nd1361 2.165068203019e+02
RINT4044 nd1344 nd1362 1.829466825953e+01
RINT4045 nd1345 nd1363 1.591325129219e+03
RINT4046 nd1346 nd1364 2.652208548698e+00
RINT4047 nd1347 nd1365 2.652208548698e+00
RINT4048 nd1348 nd1366 2.652208548698e+00
RINT4049 nd1349 nd1367 2.652208548698e+00
RINT4050 nd1350 nd1368 1.705637021361e+00
RINT4051 nd1351 nd1369 2.795740587878e+02
RINT4052 nd1352 nd1370 3.366532009551e+00
RINT4053 nd1353 nd1371 5.293042073868e+02
RINT4054 nd1354 nd1372 6.702070549808e+01
RINT4055 nd1355 nd1373 1.148926379967e+02
RINT4056 nd1356 nd1374 1.148926379967e+02
RINT4057 nd1357 nd1375 1.148926379967e+02
RINT4058 nd1358 nd1376 1.148926379967e+02
RINT4059 nd1359 nd1377 1.148926379967e+02
RINT4060 nd1360 nd1378 1.148926379967e+02
RINT4061 nd1361 nd1379 1.148926379967e+02
RINT4062 nd1362 nd1380 9.708344035913e+00
RINT4063 nd1363 nd1381 8.444608892758e+02
RINT4064 nd1364 nd1382 1.407434815460e+00
RINT4065 nd1365 nd1383 1.407434815460e+00
RINT4066 nd1366 nd1384 1.407434815460e+00
RINT4067 nd1367 nd1385 1.407434815460e+00
RINT4068 nd1368 nd1386 1.918745666955e+00
RINT4069 nd1369 nd1387 3.145050835400e+02
RINT4070 nd1370 nd1388 3.787159064381e+00
RINT4071 nd1371 nd1389 5.954374475373e+02
RINT4072 nd1372 nd1390 7.539452219915e+01
RINT4073 nd1373 nd1391 1.292477523414e+02
RINT4074 nd1374 nd1392 1.292477523414e+02
RINT4075 nd1375 nd1393 1.292477523414e+02
RINT4076 nd1376 nd1394 1.292477523414e+02
RINT4077 nd1377 nd1395 1.292477523414e+02
RINT4078 nd1378 nd1396 1.292477523414e+02
RINT4079 nd1379 nd1397 1.292477523414e+02
RINT4080 nd1380 nd1398 1.092134071841e+01
RINT4081 nd1381 nd1399 9.499709797093e+02
RINT4082 nd1382 nd1400 1.583284966182e+00
RINT4083 nd1383 nd1401 1.583284966182e+00
RINT4084 nd1384 nd1402 1.583284966182e+00
RINT4085 nd1385 nd1403 1.583284966182e+00
RINT4086 nd1386 nd1404 3.640366209020e+00
RINT4087 nd1387 nd1405 5.966990302060e+02
RINT4088 nd1388 nd1406 7.185238837848e+00
RINT4089 nd1389 nd1407 1.129701763465e+03
RINT4090 nd1390 nd1408 1.430432785782e+02
RINT4091 nd1391 nd1409 2.452170489913e+02
RINT4092 nd1392 nd1410 2.452170489913e+02
RINT4093 nd1393 nd1411 2.452170489913e+02
RINT4094 nd1394 nd1412 2.452170489913e+02
RINT4095 nd1395 nd1413 2.452170489913e+02
RINT4096 nd1396 nd1414 2.452170489913e+02
RINT4097 nd1397 nd1415 2.452170489913e+02
RINT4098 nd1398 nd1416 2.072066162452e+01
RINT4099 nd1399 nd1417 1.802345310086e+03
RINT4100 nd1400 nd1418 3.003908850143e+00
RINT4101 nd1401 nd1419 3.003908850143e+00
RINT4102 nd1402 nd1420 3.003908850143e+00
RINT4103 nd1403 nd1421 3.003908850143e+00
RINT4104 nd1404 nd1422 1.918745350117e+00
RINT4105 nd1405 nd1423 3.145050316065e+02
RINT4106 nd1406 nd1424 3.787158439016e+00
RINT4107 nd1407 nd1425 5.954373492142e+02
RINT4108 nd1408 nd1426 7.539450974944e+01
RINT4109 nd1409 nd1427 1.292477309990e+02
RINT4110 nd1410 nd1428 1.292477309990e+02
RINT4111 nd1411 nd1429 1.292477309990e+02
RINT4112 nd1412 nd1430 1.292477309990e+02
RINT4113 nd1413 nd1431 1.292477309990e+02
RINT4114 nd1414 nd1432 1.292477309990e+02
RINT4115 nd1415 nd1433 1.292477309990e+02
RINT4116 nd1416 nd1434 1.092133891499e+01
RINT4117 nd1417 nd1435 9.499708228429e+02
RINT4118 nd1418 nd1436 1.583284704738e+00
RINT4119 nd1419 nd1437 1.583284704738e+00
RINT4120 nd1420 nd1438 1.583284704738e+00
RINT4121 nd1421 nd1439 1.583284704738e+00
RINT4122 nd1422 nd1440 1.705636704523e+00
RINT4123 nd1423 nd1441 2.795740068543e+02
RINT4124 nd1424 nd1442 3.366531384187e+00
RINT4125 nd1425 nd1443 5.293041090636e+02
RINT4126 nd1426 nd1444 6.702069304836e+01
RINT4127 nd1427 nd1445 1.148926166543e+02
RINT4128 nd1428 nd1446 1.148926166543e+02
RINT4129 nd1429 nd1447 1.148926166543e+02
RINT4130 nd1430 nd1448 1.148926166543e+02
RINT4131 nd1431 nd1449 1.148926166543e+02
RINT4132 nd1432 nd1450 1.148926166543e+02
RINT4133 nd1433 nd1451 1.148926166543e+02
RINT4134 nd1434 nd1452 9.708342232498e+00
RINT4135 nd1435 nd1453 8.444607324094e+02
RINT4136 nd1436 nd1454 1.407434554016e+00
RINT4137 nd1437 nd1455 1.407434554016e+00
RINT4138 nd1438 nd1456 1.407434554016e+00
RINT4139 nd1439 nd1457 1.407434554016e+00
RINT4140 nd1440 nd1458 3.214148917832e+00
RINT4141 nd1441 nd1459 5.268369807016e+02
RINT4142 nd1442 nd1460 6.343984728188e+00
RINT4143 nd1443 nd1461 9.974352831641e+02
RINT4144 nd1444 nd1462 1.262956451761e+02
RINT4145 nd1445 nd1463 2.165068203019e+02
RINT4146 nd1446 nd1464 2.165068203019e+02
RINT4147 nd1447 nd1465 2.165068203019e+02
RINT4148 nd1448 nd1466 2.165068203019e+02
RINT4149 nd1449 nd1467 2.165068203019e+02
RINT4150 nd1450 nd1468 2.165068203019e+02
RINT4151 nd1451 nd1469 2.165068203019e+02
RINT4152 nd1452 nd1470 1.829466825953e+01
RINT4153 nd1453 nd1471 1.591325129219e+03
RINT4154 nd1454 nd1472 2.652208548698e+00
RINT4155 nd1455 nd1473 2.652208548698e+00
RINT4156 nd1456 nd1474 2.652208548698e+00
RINT4157 nd1457 nd1475 2.652208548698e+00
RINT4158 nd1458 nd1476 2.033291750104e+00
RINT4159 nd1459 nd1477 3.332805398552e+02
RINT4160 nd1460 nd1478 4.013246473754e+00
RINT4161 nd1461 nd1479 7.093098293676e+03
RINT4162 nd1462 nd1480 1.162211264604e+03
RINT4163 nd1463 nd1481 1.992362167892e+03
RINT4164 nd1464 nd1482 1.992362167892e+03
RINT4165 nd1465 nd1483 1.992362167892e+03
RINT4166 nd1466 nd1484 1.992362167892e+03
RINT4167 nd1467 nd1485 1.992362167892e+03
RINT4168 nd1468 nd1486 1.992362167892e+03
RINT4169 nd1469 nd1487 1.992362167892e+03
RINT4170 nd1470 nd1488 1.680480727344e+02
RINT4171 nd1471 nd1489 1.006682745476e+03
RINT4172 nd1472 nd1490 1.677804575794e+00
RINT4173 nd1473 nd1491 1.677804575794e+00
RINT4174 nd1474 nd1492 1.677804575794e+00
RINT4175 nd1475 nd1493 1.677804575794e+00
RINT4176 nd1476 nd1494 4.370439585014e-01
RINT4177 nd1477 nd1495 7.163666818713e+01
RINT4178 nd1478 nd1496 8.626234406556e-01
RINT4179 nd1479 nd1497 1.731494662620e+04
RINT4180 nd1480 nd1498 2.885824437699e+03
RINT4181 nd1481 nd1499 4.947127607484e+03
RINT4182 nd1482 nd1500 4.947127607484e+03
RINT4183 nd1483 nd1501 4.947127607484e+03
RINT4184 nd1484 nd1502 4.947127607484e+03
RINT4185 nd1485 nd1503 4.947127607484e+03
RINT4186 nd1486 nd1504 4.947127607484e+03
RINT4187 nd1487 nd1505 4.947127607484e+03
RINT4188 nd1488 nd1506 4.172276295469e+02
RINT4189 nd1489 nd1507 2.163804638541e+02
RINT4190 nd1490 nd1508 3.606341064234e-01
RINT4191 nd1491 nd1509 3.606341064234e-01
RINT4192 nd1492 nd1510 3.606341064234e-01
RINT4193 nd1493 nd1511 3.606341064234e-01
RINT4194 nd1512 nd1530 4.370436416635e-01
RINT4195 nd1513 nd1531 7.163661625366e+01
RINT4196 nd1514 nd1532 8.626228152911e-01
RINT4197 nd1515 nd1533 1.731463289332e+04
RINT4198 nd1516 nd1534 2.885772148887e+03
RINT4199 nd1517 nd1535 4.947037969521e+03
RINT4200 nd1518 nd1536 4.947037969521e+03
RINT4201 nd1519 nd1537 4.947037969521e+03
RINT4202 nd1520 nd1538 4.947037969521e+03
RINT4203 nd1521 nd1539 4.947037969521e+03
RINT4204 nd1522 nd1540 4.947037969521e+03
RINT4205 nd1523 nd1541 4.947037969521e+03
RINT4206 nd1524 nd1542 4.172200697186e+02
RINT4207 nd1525 nd1543 2.163803069876e+02
RINT4208 nd1526 nd1544 3.606338449794e-01
RINT4209 nd1527 nd1545 3.606338449794e-01
RINT4210 nd1528 nd1546 3.606338449794e-01
RINT4211 nd1529 nd1547 3.606338449794e-01
RINT4212 nd1530 nd1548 2.033291750104e+00
RINT4213 nd1531 nd1549 3.332805398552e+02
RINT4214 nd1532 nd1550 4.013246473754e+00
RINT4215 nd1533 nd1551 7.093098293676e+03
RINT4216 nd1534 nd1552 1.162211264604e+03
RINT4217 nd1535 nd1553 1.992362167892e+03
RINT4218 nd1536 nd1554 1.992362167892e+03
RINT4219 nd1537 nd1555 1.992362167892e+03
RINT4220 nd1538 nd1556 1.992362167892e+03
RINT4221 nd1539 nd1557 1.992362167892e+03
RINT4222 nd1540 nd1558 1.992362167892e+03
RINT4223 nd1541 nd1559 1.992362167892e+03
RINT4224 nd1542 nd1560 1.680480727344e+02
RINT4225 nd1543 nd1561 1.006682745476e+03
RINT4226 nd1544 nd1562 1.677804575794e+00
RINT4227 nd1545 nd1563 1.677804575794e+00
RINT4228 nd1546 nd1564 1.677804575794e+00
RINT4229 nd1547 nd1565 1.677804575794e+00
RINT4230 nd1548 nd1566 3.214148917832e+00
RINT4231 nd1549 nd1567 5.268369807016e+02
RINT4232 nd1550 nd1568 6.343984728188e+00
RINT4233 nd1551 nd1569 9.974352831641e+02
RINT4234 nd1552 nd1570 1.262956451761e+02
RINT4235 nd1553 nd1571 2.165068203019e+02
RINT4236 nd1554 nd1572 2.165068203019e+02
RINT4237 nd1555 nd1573 2.165068203019e+02
RINT4238 nd1556 nd1574 2.165068203019e+02
RINT4239 nd1557 nd1575 2.165068203019e+02
RINT4240 nd1558 nd1576 2.165068203019e+02
RINT4241 nd1559 nd1577 2.165068203019e+02
RINT4242 nd1560 nd1578 1.829466825953e+01
RINT4243 nd1561 nd1579 1.591325129219e+03
RINT4244 nd1562 nd1580 2.652208548698e+00
RINT4245 nd1563 nd1581 2.652208548698e+00
RINT4246 nd1564 nd1582 2.652208548698e+00
RINT4247 nd1565 nd1583 2.652208548698e+00
RINT4248 nd1566 nd1584 1.705637021361e+00
RINT4249 nd1567 nd1585 2.795740587878e+02
RINT4250 nd1568 nd1586 3.366532009551e+00
RINT4251 nd1569 nd1587 5.293042073868e+02
RINT4252 nd1570 nd1588 6.702070549808e+01
RINT4253 nd1571 nd1589 1.148926379967e+02
RINT4254 nd1572 nd1590 1.148926379967e+02
RINT4255 nd1573 nd1591 1.148926379967e+02
RINT4256 nd1574 nd1592 1.148926379967e+02
RINT4257 nd1575 nd1593 1.148926379967e+02
RINT4258 nd1576 nd1594 1.148926379967e+02
RINT4259 nd1577 nd1595 1.148926379967e+02
RINT4260 nd1578 nd1596 9.708344035913e+00
RINT4261 nd1579 nd1597 8.444608892758e+02
RINT4262 nd1580 nd1598 1.407434815460e+00
RINT4263 nd1581 nd1599 1.407434815460e+00
RINT4264 nd1582 nd1600 1.407434815460e+00
RINT4265 nd1583 nd1601 1.407434815460e+00
RINT4266 nd1584 nd1602 1.918745666955e+00
RINT4267 nd1585 nd1603 3.145050835400e+02
RINT4268 nd1586 nd1604 3.787159064381e+00
RINT4269 nd1587 nd1605 5.954374475373e+02
RINT4270 nd1588 nd1606 7.539452219915e+01
RINT4271 nd1589 nd1607 1.292477523414e+02
RINT4272 nd1590 nd1608 1.292477523414e+02
RINT4273 nd1591 nd1609 1.292477523414e+02
RINT4274 nd1592 nd1610 1.292477523414e+02
RINT4275 nd1593 nd1611 1.292477523414e+02
RINT4276 nd1594 nd1612 1.292477523414e+02
RINT4277 nd1595 nd1613 1.292477523414e+02
RINT4278 nd1596 nd1614 1.092134071841e+01
RINT4279 nd1597 nd1615 9.499709797093e+02
RINT4280 nd1598 nd1616 1.583284966182e+00
RINT4281 nd1599 nd1617 1.583284966182e+00
RINT4282 nd1600 nd1618 1.583284966182e+00
RINT4283 nd1601 nd1619 1.583284966182e+00
RINT4284 nd1602 nd1620 3.640366209020e+00
RINT4285 nd1603 nd1621 5.966990302060e+02
RINT4286 nd1604 nd1622 7.185238837848e+00
RINT4287 nd1605 nd1623 1.129701763465e+03
RINT4288 nd1606 nd1624 1.430432785782e+02
RINT4289 nd1607 nd1625 2.452170489913e+02
RINT4290 nd1608 nd1626 2.452170489913e+02
RINT4291 nd1609 nd1627 2.452170489913e+02
RINT4292 nd1610 nd1628 2.452170489913e+02
RINT4293 nd1611 nd1629 2.452170489913e+02
RINT4294 nd1612 nd1630 2.452170489913e+02
RINT4295 nd1613 nd1631 2.452170489913e+02
RINT4296 nd1614 nd1632 2.072066162452e+01
RINT4297 nd1615 nd1633 1.802345310086e+03
RINT4298 nd1616 nd1634 3.003908850143e+00
RINT4299 nd1617 nd1635 3.003908850143e+00
RINT4300 nd1618 nd1636 3.003908850143e+00
RINT4301 nd1619 nd1637 3.003908850143e+00
RINT4302 nd1620 nd1638 1.918745350117e+00
RINT4303 nd1621 nd1639 3.145050316065e+02
RINT4304 nd1622 nd1640 3.787158439016e+00
RINT4305 nd1623 nd1641 5.954373492142e+02
RINT4306 nd1624 nd1642 7.539450974944e+01
RINT4307 nd1625 nd1643 1.292477309990e+02
RINT4308 nd1626 nd1644 1.292477309990e+02
RINT4309 nd1627 nd1645 1.292477309990e+02
RINT4310 nd1628 nd1646 1.292477309990e+02
RINT4311 nd1629 nd1647 1.292477309990e+02
RINT4312 nd1630 nd1648 1.292477309990e+02
RINT4313 nd1631 nd1649 1.292477309990e+02
RINT4314 nd1632 nd1650 1.092133891499e+01
RINT4315 nd1633 nd1651 9.499708228429e+02
RINT4316 nd1634 nd1652 1.583284704738e+00
RINT4317 nd1635 nd1653 1.583284704738e+00
RINT4318 nd1636 nd1654 1.583284704738e+00
RINT4319 nd1637 nd1655 1.583284704738e+00
RINT4320 nd1638 nd1656 1.705636704523e+00
RINT4321 nd1639 nd1657 2.795740068543e+02
RINT4322 nd1640 nd1658 3.366531384187e+00
RINT4323 nd1641 nd1659 5.293041090636e+02
RINT4324 nd1642 nd1660 6.702069304836e+01
RINT4325 nd1643 nd1661 1.148926166543e+02
RINT4326 nd1644 nd1662 1.148926166543e+02
RINT4327 nd1645 nd1663 1.148926166543e+02
RINT4328 nd1646 nd1664 1.148926166543e+02
RINT4329 nd1647 nd1665 1.148926166543e+02
RINT4330 nd1648 nd1666 1.148926166543e+02
RINT4331 nd1649 nd1667 1.148926166543e+02
RINT4332 nd1650 nd1668 9.708342232498e+00
RINT4333 nd1651 nd1669 8.444607324094e+02
RINT4334 nd1652 nd1670 1.407434554016e+00
RINT4335 nd1653 nd1671 1.407434554016e+00
RINT4336 nd1654 nd1672 1.407434554016e+00
RINT4337 nd1655 nd1673 1.407434554016e+00
RINT4338 nd1656 nd1674 3.214148917832e+00
RINT4339 nd1657 nd1675 5.268369807016e+02
RINT4340 nd1658 nd1676 6.343984728188e+00
RINT4341 nd1659 nd1677 9.974352831641e+02
RINT4342 nd1660 nd1678 1.262956451761e+02
RINT4343 nd1661 nd1679 2.165068203019e+02
RINT4344 nd1662 nd1680 2.165068203019e+02
RINT4345 nd1663 nd1681 2.165068203019e+02
RINT4346 nd1664 nd1682 2.165068203019e+02
RINT4347 nd1665 nd1683 2.165068203019e+02
RINT4348 nd1666 nd1684 2.165068203019e+02
RINT4349 nd1667 nd1685 2.165068203019e+02
RINT4350 nd1668 nd1686 1.829466825953e+01
RINT4351 nd1669 nd1687 1.591325129219e+03
RINT4352 nd1670 nd1688 2.652208548698e+00
RINT4353 nd1671 nd1689 2.652208548698e+00
RINT4354 nd1672 nd1690 2.652208548698e+00
RINT4355 nd1673 nd1691 2.652208548698e+00
RINT4356 nd1674 nd1692 2.033291750104e+00
RINT4357 nd1675 nd1693 3.332805398552e+02
RINT4358 nd1676 nd1694 4.013246473754e+00
RINT4359 nd1677 nd1695 7.093098293676e+03
RINT4360 nd1678 nd1696 1.162211264604e+03
RINT4361 nd1679 nd1697 1.992362167892e+03
RINT4362 nd1680 nd1698 1.992362167892e+03
RINT4363 nd1681 nd1699 1.992362167892e+03
RINT4364 nd1682 nd1700 1.992362167892e+03
RINT4365 nd1683 nd1701 1.992362167892e+03
RINT4366 nd1684 nd1702 1.992362167892e+03
RINT4367 nd1685 nd1703 1.992362167892e+03
RINT4368 nd1686 nd1704 1.680480727344e+02
RINT4369 nd1687 nd1705 1.006682745476e+03
RINT4370 nd1688 nd1706 1.677804575794e+00
RINT4371 nd1689 nd1707 1.677804575794e+00
RINT4372 nd1690 nd1708 1.677804575794e+00
RINT4373 nd1691 nd1709 1.677804575794e+00
RINT4374 nd1692 nd1710 4.370439585014e-01
RINT4375 nd1693 nd1711 7.163666818713e+01
RINT4376 nd1694 nd1712 8.626234406556e-01
RINT4377 nd1695 nd1713 1.731494662620e+04
RINT4378 nd1696 nd1714 2.885824437699e+03
RINT4379 nd1697 nd1715 4.947127607484e+03
RINT4380 nd1698 nd1716 4.947127607484e+03
RINT4381 nd1699 nd1717 4.947127607484e+03
RINT4382 nd1700 nd1718 4.947127607484e+03
RINT4383 nd1701 nd1719 4.947127607484e+03
RINT4384 nd1702 nd1720 4.947127607484e+03
RINT4385 nd1703 nd1721 4.947127607484e+03
RINT4386 nd1704 nd1722 4.172276295469e+02
RINT4387 nd1705 nd1723 2.163804638541e+02
RINT4388 nd1706 nd1724 3.606341064234e-01
RINT4389 nd1707 nd1725 3.606341064234e-01
RINT4390 nd1708 nd1726 3.606341064234e-01
RINT4391 nd1709 nd1727 3.606341064234e-01
RINT4392 nd1728 nd1746 4.370436416635e-01
RINT4393 nd1729 nd1747 7.163661625366e+01
RINT4394 nd1730 nd1748 8.626228152911e-01
RINT4395 nd1731 nd1749 1.731463289332e+04
RINT4396 nd1732 nd1750 2.885772148887e+03
RINT4397 nd1733 nd1751 4.947037969521e+03
RINT4398 nd1734 nd1752 4.947037969521e+03
RINT4399 nd1735 nd1753 4.947037969521e+03
RINT4400 nd1736 nd1754 4.947037969521e+03
RINT4401 nd1737 nd1755 4.947037969521e+03
RINT4402 nd1738 nd1756 4.947037969521e+03
RINT4403 nd1739 nd1757 4.947037969521e+03
RINT4404 nd1740 nd1758 4.172200697186e+02
RINT4405 nd1741 nd1759 2.163803069876e+02
RINT4406 nd1742 nd1760 3.606338449794e-01
RINT4407 nd1743 nd1761 3.606338449794e-01
RINT4408 nd1744 nd1762 3.606338449794e-01
RINT4409 nd1745 nd1763 3.606338449794e-01
RINT4410 nd1746 nd1764 2.033291750104e+00
RINT4411 nd1747 nd1765 3.332805398552e+02
RINT4412 nd1748 nd1766 4.013246473754e+00
RINT4413 nd1749 nd1767 7.093098293676e+03
RINT4414 nd1750 nd1768 1.162211264604e+03
RINT4415 nd1751 nd1769 1.992362167892e+03
RINT4416 nd1752 nd1770 1.992362167892e+03
RINT4417 nd1753 nd1771 1.992362167892e+03
RINT4418 nd1754 nd1772 1.992362167892e+03
RINT4419 nd1755 nd1773 1.992362167892e+03
RINT4420 nd1756 nd1774 1.992362167892e+03
RINT4421 nd1757 nd1775 1.992362167892e+03
RINT4422 nd1758 nd1776 1.680480727344e+02
RINT4423 nd1759 nd1777 1.006682745476e+03
RINT4424 nd1760 nd1778 1.677804575794e+00
RINT4425 nd1761 nd1779 1.677804575794e+00
RINT4426 nd1762 nd1780 1.677804575794e+00
RINT4427 nd1763 nd1781 1.677804575794e+00
RINT4428 nd1764 nd1782 3.214148917832e+00
RINT4429 nd1765 nd1783 5.268369807016e+02
RINT4430 nd1766 nd1784 6.343984728188e+00
RINT4431 nd1767 nd1785 9.974352831641e+02
RINT4432 nd1768 nd1786 1.262956451761e+02
RINT4433 nd1769 nd1787 2.165068203019e+02
RINT4434 nd1770 nd1788 2.165068203019e+02
RINT4435 nd1771 nd1789 2.165068203019e+02
RINT4436 nd1772 nd1790 2.165068203019e+02
RINT4437 nd1773 nd1791 2.165068203019e+02
RINT4438 nd1774 nd1792 2.165068203019e+02
RINT4439 nd1775 nd1793 2.165068203019e+02
RINT4440 nd1776 nd1794 1.829466825953e+01
RINT4441 nd1777 nd1795 1.591325129219e+03
RINT4442 nd1778 nd1796 2.652208548698e+00
RINT4443 nd1779 nd1797 2.652208548698e+00
RINT4444 nd1780 nd1798 2.652208548698e+00
RINT4445 nd1781 nd1799 2.652208548698e+00
RINT4446 nd1782 nd1800 1.705637021361e+00
RINT4447 nd1783 nd1801 2.795740587878e+02
RINT4448 nd1784 nd1802 3.366532009551e+00
RINT4449 nd1785 nd1803 5.293042073868e+02
RINT4450 nd1786 nd1804 6.702070549808e+01
RINT4451 nd1787 nd1805 1.148926379967e+02
RINT4452 nd1788 nd1806 1.148926379967e+02
RINT4453 nd1789 nd1807 1.148926379967e+02
RINT4454 nd1790 nd1808 1.148926379967e+02
RINT4455 nd1791 nd1809 1.148926379967e+02
RINT4456 nd1792 nd1810 1.148926379967e+02
RINT4457 nd1793 nd1811 1.148926379967e+02
RINT4458 nd1794 nd1812 9.708344035913e+00
RINT4459 nd1795 nd1813 8.444608892758e+02
RINT4460 nd1796 nd1814 1.407434815460e+00
RINT4461 nd1797 nd1815 1.407434815460e+00
RINT4462 nd1798 nd1816 1.407434815460e+00
RINT4463 nd1799 nd1817 1.407434815460e+00
RINT4464 nd1800 nd1818 1.918745666955e+00
RINT4465 nd1801 nd1819 3.145050835400e+02
RINT4466 nd1802 nd1820 3.787159064381e+00
RINT4467 nd1803 nd1821 5.954374475373e+02
RINT4468 nd1804 nd1822 7.539452219915e+01
RINT4469 nd1805 nd1823 1.292477523414e+02
RINT4470 nd1806 nd1824 1.292477523414e+02
RINT4471 nd1807 nd1825 1.292477523414e+02
RINT4472 nd1808 nd1826 1.292477523414e+02
RINT4473 nd1809 nd1827 1.292477523414e+02
RINT4474 nd1810 nd1828 1.292477523414e+02
RINT4475 nd1811 nd1829 1.292477523414e+02
RINT4476 nd1812 nd1830 1.092134071841e+01
RINT4477 nd1813 nd1831 9.499709797093e+02
RINT4478 nd1814 nd1832 1.583284966182e+00
RINT4479 nd1815 nd1833 1.583284966182e+00
RINT4480 nd1816 nd1834 1.583284966182e+00
RINT4481 nd1817 nd1835 1.583284966182e+00
RINT4482 nd1818 nd1836 3.640366209020e+00
RINT4483 nd1819 nd1837 5.966990302060e+02
RINT4484 nd1820 nd1838 7.185238837848e+00
RINT4485 nd1821 nd1839 1.129701763465e+03
RINT4486 nd1822 nd1840 1.430432785782e+02
RINT4487 nd1823 nd1841 2.452170489913e+02
RINT4488 nd1824 nd1842 2.452170489913e+02
RINT4489 nd1825 nd1843 2.452170489913e+02
RINT4490 nd1826 nd1844 2.452170489913e+02
RINT4491 nd1827 nd1845 2.452170489913e+02
RINT4492 nd1828 nd1846 2.452170489913e+02
RINT4493 nd1829 nd1847 2.452170489913e+02
RINT4494 nd1830 nd1848 2.072066162452e+01
RINT4495 nd1831 nd1849 1.802345310086e+03
RINT4496 nd1832 nd1850 3.003908850143e+00
RINT4497 nd1833 nd1851 3.003908850143e+00
RINT4498 nd1834 nd1852 3.003908850143e+00
RINT4499 nd1835 nd1853 3.003908850143e+00
RINT4500 nd1836 nd1854 1.918745350117e+00
RINT4501 nd1837 nd1855 3.145050316065e+02
RINT4502 nd1838 nd1856 3.787158439016e+00
RINT4503 nd1839 nd1857 5.954373492142e+02
RINT4504 nd1840 nd1858 7.539450974944e+01
RINT4505 nd1841 nd1859 1.292477309990e+02
RINT4506 nd1842 nd1860 1.292477309990e+02
RINT4507 nd1843 nd1861 1.292477309990e+02
RINT4508 nd1844 nd1862 1.292477309990e+02
RINT4509 nd1845 nd1863 1.292477309990e+02
RINT4510 nd1846 nd1864 1.292477309990e+02
RINT4511 nd1847 nd1865 1.292477309990e+02
RINT4512 nd1848 nd1866 1.092133891499e+01
RINT4513 nd1849 nd1867 9.499708228429e+02
RINT4514 nd1850 nd1868 1.583284704738e+00
RINT4515 nd1851 nd1869 1.583284704738e+00
RINT4516 nd1852 nd1870 1.583284704738e+00
RINT4517 nd1853 nd1871 1.583284704738e+00
RINT4518 nd1854 nd1872 1.705636704523e+00
RINT4519 nd1855 nd1873 2.795740068543e+02
RINT4520 nd1856 nd1874 3.366531384187e+00
RINT4521 nd1857 nd1875 5.293041090636e+02
RINT4522 nd1858 nd1876 6.702069304836e+01
RINT4523 nd1859 nd1877 1.148926166543e+02
RINT4524 nd1860 nd1878 1.148926166543e+02
RINT4525 nd1861 nd1879 1.148926166543e+02
RINT4526 nd1862 nd1880 1.148926166543e+02
RINT4527 nd1863 nd1881 1.148926166543e+02
RINT4528 nd1864 nd1882 1.148926166543e+02
RINT4529 nd1865 nd1883 1.148926166543e+02
RINT4530 nd1866 nd1884 9.708342232498e+00
RINT4531 nd1867 nd1885 8.444607324094e+02
RINT4532 nd1868 nd1886 1.407434554016e+00
RINT4533 nd1869 nd1887 1.407434554016e+00
RINT4534 nd1870 nd1888 1.407434554016e+00
RINT4535 nd1871 nd1889 1.407434554016e+00
RINT4536 nd1872 nd1890 3.214148917832e+00
RINT4537 nd1873 nd1891 5.268369807016e+02
RINT4538 nd1874 nd1892 6.343984728188e+00
RINT4539 nd1875 nd1893 9.974352831641e+02
RINT4540 nd1876 nd1894 1.262956451761e+02
RINT4541 nd1877 nd1895 2.165068203019e+02
RINT4542 nd1878 nd1896 2.165068203019e+02
RINT4543 nd1879 nd1897 2.165068203019e+02
RINT4544 nd1880 nd1898 2.165068203019e+02
RINT4545 nd1881 nd1899 2.165068203019e+02
RINT4546 nd1882 nd1900 2.165068203019e+02
RINT4547 nd1883 nd1901 2.165068203019e+02
RINT4548 nd1884 nd1902 1.829466825953e+01
RINT4549 nd1885 nd1903 1.591325129219e+03
RINT4550 nd1886 nd1904 2.652208548698e+00
RINT4551 nd1887 nd1905 2.652208548698e+00
RINT4552 nd1888 nd1906 2.652208548698e+00
RINT4553 nd1889 nd1907 2.652208548698e+00
RINT4554 nd1890 nd1908 2.033291750104e+00
RINT4555 nd1891 nd1909 3.332805398552e+02
RINT4556 nd1892 nd1910 4.013246473754e+00
RINT4557 nd1893 nd1911 7.093098293676e+03
RINT4558 nd1894 nd1912 1.162211264604e+03
RINT4559 nd1895 nd1913 1.992362167892e+03
RINT4560 nd1896 nd1914 1.992362167892e+03
RINT4561 nd1897 nd1915 1.992362167892e+03
RINT4562 nd1898 nd1916 1.992362167892e+03
RINT4563 nd1899 nd1917 1.992362167892e+03
RINT4564 nd1900 nd1918 1.992362167892e+03
RINT4565 nd1901 nd1919 1.992362167892e+03
RINT4566 nd1902 nd1920 1.680480727344e+02
RINT4567 nd1903 nd1921 1.006682745476e+03
RINT4568 nd1904 nd1922 1.677804575794e+00
RINT4569 nd1905 nd1923 1.677804575794e+00
RINT4570 nd1906 nd1924 1.677804575794e+00
RINT4571 nd1907 nd1925 1.677804575794e+00
RINT4572 nd1908 nd1926 4.370439585014e-01
RINT4573 nd1909 nd1927 7.163666818713e+01
RINT4574 nd1910 nd1928 8.626234406556e-01
RINT4575 nd1911 nd1929 1.731494662620e+04
RINT4576 nd1912 nd1930 2.885824437699e+03
RINT4577 nd1913 nd1931 4.947127607484e+03
RINT4578 nd1914 nd1932 4.947127607484e+03
RINT4579 nd1915 nd1933 4.947127607484e+03
RINT4580 nd1916 nd1934 4.947127607484e+03
RINT4581 nd1917 nd1935 4.947127607484e+03
RINT4582 nd1918 nd1936 4.947127607484e+03
RINT4583 nd1919 nd1937 4.947127607484e+03
RINT4584 nd1920 nd1938 4.172276295469e+02
RINT4585 nd1921 nd1939 2.163804638541e+02
RINT4586 nd1922 nd1940 3.606341064234e-01
RINT4587 nd1923 nd1941 3.606341064234e-01
RINT4588 nd1924 nd1942 3.606341064234e-01
RINT4589 nd1925 nd1943 3.606341064234e-01
RINT4590 nd1944 nd1962 8.180901042573e+00
RINT4591 nd1945 nd1963 1.340946332877e+03
RINT4592 nd1946 nd1964 1.614720182658e+01
RINT4593 nd1947 nd1965 3.241079031595e+05
RINT4594 nd1948 nd1966 5.401798385992e+04
RINT4595 nd1949 nd1967 9.260225804557e+04
RINT4596 nd1950 nd1968 9.260225804557e+04
RINT4597 nd1951 nd1969 9.260225804557e+04
RINT4598 nd1952 nd1970 9.260225804557e+04
RINT4599 nd1953 nd1971 9.260225804557e+04
RINT4600 nd1954 nd1972 9.260225804557e+04
RINT4601 nd1955 nd1973 9.260225804557e+04
RINT4602 nd1956 nd1974 7.809828991795e+03
RINT4603 nd1957 nd1975 4.050364106178e+03
RINT4604 nd1958 nd1976 6.750606843630e+00
RINT4605 nd1959 nd1977 6.750606843630e+00
RINT4606 nd1960 nd1978 6.750606843630e+00
RINT4607 nd1961 nd1979 6.750606843630e+00
RINT4608 nd1962 nd1980 3.806063516898e+01
RINT4609 nd1963 nd1981 6.238587765727e+03
RINT4610 nd1964 nd1982 7.512286904865e+01
RINT4611 nd1965 nd1983 5.888693897551e+05
RINT4612 nd1966 nd1984 9.814489829252e+04
RINT4613 nd1967 nd1985 1.682483970729e+05
RINT4614 nd1968 nd1986 1.682483970729e+05
RINT4615 nd1969 nd1987 1.682483970729e+05
RINT4616 nd1970 nd1988 1.682483970729e+05
RINT4617 nd1971 nd1989 1.682483970729e+05
RINT4618 nd1972 nd1990 1.682483970729e+05
RINT4619 nd1973 nd1991 1.682483970729e+05
RINT4620 nd1974 nd1992 1.418962384952e+04
RINT4621 nd1975 nd1993 1.884382047216e+04
RINT4622 nd1976 nd1994 3.140636745361e+01
RINT4623 nd1977 nd1995 3.140636745361e+01
RINT4624 nd1978 nd1996 3.140636745361e+01
RINT4625 nd1979 nd1997 3.140636745361e+01
RINT4626 nd1980 nd1998 6.016477927191e+01
RINT4627 nd1981 nd1999 9.861718130214e+03
RINT4628 nd1982 nd2000 1.187513244200e+02
RINT4629 nd1983 nd2001 9.308619442976e+05
RINT4630 nd1984 nd2002 1.551436573829e+05
RINT4631 nd1985 nd2003 2.659605555136e+05
RINT4632 nd1986 nd2004 2.659605555136e+05
RINT4633 nd1987 nd2005 2.659605555136e+05
RINT4634 nd1988 nd2006 2.659605555136e+05
RINT4635 nd1989 nd2007 2.659605555136e+05
RINT4636 nd1990 nd2008 2.659605555136e+05
RINT4637 nd1991 nd2009 2.659605555136e+05
RINT4638 nd1992 nd2010 2.243040829633e+04
RINT4639 nd1993 nd2011 2.978758221752e+04
RINT4640 nd1994 nd2012 4.964597036254e+01
RINT4641 nd1995 nd2013 4.964597036254e+01
RINT4642 nd1996 nd2014 4.964597036254e+01
RINT4643 nd1997 nd2015 4.964597036254e+01
RINT4644 nd1998 nd2016 3.192735543112e+01
RINT4645 nd1999 nd2017 5.233270756000e+03
RINT4646 nd2000 nd2018 6.301719691416e+01
RINT4647 nd2001 nd2019 4.939760523109e+05
RINT4648 nd2002 nd2020 8.232934205182e+04
RINT4649 nd2003 nd2021 1.411360149460e+05
RINT4650 nd2004 nd2022 1.411360149460e+05
RINT4651 nd2005 nd2023 1.411360149460e+05
RINT4652 nd2006 nd2024 1.411360149460e+05
RINT4653 nd2007 nd2025 1.411360149460e+05
RINT4654 nd2008 nd2026 1.411360149460e+05
RINT4655 nd2009 nd2027 1.411360149460e+05
RINT4656 nd2010 nd2028 1.190303740508e+04
RINT4657 nd2011 nd2029 1.580723367395e+04
RINT4658 nd2012 nd2030 2.634538945658e+01
RINT4659 nd2013 nd2031 2.634538945658e+01
RINT4660 nd2014 nd2032 2.634538945658e+01
RINT4661 nd2015 nd2033 2.634538945658e+01
RINT4662 nd2016 nd2034 3.591647819764e+01
RINT4663 nd2017 nd2035 5.887135106310e+03
RINT4664 nd2018 nd2036 7.089080033348e+01
RINT4665 nd2019 nd2037 5.556952611141e+05
RINT4666 nd2020 nd2038 9.261587685234e+04
RINT4667 nd2021 nd2039 1.587700746040e+05
RINT4668 nd2022 nd2040 1.587700746040e+05
RINT4669 nd2023 nd2041 1.587700746040e+05
RINT4670 nd2024 nd2042 1.587700746040e+05
RINT4671 nd2025 nd2043 1.587700746040e+05
RINT4672 nd2026 nd2044 1.587700746040e+05
RINT4673 nd2027 nd2045 1.587700746040e+05
RINT4674 nd2028 nd2046 1.339024725576e+04
RINT4675 nd2029 nd2047 1.778224835565e+04
RINT4676 nd2030 nd2048 2.963708059275e+01
RINT4677 nd2031 nd2049 2.963708059275e+01
RINT4678 nd2032 nd2050 2.963708059275e+01
RINT4679 nd2033 nd2051 2.963708059275e+01
RINT4680 nd2034 nd2052 6.814302480494e+01
RINT4681 nd2035 nd2053 1.116944683083e+04
RINT4682 nd2036 nd2054 1.344985312587e+02
RINT4683 nd2037 nd2055 1.054300361904e+06
RINT4684 nd2038 nd2056 1.757167269840e+05
RINT4685 nd2039 nd2057 3.012286748297e+05
RINT4686 nd2040 nd2058 3.012286748297e+05
RINT4687 nd2041 nd2059 3.012286748297e+05
RINT4688 nd2042 nd2060 3.012286748297e+05
RINT4689 nd2043 nd2061 3.012286748297e+05
RINT4690 nd2044 nd2062 3.012286748297e+05
RINT4691 nd2045 nd2063 3.012286748297e+05
RINT4692 nd2046 nd2064 2.540482799769e+04
RINT4693 nd2047 nd2065 3.373761158093e+04
RINT4694 nd2048 nd2066 5.622935263488e+01
RINT4695 nd2049 nd2067 5.622935263488e+01
RINT4696 nd2050 nd2068 5.622935263488e+01
RINT4697 nd2051 nd2069 5.622935263488e+01
RINT4698 nd2052 nd2070 3.591647226683e+01
RINT4699 nd2053 nd2071 5.887134134181e+03
RINT4700 nd2054 nd2072 7.089078862745e+01
RINT4701 nd2055 nd2073 5.556951693534e+05
RINT4702 nd2056 nd2074 9.261586155890e+04
RINT4703 nd2057 nd2075 1.587700483867e+05
RINT4704 nd2058 nd2076 1.587700483867e+05
RINT4705 nd2059 nd2077 1.587700483867e+05
RINT4706 nd2060 nd2078 1.587700483867e+05
RINT4707 nd2061 nd2079 1.587700483867e+05
RINT4708 nd2062 nd2080 1.587700483867e+05
RINT4709 nd2063 nd2081 1.587700483867e+05
RINT4710 nd2064 nd2082 1.339024504466e+04
RINT4711 nd2065 nd2083 1.778224541931e+04
RINT4712 nd2066 nd2084 2.963707569885e+01
RINT4713 nd2067 nd2085 2.963707569885e+01
RINT4714 nd2068 nd2086 2.963707569885e+01
RINT4715 nd2069 nd2087 2.963707569885e+01
RINT4716 nd2070 nd2088 3.192734950032e+01
RINT4717 nd2071 nd2089 5.233269783871e+03
RINT4718 nd2072 nd2090 6.301718520814e+01
RINT4719 nd2073 nd2091 4.939759605503e+05
RINT4720 nd2074 nd2092 8.232932675838e+04
RINT4721 nd2075 nd2093 1.411359887287e+05
RINT4722 nd2076 nd2094 1.411359887286e+05
RINT4723 nd2077 nd2095 1.411359887287e+05
RINT4724 nd2078 nd2096 1.411359887286e+05
RINT4725 nd2079 nd2097 1.411359887287e+05
RINT4726 nd2080 nd2098 1.411359887287e+05
RINT4727 nd2081 nd2099 1.411359887286e+05
RINT4728 nd2082 nd2100 1.190303519398e+04
RINT4729 nd2083 nd2101 1.580723073761e+04
RINT4730 nd2084 nd2102 2.634538456268e+01
RINT4731 nd2085 nd2103 2.634538456268e+01
RINT4732 nd2086 nd2104 2.634538456268e+01
RINT4733 nd2087 nd2105 2.634538456268e+01
RINT4734 nd2088 nd2106 6.016477927191e+01
RINT4735 nd2089 nd2107 9.861718130214e+03
RINT4736 nd2090 nd2108 1.187513244200e+02
RINT4737 nd2091 nd2109 9.308619442976e+05
RINT4738 nd2092 nd2110 1.551436573829e+05
RINT4739 nd2093 nd2111 2.659605555136e+05
RINT4740 nd2094 nd2112 2.659605555136e+05
RINT4741 nd2095 nd2113 2.659605555136e+05
RINT4742 nd2096 nd2114 2.659605555136e+05
RINT4743 nd2097 nd2115 2.659605555136e+05
RINT4744 nd2098 nd2116 2.659605555136e+05
RINT4745 nd2099 nd2117 2.659605555136e+05
RINT4746 nd2100 nd2118 2.243040829633e+04
RINT4747 nd2101 nd2119 2.978758221752e+04
RINT4748 nd2102 nd2120 4.964597036254e+01
RINT4749 nd2103 nd2121 4.964597036254e+01
RINT4750 nd2104 nd2122 4.964597036254e+01
RINT4751 nd2105 nd2123 4.964597036254e+01
RINT4752 nd2106 nd2124 3.806063516898e+01
RINT4753 nd2107 nd2125 6.238587765727e+03
RINT4754 nd2108 nd2126 7.512286904865e+01
RINT4755 nd2109 nd2127 5.888693897551e+05
RINT4756 nd2110 nd2128 9.814489829252e+04
RINT4757 nd2111 nd2129 1.682483970729e+05
RINT4758 nd2112 nd2130 1.682483970729e+05
RINT4759 nd2113 nd2131 1.682483970729e+05
RINT4760 nd2114 nd2132 1.682483970729e+05
RINT4761 nd2115 nd2133 1.682483970729e+05
RINT4762 nd2116 nd2134 1.682483970729e+05
RINT4763 nd2117 nd2135 1.682483970729e+05
RINT4764 nd2118 nd2136 1.418962384952e+04
RINT4765 nd2119 nd2137 1.884382047216e+04
RINT4766 nd2120 nd2138 3.140636745361e+01
RINT4767 nd2121 nd2139 3.140636745361e+01
RINT4768 nd2122 nd2140 3.140636745361e+01
RINT4769 nd2123 nd2141 3.140636745361e+01
RINT4770 nd2124 nd2142 8.180906973376e+00
RINT4771 nd2125 nd2143 1.340947305006e+03
RINT4772 nd2126 nd2144 1.614721353260e+01
RINT4773 nd2127 nd2145 3.241137758398e+05
RINT4774 nd2128 nd2146 5.401896263997e+04
RINT4775 nd2129 nd2147 9.260393595423e+04
RINT4776 nd2130 nd2148 9.260393595423e+04
RINT4777 nd2131 nd2149 9.260393595423e+04
RINT4778 nd2132 nd2150 9.260393595423e+04
RINT4779 nd2133 nd2151 9.260393595423e+04
RINT4780 nd2134 nd2152 9.260393595423e+04
RINT4781 nd2135 nd2153 9.260393595423e+04
RINT4782 nd2136 nd2154 7.809970502164e+03
RINT4783 nd2137 nd2155 4.050367042518e+03
RINT4784 nd2138 nd2156 6.750611737530e+00
RINT4785 nd2139 nd2157 6.750611737530e+00
RINT4786 nd2140 nd2158 6.750611737530e+00
RINT4787 nd2141 nd2159 6.750611737530e+00
RINT4788 nd2160 nd2178 9.595617906178e+01
RINT4789 nd2161 nd2179 1.572835140777e+04
RINT4790 nd2162 nd2180 1.893952489774e+02
RINT4791 nd2163 nd2181 2.382793656193e+06
RINT4792 nd2164 nd2182 3.955093239879e+05
RINT4793 nd2165 nd2183 6.788524287622e+05
RINT4794 nd2166 nd2184 6.788524287622e+05
RINT4795 nd2167 nd2185 6.788524287622e+05
RINT4796 nd2168 nd2186 6.788524287622e+05
RINT4797 nd2169 nd2187 6.788524287622e+05
RINT4798 nd2170 nd2188 6.788524287622e+05
RINT4799 nd2171 nd2189 6.788524287622e+05
RINT4800 nd2172 nd2190 5.718729630538e+04
RINT4801 nd2173 nd2191 4.750790425349e+04
RINT4802 nd2174 nd2192 7.917984042248e+01
RINT4803 nd2175 nd2193 7.917984042248e+01
RINT4804 nd2176 nd2194 7.917984042248e+01
RINT4805 nd2177 nd2195 7.917984042248e+01
RINT4806 nd2178 nd2196 4.464243124901e+02
RINT4807 nd2179 nd2197 7.317421902862e+04
RINT4808 nd2180 nd2198 8.811380844914e+02
RINT4809 nd2181 nd2199 1.387401404147e+05
RINT4810 nd2182 nd2200 1.538097961822e+04
RINT4811 nd2183 nd2201 3.035769696152e+04
RINT4812 nd2184 nd2202 3.035769696152e+04
RINT4813 nd2185 nd2203 3.035769696152e+04
RINT4814 nd2186 nd2204 3.035769696152e+04
RINT4815 nd2187 nd2205 3.035769696152e+04
RINT4816 nd2188 nd2206 3.035769696152e+04
RINT4817 nd2189 nd2207 3.035769696152e+04
RINT4818 nd2190 nd2208 2.248683976078e+03
RINT4819 nd2191 nd2209 2.210246771138e+05
RINT4820 nd2192 nd2210 3.683744618564e+02
RINT4821 nd2193 nd2211 3.683744618564e+02
RINT4822 nd2194 nd2212 3.683744618564e+02
RINT4823 nd2195 nd2213 3.683744618564e+02
RINT4824 nd2196 nd2214 7.056902782450e+02
RINT4825 nd2197 nd2215 1.156709738738e+05
RINT4826 nd2198 nd2216 1.392868987239e+03
RINT4827 nd2199 nd2217 2.193150452467e+05
RINT4828 nd2200 nd2218 2.431365739451e+04
RINT4829 nd2201 nd2219 4.798827262825e+04
RINT4830 nd2202 nd2220 4.798827262825e+04
RINT4831 nd2203 nd2221 4.798827262825e+04
RINT4832 nd2204 nd2222 4.798827262825e+04
RINT4833 nd2205 nd2223 4.798827262825e+04
RINT4834 nd2206 nd2224 4.798827262825e+04
RINT4835 nd2207 nd2225 4.798827262825e+04
RINT4836 nd2208 nd2226 3.554632613785e+03
RINT4837 nd2209 nd2227 3.493872567591e+05
RINT4838 nd2210 nd2228 5.823120945985e+02
RINT4839 nd2211 nd2229 5.823120945985e+02
RINT4840 nd2212 nd2230 5.823120945985e+02
RINT4841 nd2213 nd2231 5.823120945985e+02
RINT4842 nd2214 nd2232 3.744852820948e+02
RINT4843 nd2215 nd2233 6.138256203421e+04
RINT4844 nd2216 nd2234 7.391471183429e+02
RINT4845 nd2217 nd2235 4.444711096735e+05
RINT4846 nd2218 nd2236 6.795909320561e+04
RINT4847 nd2219 nd2237 1.196551611856e+05
RINT4848 nd2220 nd2238 1.196551611856e+05
RINT4849 nd2221 nd2239 1.196551611856e+05
RINT4850 nd2222 nd2240 1.196551611856e+05
RINT4851 nd2223 nd2241 1.196551611856e+05
RINT4852 nd2224 nd2242 1.196551611856e+05
RINT4853 nd2225 nd2243 1.196551611856e+05
RINT4854 nd2226 nd2244 9.845113585208e+03
RINT4855 nd2227 nd2245 1.854076631651e+05
RINT4856 nd2228 nd2246 3.090127719419e+02
RINT4857 nd2229 nd2247 3.090127719419e+02
RINT4858 nd2230 nd2248 3.090127719419e+02
RINT4859 nd2231 nd2249 3.090127719419e+02
RINT4860 nd2232 nd2250 4.212748687786e+02
RINT4861 nd2233 nd2251 6.905192808007e+04
RINT4862 nd2234 nd2252 8.314989137788e+02
RINT4863 nd2235 nd2253 6.517912110384e+06
RINT4864 nd2236 nd2254 1.086318685064e+06
RINT4865 nd2237 nd2255 1.862260602967e+06
RINT4866 nd2238 nd2256 1.862260602967e+06
RINT4867 nd2239 nd2257 1.862260602967e+06
RINT4868 nd2240 nd2258 1.862260602967e+06
RINT4869 nd2241 nd2259 1.862260602967e+06
RINT4870 nd2242 nd2260 1.862260602967e+06
RINT4871 nd2243 nd2261 1.862260602967e+06
RINT4872 nd2244 nd2262 1.570581231418e+05
RINT4873 nd2245 nd2263 2.085731875323e+05
RINT4874 nd2246 nd2264 3.476219792205e+02
RINT4875 nd2247 nd2265 3.476219792205e+02
RINT4876 nd2248 nd2266 3.476219792205e+02
RINT4877 nd2249 nd2267 3.476219792205e+02
RINT4878 nd2250 nd2268 7.992694516125e+02
RINT4879 nd2251 nd2269 1.310097059655e+05
RINT4880 nd2252 nd2270 1.577572578111e+03
RINT4881 nd2253 nd2271 1.236619704667e+07
RINT4882 nd2254 nd2272 2.061032841111e+06
RINT4883 nd2255 nd2273 3.533199156191e+06
RINT4884 nd2256 nd2274 3.533199156191e+06
RINT4885 nd2257 nd2275 3.533199156191e+06
RINT4886 nd2258 nd2276 3.533199156191e+06
RINT4887 nd2259 nd2277 3.533199156191e+06
RINT4888 nd2260 nd2278 3.533199156191e+06
RINT4889 nd2261 nd2279 3.533199156191e+06
RINT4890 nd2262 nd2280 2.979806517269e+05
RINT4891 nd2263 nd2281 3.957183054934e+05
RINT4892 nd2264 nd2282 6.595305091556e+02
RINT4893 nd2265 nd2283 6.595305091556e+02
RINT4894 nd2266 nd2284 6.595305091556e+02
RINT4895 nd2267 nd2285 6.595305091556e+02
RINT4896 nd2268 nd2286 4.212747992145e+02
RINT4897 nd2269 nd2287 6.905191667769e+04
RINT4898 nd2270 nd2288 8.314987764754e+02
RINT4899 nd2271 nd2289 6.517911034097e+06
RINT4900 nd2272 nd2290 1.086318505683e+06
RINT4901 nd2273 nd2291 1.862260295456e+06
RINT4902 nd2274 nd2292 1.862260295456e+06
RINT4903 nd2275 nd2293 1.862260295456e+06
RINT4904 nd2276 nd2294 1.862260295456e+06
RINT4905 nd2277 nd2295 1.862260295456e+06
RINT4906 nd2278 nd2296 1.862260295456e+06
RINT4907 nd2279 nd2297 1.862260295456e+06
RINT4908 nd2280 nd2298 1.570580972071e+05
RINT4909 nd2281 nd2299 2.085731530911e+05
RINT4910 nd2282 nd2300 3.476219218185e+02
RINT4911 nd2283 nd2301 3.476219218185e+02
RINT4912 nd2284 nd2302 3.476219218185e+02
RINT4913 nd2285 nd2303 3.476219218185e+02
RINT4914 nd2286 nd2304 3.744852125307e+02
RINT4915 nd2287 nd2305 6.138255063183e+04
RINT4916 nd2288 nd2306 7.391469810395e+02
RINT4917 nd2289 nd2307 4.444700333862e+05
RINT4918 nd2290 nd2308 6.795891382440e+04
RINT4919 nd2291 nd2309 1.196548536749e+05
RINT4920 nd2292 nd2310 1.196548536749e+05
RINT4921 nd2293 nd2311 1.196548536749e+05
RINT4922 nd2294 nd2312 1.196548536749e+05
RINT4923 nd2295 nd2313 1.196548536749e+05
RINT4924 nd2296 nd2314 1.196548536749e+05
RINT4925 nd2297 nd2315 1.196548536749e+05
RINT4926 nd2298 nd2316 9.845087650576e+03
RINT4927 nd2299 nd2317 1.854076287240e+05
RINT4928 nd2300 nd2318 3.090127145399e+02
RINT4929 nd2301 nd2319 3.090127145399e+02
RINT4930 nd2302 nd2320 3.090127145399e+02
RINT4931 nd2303 nd2321 3.090127145399e+02
RINT4932 nd2304 nd2322 7.056902782450e+02
RINT4933 nd2305 nd2323 1.156709738738e+05
RINT4934 nd2306 nd2324 1.392868987239e+03
RINT4935 nd2307 nd2325 2.193150452467e+05
RINT4936 nd2308 nd2326 2.431365739451e+04
RINT4937 nd2309 nd2327 4.798827262825e+04
RINT4938 nd2310 nd2328 4.798827262825e+04
RINT4939 nd2311 nd2329 4.798827262825e+04
RINT4940 nd2312 nd2330 4.798827262825e+04
RINT4941 nd2313 nd2331 4.798827262825e+04
RINT4942 nd2314 nd2332 4.798827262825e+04
RINT4943 nd2315 nd2333 4.798827262825e+04
RINT4944 nd2316 nd2334 3.554632613785e+03
RINT4945 nd2317 nd2335 3.493872567591e+05
RINT4946 nd2318 nd2336 5.823120945985e+02
RINT4947 nd2319 nd2337 5.823120945985e+02
RINT4948 nd2320 nd2338 5.823120945985e+02
RINT4949 nd2321 nd2339 5.823120945985e+02
RINT4950 nd2322 nd2340 4.464243124901e+02
RINT4951 nd2323 nd2341 7.317421902862e+04
RINT4952 nd2324 nd2342 8.811380844914e+02
RINT4953 nd2325 nd2343 1.387401404147e+05
RINT4954 nd2326 nd2344 1.538097961822e+04
RINT4955 nd2327 nd2345 3.035769696152e+04
RINT4956 nd2328 nd2346 3.035769696152e+04
RINT4957 nd2329 nd2347 3.035769696152e+04
RINT4958 nd2330 nd2348 3.035769696152e+04
RINT4959 nd2331 nd2349 3.035769696152e+04
RINT4960 nd2332 nd2350 3.035769696152e+04
RINT4961 nd2333 nd2351 3.035769696152e+04
RINT4962 nd2334 nd2352 2.248683976078e+03
RINT4963 nd2335 nd2353 2.210246771138e+05
RINT4964 nd2336 nd2354 3.683744618564e+02
RINT4965 nd2337 nd2355 3.683744618564e+02
RINT4966 nd2338 nd2356 3.683744618564e+02
RINT4967 nd2339 nd2357 3.683744618564e+02
RINT4968 nd2340 nd2358 9.595624862589e+01
RINT4969 nd2341 nd2359 1.572836281015e+04
RINT4970 nd2342 nd2360 1.893953862808e+02
RINT4971 nd2343 nd2361 2.382862538577e+06
RINT4972 nd2344 nd2362 3.955208043852e+05
RINT4973 nd2345 nd2363 6.788721094432e+05
RINT4974 nd2346 nd2364 6.788721094432e+05
RINT4975 nd2347 nd2365 6.788721094432e+05
RINT4976 nd2348 nd2366 6.788721094432e+05
RINT4977 nd2349 nd2367 6.788721094432e+05
RINT4978 nd2350 nd2368 6.788721094432e+05
RINT4979 nd2351 nd2369 6.788721094432e+05
RINT4980 nd2352 nd2370 5.718895612184e+04
RINT4981 nd2353 nd2371 4.750793869468e+04
RINT4982 nd2354 nd2372 7.917989782446e+01
RINT4983 nd2355 nd2373 7.917989782446e+01
RINT4984 nd2356 nd2374 7.917989782446e+01
RINT4985 nd2357 nd2375 7.917989782446e+01
RINT4986 nd2376 nd2394 3.699406346365e-01
RINT4987 nd2377 nd2395 6.063764062376e+01
RINT4988 nd2378 nd2396 7.301770379866e-01
RINT4989 nd2379 nd2397 9.186403689673e+03
RINT4990 nd2380 nd2398 1.524810301446e+03
RINT4991 nd2381 nd2399 2.617185269113e+03
RINT4992 nd2382 nd2400 2.617185269113e+03
RINT4993 nd2383 nd2401 2.617185269113e+03
RINT4994 nd2384 nd2402 2.617185269113e+03
RINT4995 nd2385 nd2403 2.617185269113e+03
RINT4996 nd2386 nd2404 2.617185269113e+03
RINT4997 nd2387 nd2405 2.617185269113e+03
RINT4998 nd2388 nd2406 2.204746468150e+02
RINT4999 nd2389 nd2407 1.831576082085e+02
RINT5000 nd2390 nd2408 3.052626803476e-01
RINT5001 nd2391 nd2409 3.052626803476e-01
RINT5002 nd2392 nd2410 3.052626803476e-01
RINT5003 nd2393 nd2411 3.052626803476e-01
RINT5004 nd2394 nd2412 1.721103269164e+00
RINT5005 nd2395 nd2413 2.821091595264e+02
RINT5006 nd2396 nd2414 3.397058796696e+00
RINT5007 nd2397 nd2415 5.348859875040e+02
RINT5008 nd2398 nd2416 5.929841534887e+01
RINT5009 nd2399 nd2417 1.170382750737e+02
RINT5010 nd2400 nd2418 1.170382750737e+02
RINT5011 nd2401 nd2419 1.170382750737e+02
RINT5012 nd2402 nd2420 1.170382750737e+02
RINT5013 nd2403 nd2421 1.170382750737e+02
RINT5014 nd2404 nd2422 1.170382750737e+02
RINT5015 nd2405 nd2423 1.170382750737e+02
RINT5016 nd2406 nd2424 8.669369553281e+00
RINT5017 nd2407 nd2425 8.521182285633e+02
RINT5018 nd2408 nd2426 1.420197047605e+00
RINT5019 nd2409 nd2427 1.420197047605e+00
RINT5020 nd2410 nd2428 1.420197047605e+00
RINT5021 nd2411 nd2429 1.420197047605e+00
RINT5022 nd2412 nd2430 2.720653447681e+00
RINT5023 nd2413 nd2431 4.459472428174e+02
RINT5024 nd2414 nd2432 5.369939092438e+00
RINT5025 nd2415 nd2433 8.455270709734e+02
RINT5026 nd2416 nd2434 9.373664035818e+01
RINT5027 nd2417 nd2435 1.850095762960e+02
RINT5028 nd2418 nd2436 1.850095762960e+02
RINT5029 nd2419 nd2437 1.850095762960e+02
RINT5030 nd2420 nd2438 1.850095762960e+02
RINT5031 nd2421 nd2439 1.850095762960e+02
RINT5032 nd2422 nd2440 1.850095762960e+02
RINT5033 nd2423 nd2441 1.850095762960e+02
RINT5034 nd2424 nd2442 1.370420391788e+01
RINT5035 nd2425 nd2443 1.346995521947e+03
RINT5036 nd2426 nd2444 2.244992536579e+00
RINT5037 nd2427 nd2445 2.244992536579e+00
RINT5038 nd2428 nd2446 2.244992536579e+00
RINT5039 nd2429 nd2447 2.244992536579e+00
RINT5040 nd2430 nd2448 1.443756142385e+00
RINT5041 nd2431 nd2449 2.366486887721e+02
RINT5042 nd2432 nd2450 2.849639874400e+00
RINT5043 nd2433 nd2451 1.713573070519e+03
RINT5044 nd2434 nd2452 2.620032426845e+02
RINT5045 nd2435 nd2453 4.613075124431e+02
RINT5046 nd2436 nd2454 4.613075124431e+02
RINT5047 nd2437 nd2455 4.613075124431e+02
RINT5048 nd2438 nd2456 4.613075124431e+02
RINT5049 nd2439 nd2457 4.613075124431e+02
RINT5050 nd2440 nd2458 4.613075124431e+02
RINT5051 nd2441 nd2459 4.613075124431e+02
RINT5052 nd2442 nd2460 3.795594617660e+01
RINT5053 nd2443 nd2461 7.148036660946e+02
RINT5054 nd2444 nd2462 1.191339443491e+00
RINT5055 nd2445 nd2463 1.191339443491e+00
RINT5056 nd2446 nd2464 1.191339443491e+00
RINT5057 nd2447 nd2465 1.191339443491e+00
RINT5058 nd2448 nd2466 1.624144415046e+00
RINT5059 nd2449 nd2467 2.662164578309e+02
RINT5060 nd2450 nd2468 3.205684499639e+00
RINT5061 nd2451 nd2469 1.769634296528e+03
RINT5062 nd2452 nd2470 2.682182902694e+02
RINT5063 nd2453 nd2471 4.735742559059e+02
RINT5064 nd2454 nd2472 4.735742559059e+02
RINT5065 nd2455 nd2473 4.735742559059e+02
RINT5066 nd2456 nd2474 4.735742559059e+02
RINT5067 nd2457 nd2475 4.735742559059e+02
RINT5068 nd2458 nd2476 4.735742559059e+02
RINT5069 nd2459 nd2477 4.735742559059e+02
RINT5070 nd2460 nd2478 3.886457997377e+01
RINT5071 nd2461 nd2479 8.041138998895e+02
RINT5072 nd2462 nd2480 1.340189833149e+00
RINT5073 nd2463 nd2481 1.340189833149e+00
RINT5074 nd2464 nd2482 1.340189833149e+00
RINT5075 nd2465 nd2483 1.340189833149e+00
RINT5076 nd2466 nd2484 3.081429993005e+00
RINT5077 nd2467 nd2485 5.050827809351e+02
RINT5078 nd2468 nd2486 6.082028342915e+00
RINT5079 nd2469 nd2487 9.576495229907e+02
RINT5080 nd2470 nd2488 1.061667355280e+02
RINT5081 nd2471 nd2489 2.095430632217e+02
RINT5082 nd2472 nd2490 2.095430632217e+02
RINT5083 nd2473 nd2491 2.095430632217e+02
RINT5084 nd2474 nd2492 2.095430632217e+02
RINT5085 nd2475 nd2493 2.095430632217e+02
RINT5086 nd2476 nd2494 2.095430632217e+02
RINT5087 nd2477 nd2495 2.095430632217e+02
RINT5088 nd2478 nd2496 1.552147151222e+01
RINT5089 nd2479 nd2497 1.525615989537e+03
RINT5090 nd2480 nd2498 2.542693315895e+00
RINT5091 nd2481 nd2499 2.542693315895e+00
RINT5092 nd2482 nd2500 2.542693315895e+00
RINT5093 nd2483 nd2501 2.542693315895e+00
RINT5094 nd2484 nd2502 1.624144146855e+00
RINT5095 nd2485 nd2503 2.662164138712e+02
RINT5096 nd2486 nd2504 3.205683970292e+00
RINT5097 nd2487 nd2505 1.769630147109e+03
RINT5098 nd2488 nd2506 2.682175986996e+02
RINT5099 nd2489 nd2507 4.735730703576e+02
RINT5100 nd2490 nd2508 4.735730703576e+02
RINT5101 nd2491 nd2509 4.735730703576e+02
RINT5102 nd2492 nd2510 4.735730703576e+02
RINT5103 nd2493 nd2511 4.735730703576e+02
RINT5104 nd2494 nd2512 4.735730703576e+02
RINT5105 nd2495 nd2513 4.735730703576e+02
RINT5106 nd2496 nd2514 3.886447998777e+01
RINT5107 nd2497 nd2515 8.041137671081e+02
RINT5108 nd2498 nd2516 1.340189611847e+00
RINT5109 nd2499 nd2517 1.340189611847e+00
RINT5110 nd2500 nd2518 1.340189611847e+00
RINT5111 nd2501 nd2519 1.340189611847e+00
RINT5112 nd2502 nd2520 1.443755874193e+00
RINT5113 nd2503 nd2521 2.366486448124e+02
RINT5114 nd2504 nd2522 2.849639345053e+00
RINT5115 nd2505 nd2523 1.713568921100e+03
RINT5116 nd2506 nd2524 2.620025511147e+02
RINT5117 nd2507 nd2525 4.613063268948e+02
RINT5118 nd2508 nd2526 4.613063268948e+02
RINT5119 nd2509 nd2527 4.613063268948e+02
RINT5120 nd2510 nd2528 4.613063268948e+02
RINT5121 nd2511 nd2529 4.613063268948e+02
RINT5122 nd2512 nd2530 4.613063268948e+02
RINT5123 nd2513 nd2531 4.613063268948e+02
RINT5124 nd2514 nd2532 3.795584619060e+01
RINT5125 nd2515 nd2533 7.148035333132e+02
RINT5126 nd2516 nd2534 1.191339222189e+00
RINT5127 nd2517 nd2535 1.191339222189e+00
RINT5128 nd2518 nd2536 1.191339222189e+00
RINT5129 nd2519 nd2537 1.191339222189e+00
RINT5130 nd2520 nd2538 2.720653447681e+00
RINT5131 nd2521 nd2539 4.459472428174e+02
RINT5132 nd2522 nd2540 5.369939092438e+00
RINT5133 nd2523 nd2541 8.455270709734e+02
RINT5134 nd2524 nd2542 9.373664035818e+01
RINT5135 nd2525 nd2543 1.850095762960e+02
RINT5136 nd2526 nd2544 1.850095762960e+02
RINT5137 nd2527 nd2545 1.850095762960e+02
RINT5138 nd2528 nd2546 1.850095762960e+02
RINT5139 nd2529 nd2547 1.850095762960e+02
RINT5140 nd2530 nd2548 1.850095762960e+02
RINT5141 nd2531 nd2549 1.850095762960e+02
RINT5142 nd2532 nd2550 1.370420391788e+01
RINT5143 nd2533 nd2551 1.346995521947e+03
RINT5144 nd2534 nd2552 2.244992536579e+00
RINT5145 nd2535 nd2553 2.244992536579e+00
RINT5146 nd2536 nd2554 2.244992536579e+00
RINT5147 nd2537 nd2555 2.244992536579e+00
RINT5148 nd2538 nd2556 1.721103269164e+00
RINT5149 nd2539 nd2557 2.821091595264e+02
RINT5150 nd2540 nd2558 3.397058796696e+00
RINT5151 nd2541 nd2559 5.348859875040e+02
RINT5152 nd2542 nd2560 5.929841534887e+01
RINT5153 nd2543 nd2561 1.170382750737e+02
RINT5154 nd2544 nd2562 1.170382750737e+02
RINT5155 nd2545 nd2563 1.170382750737e+02
RINT5156 nd2546 nd2564 1.170382750737e+02
RINT5157 nd2547 nd2565 1.170382750737e+02
RINT5158 nd2548 nd2566 1.170382750737e+02
RINT5159 nd2549 nd2567 1.170382750737e+02
RINT5160 nd2550 nd2568 8.669369553281e+00
RINT5161 nd2551 nd2569 8.521182285633e+02
RINT5162 nd2552 nd2570 1.420197047605e+00
RINT5163 nd2553 nd2571 1.420197047605e+00
RINT5164 nd2554 nd2572 1.420197047605e+00
RINT5165 nd2555 nd2573 1.420197047605e+00
RINT5166 nd2556 nd2574 3.699409028276e-01
RINT5167 nd2557 nd2575 6.063768458344e+01
RINT5168 nd2558 nd2576 7.301775673336e-01
RINT5169 nd2559 nd2577 9.186669252484e+03
RINT5170 nd2560 nd2578 1.524854561914e+03
RINT5171 nd2561 nd2579 2.617261144202e+03
RINT5172 nd2562 nd2580 2.617261144202e+03
RINT5173 nd2563 nd2581 2.617261144202e+03
RINT5174 nd2564 nd2582 2.617261144202e+03
RINT5175 nd2565 nd2583 2.617261144202e+03
RINT5176 nd2566 nd2584 2.617261144202e+03
RINT5177 nd2567 nd2585 2.617261144202e+03
RINT5178 nd2568 nd2586 2.204810459188e+02
RINT5179 nd2569 nd2587 1.831577409900e+02
RINT5180 nd2570 nd2588 3.052629016499e-01
RINT5181 nd2571 nd2589 3.052629016499e-01
RINT5182 nd2572 nd2590 3.052629016499e-01
RINT5183 nd2573 nd2591 3.052629016499e-01
RINT5184 nd2592 nd2610 9.595617906178e+01
RINT5185 nd2593 nd2611 1.572835140777e+04
RINT5186 nd2594 nd2612 1.893952489774e+02
RINT5187 nd2595 nd2613 3.801556311348e+06
RINT5188 nd2596 nd2614 6.335927185581e+05
RINT5189 nd2597 nd2615 1.086158946100e+06
RINT5190 nd2598 nd2616 1.086158946100e+06
RINT5191 nd2599 nd2617 1.086158946100e+06
RINT5192 nd2600 nd2618 1.086158946100e+06
RINT5193 nd2601 nd2619 1.086158946100e+06
RINT5194 nd2602 nd2620 1.086158946100e+06
RINT5195 nd2603 nd2621 1.086158946100e+06
RINT5196 nd2604 nd2622 9.160376653851e+04
RINT5197 nd2605 nd2623 4.750790425349e+04
RINT5198 nd2606 nd2624 7.917984042248e+01
RINT5199 nd2607 nd2625 7.917984042248e+01
RINT5200 nd2608 nd2626 7.917984042248e+01
RINT5201 nd2609 nd2627 7.917984042248e+01
RINT5202 nd2610 nd2628 4.464243124901e+02
RINT5203 nd2611 nd2629 7.317421902862e+04
RINT5204 nd2612 nd2630 8.811380844914e+02
RINT5205 nd2613 nd2631 6.907021159807e+06
RINT5206 nd2614 nd2632 1.151170193301e+06
RINT5207 nd2615 nd2633 1.973434617088e+06
RINT5208 nd2616 nd2634 1.973434617088e+06
RINT5209 nd2617 nd2635 1.973434617088e+06
RINT5210 nd2618 nd2636 1.973434617088e+06
RINT5211 nd2619 nd2637 1.973434617088e+06
RINT5212 nd2620 nd2638 1.973434617088e+06
RINT5213 nd2621 nd2639 1.973434617088e+06
RINT5214 nd2622 nd2640 1.664342448146e+05
RINT5215 nd2623 nd2641 2.210246771138e+05
RINT5216 nd2624 nd2642 3.683744618564e+02
RINT5217 nd2625 nd2643 3.683744618564e+02
RINT5218 nd2626 nd2644 3.683744618564e+02
RINT5219 nd2627 nd2645 3.683744618564e+02
RINT5220 nd2628 nd2646 7.056902782450e+02
RINT5221 nd2629 nd2647 1.156709738738e+05
RINT5222 nd2630 nd2648 1.392868987239e+03
RINT5223 nd2631 nd2649 1.091835177372e+07
RINT5224 nd2632 nd2650 1.819725295620e+06
RINT5225 nd2633 nd2651 3.119529078206e+06
RINT5226 nd2634 nd2652 3.119529078206e+06
RINT5227 nd2635 nd2653 3.119529078206e+06
RINT5228 nd2636 nd2654 3.119529078206e+06
RINT5229 nd2637 nd2655 3.119529078206e+06
RINT5230 nd2638 nd2656 3.119529078206e+06
RINT5231 nd2639 nd2657 3.119529078206e+06
RINT5232 nd2640 nd2658 2.630928138246e+05
RINT5233 nd2641 nd2659 3.493872567591e+05
RINT5234 nd2642 nd2660 5.823120945985e+02
RINT5235 nd2643 nd2661 5.823120945985e+02
RINT5236 nd2644 nd2662 5.823120945985e+02
RINT5237 nd2645 nd2663 5.823120945985e+02
RINT5238 nd2646 nd2664 3.744852820948e+02
RINT5239 nd2647 nd2665 6.138256203421e+04
RINT5240 nd2648 nd2666 7.391471183429e+02
RINT5241 nd2649 nd2667 5.793989473911e+06
RINT5242 nd2650 nd2668 9.656649123185e+05
RINT5243 nd2651 nd2669 1.655425563974e+06
RINT5244 nd2652 nd2670 1.655425563974e+06
RINT5245 nd2653 nd2671 1.655425563974e+06
RINT5246 nd2654 nd2672 1.655425563974e+06
RINT5247 nd2655 nd2673 1.655425563974e+06
RINT5248 nd2656 nd2674 1.655425563974e+06
RINT5249 nd2657 nd2675 1.655425563974e+06
RINT5250 nd2658 nd2676 1.396142041906e+05
RINT5251 nd2659 nd2677 1.854076631651e+05
RINT5252 nd2660 nd2678 3.090127719419e+02
RINT5253 nd2661 nd2679 3.090127719419e+02
RINT5254 nd2662 nd2680 3.090127719419e+02
RINT5255 nd2663 nd2681 3.090127719419e+02
RINT5256 nd2664 nd2682 4.212748687786e+02
RINT5257 nd2665 nd2683 6.905192808007e+04
RINT5258 nd2666 nd2684 8.314989137788e+02
RINT5259 nd2667 nd2685 4.590124185691e+05
RINT5260 nd2668 nd2686 6.957116866609e+04
RINT5261 nd2669 nd2687 1.228369415093e+05
RINT5262 nd2670 nd2688 1.228369415093e+05
RINT5263 nd2671 nd2689 1.228369415093e+05
RINT5264 nd2672 nd2690 1.228369415093e+05
RINT5265 nd2673 nd2691 1.228369415093e+05
RINT5266 nd2674 nd2692 1.228369415093e+05
RINT5267 nd2675 nd2693 1.228369415093e+05
RINT5268 nd2676 nd2694 1.008079741980e+04
RINT5269 nd2677 nd2695 2.085731875323e+05
RINT5270 nd2678 nd2696 3.476219792205e+02
RINT5271 nd2679 nd2697 3.476219792205e+02
RINT5272 nd2680 nd2698 3.476219792205e+02
RINT5273 nd2681 nd2699 3.476219792205e+02
RINT5274 nd2682 nd2700 7.992694516125e+02
RINT5275 nd2683 nd2701 1.310097059655e+05
RINT5276 nd2684 nd2702 1.577572578111e+03
RINT5277 nd2685 nd2703 2.483976630380e+05
RINT5278 nd2686 nd2704 2.753780831547e+04
RINT5279 nd2687 nd2705 5.435183327565e+04
RINT5280 nd2688 nd2706 5.435183327565e+04
RINT5281 nd2689 nd2707 5.435183327565e+04
RINT5282 nd2690 nd2708 5.435183327565e+04
RINT5283 nd2691 nd2709 5.435183327565e+04
RINT5284 nd2692 nd2710 5.435183327565e+04
RINT5285 nd2693 nd2711 5.435183327565e+04
RINT5286 nd2694 nd2712 4.026000282971e+03
RINT5287 nd2695 nd2713 3.957183054934e+05
RINT5288 nd2696 nd2714 6.595305091556e+02
RINT5289 nd2697 nd2715 6.595305091556e+02
RINT5290 nd2698 nd2716 6.595305091556e+02
RINT5291 nd2699 nd2717 6.595305091556e+02
RINT5292 nd2700 nd2718 4.212747992145e+02
RINT5293 nd2701 nd2719 6.905191667769e+04
RINT5294 nd2702 nd2720 8.314987764754e+02
RINT5295 nd2703 nd2721 4.590113422819e+05
RINT5296 nd2704 nd2722 6.957098928488e+04
RINT5297 nd2705 nd2723 1.228366339986e+05
RINT5298 nd2706 nd2724 1.228366339986e+05
RINT5299 nd2707 nd2725 1.228366339986e+05
RINT5300 nd2708 nd2726 1.228366339986e+05
RINT5301 nd2709 nd2727 1.228366339986e+05
RINT5302 nd2710 nd2728 1.228366339986e+05
RINT5303 nd2711 nd2729 1.228366339986e+05
RINT5304 nd2712 nd2730 1.008077148517e+04
RINT5305 nd2713 nd2731 2.085731530911e+05
RINT5306 nd2714 nd2732 3.476219218185e+02
RINT5307 nd2715 nd2733 3.476219218185e+02
RINT5308 nd2716 nd2734 3.476219218185e+02
RINT5309 nd2717 nd2735 3.476219218185e+02
RINT5310 nd2718 nd2736 3.744852125307e+02
RINT5311 nd2719 nd2737 6.138255063183e+04
RINT5312 nd2720 nd2738 7.391469810395e+02
RINT5313 nd2721 nd2739 5.793988397623e+06
RINT5314 nd2722 nd2740 9.656647329372e+05
RINT5315 nd2723 nd2741 1.655425256464e+06
RINT5316 nd2724 nd2742 1.655425256464e+06
RINT5317 nd2725 nd2743 1.655425256464e+06
RINT5318 nd2726 nd2744 1.655425256464e+06
RINT5319 nd2727 nd2745 1.655425256464e+06
RINT5320 nd2728 nd2746 1.655425256464e+06
RINT5321 nd2729 nd2747 1.655425256464e+06
RINT5322 nd2730 nd2748 1.396141782560e+05
RINT5323 nd2731 nd2749 1.854076287240e+05
RINT5324 nd2732 nd2750 3.090127145399e+02
RINT5325 nd2733 nd2751 3.090127145399e+02
RINT5326 nd2734 nd2752 3.090127145399e+02
RINT5327 nd2735 nd2753 3.090127145399e+02
RINT5328 nd2736 nd2754 7.056902782450e+02
RINT5329 nd2737 nd2755 1.156709738738e+05
RINT5330 nd2738 nd2756 1.392868987239e+03
RINT5331 nd2739 nd2757 1.091835177372e+07
RINT5332 nd2740 nd2758 1.819725295620e+06
RINT5333 nd2741 nd2759 3.119529078206e+06
RINT5334 nd2742 nd2760 3.119529078206e+06
RINT5335 nd2743 nd2761 3.119529078206e+06
RINT5336 nd2744 nd2762 3.119529078206e+06
RINT5337 nd2745 nd2763 3.119529078206e+06
RINT5338 nd2746 nd2764 3.119529078206e+06
RINT5339 nd2747 nd2765 3.119529078206e+06
RINT5340 nd2748 nd2766 2.630928138246e+05
RINT5341 nd2749 nd2767 3.493872567591e+05
RINT5342 nd2750 nd2768 5.823120945985e+02
RINT5343 nd2751 nd2769 5.823120945985e+02
RINT5344 nd2752 nd2770 5.823120945985e+02
RINT5345 nd2753 nd2771 5.823120945985e+02
RINT5346 nd2754 nd2772 4.464243124901e+02
RINT5347 nd2755 nd2773 7.317421902862e+04
RINT5348 nd2756 nd2774 8.811380844914e+02
RINT5349 nd2757 nd2775 6.907021159807e+06
RINT5350 nd2758 nd2776 1.151170193301e+06
RINT5351 nd2759 nd2777 1.973434617088e+06
RINT5352 nd2760 nd2778 1.973434617088e+06
RINT5353 nd2761 nd2779 1.973434617088e+06
RINT5354 nd2762 nd2780 1.973434617088e+06
RINT5355 nd2763 nd2781 1.973434617088e+06
RINT5356 nd2764 nd2782 1.973434617088e+06
RINT5357 nd2765 nd2783 1.973434617088e+06
RINT5358 nd2766 nd2784 1.664342448146e+05
RINT5359 nd2767 nd2785 2.210246771138e+05
RINT5360 nd2768 nd2786 3.683744618564e+02
RINT5361 nd2769 nd2787 3.683744618564e+02
RINT5362 nd2770 nd2788 3.683744618564e+02
RINT5363 nd2771 nd2789 3.683744618564e+02
RINT5364 nd2772 nd2790 9.595624862589e+01
RINT5365 nd2773 nd2791 1.572836281015e+04
RINT5366 nd2774 nd2792 1.893953862808e+02
RINT5367 nd2775 nd2793 3.801625193732e+06
RINT5368 nd2776 nd2794 6.336041989553e+05
RINT5369 nd2777 nd2795 1.086178626780e+06
RINT5370 nd2778 nd2796 1.086178626780e+06
RINT5371 nd2779 nd2797 1.086178626780e+06
RINT5372 nd2780 nd2798 1.086178626780e+06
RINT5373 nd2781 nd2799 1.086178626780e+06
RINT5374 nd2782 nd2800 1.086178626780e+06
RINT5375 nd2783 nd2801 1.086178626780e+06
RINT5376 nd2784 nd2802 9.160542635498e+04
RINT5377 nd2785 nd2803 4.750793869468e+04
RINT5378 nd2786 nd2804 7.917989782446e+01
RINT5379 nd2787 nd2805 7.917989782446e+01
RINT5380 nd2788 nd2806 7.917989782446e+01
RINT5381 nd2789 nd2807 7.917989782446e+01
RINT5382 nd2808 nd2826 2.343613441334e+02
RINT5383 nd2809 nd2827 3.841459312957e+04
RINT5384 nd2810 nd2828 4.625749540760e+02
RINT5385 nd2811 nd2829 2.320646029608e+08
RINT5386 nd2812 nd2830 3.867743382681e+07
RINT5387 nd2813 nd2831 6.630417227453e+07
RINT5388 nd2814 nd2832 6.630417227453e+07
RINT5389 nd2815 nd2833 6.630417227453e+07
RINT5390 nd2816 nd2834 6.630417227453e+07
RINT5391 nd2817 nd2835 6.630417227453e+07
RINT5392 nd2818 nd2836 6.630417227453e+07
RINT5393 nd2819 nd2837 6.630417227453e+07
RINT5394 nd2820 nd2838 5.591918143635e+06
RINT5395 nd2821 nd2839 1.160323014804e+05
RINT5396 nd2822 nd2840 1.933871691340e+02
RINT5397 nd2823 nd2841 1.933871691340e+02
RINT5398 nd2824 nd2842 1.933871691340e+02
RINT5399 nd2825 nd2843 1.933871691340e+02
RINT5400 nd2826 nd2844 1.090337307633e+03
RINT5401 nd2827 nd2845 1.787191663438e+05
RINT5402 nd2828 nd2846 2.152073038627e+03
RINT5403 nd2829 nd2847 1.079652002018e+09
RINT5404 nd2830 nd2848 1.799420003364e+08
RINT5405 nd2831 nd2849 3.084720005767e+08
RINT5406 nd2832 nd2850 3.084720005767e+08
RINT5407 nd2833 nd2851 3.084720005767e+08
RINT5408 nd2834 nd2852 3.084720005767e+08
RINT5409 nd2835 nd2853 3.084720005767e+08
RINT5410 nd2836 nd2854 3.084720005767e+08
RINT5411 nd2837 nd2855 3.084720005767e+08
RINT5412 nd2838 nd2856 2.601571089201e+07
RINT5413 nd2839 nd2857 5.398260010091e+05
RINT5414 nd2840 nd2858 8.997100016819e+02
RINT5415 nd2841 nd2859 8.997100016819e+02
RINT5416 nd2842 nd2860 8.997100016819e+02
RINT5417 nd2843 nd2861 8.997100016819e+02
RINT5418 nd2844 nd2862 1.723563023960e+03
RINT5419 nd2845 nd2863 2.825123423977e+05
RINT5420 nd2846 nd2864 3.401913782341e+03
RINT5421 nd2847 nd2865 1.706672106325e+09
RINT5422 nd2848 nd2866 2.844453510541e+08
RINT5423 nd2849 nd2867 4.876206018071e+08
RINT5424 nd2850 nd2868 4.876206018071e+08
RINT5425 nd2851 nd2869 4.876206018071e+08
RINT5426 nd2852 nd2870 4.876206018071e+08
RINT5427 nd2853 nd2871 4.876206018071e+08
RINT5428 nd2854 nd2872 4.876206018071e+08
RINT5429 nd2855 nd2873 4.876206018071e+08
RINT5430 nd2856 nd2874 4.112462906807e+07
RINT5431 nd2857 nd2875 8.533360531624e+05
RINT5432 nd2858 nd2876 1.422226755271e+03
RINT5433 nd2859 nd2877 1.422226755271e+03
RINT5434 nd2860 nd2878 1.422226755271e+03
RINT5435 nd2861 nd2879 1.422226755271e+03
RINT5436 nd2862 nd2880 9.146349399073e+02
RINT5437 nd2863 nd2881 1.499194724649e+05
RINT5438 nd2864 nd2882 1.805277303253e+03
RINT5439 nd2865 nd2883 9.056715174962e+08
RINT5440 nd2866 nd2884 1.509452529160e+08
RINT5441 nd2867 nd2885 2.587632907132e+08
RINT5442 nd2868 nd2886 2.587632907132e+08
RINT5443 nd2869 nd2887 2.587632907132e+08
RINT5444 nd2870 nd2888 2.587632907132e+08
RINT5445 nd2871 nd2889 2.587632907132e+08
RINT5446 nd2872 nd2890 2.587632907132e+08
RINT5447 nd2873 nd2891 2.587632907132e+08
RINT5448 nd2874 nd2892 2.182341006015e+07
RINT5449 nd2875 nd2893 4.528357587481e+05
RINT5450 nd2876 nd2894 7.547262645801e+02
RINT5451 nd2877 nd2895 7.547262645801e+02
RINT5452 nd2878 nd2896 7.547262645801e+02
RINT5453 nd2879 nd2897 7.547262645801e+02
RINT5454 nd2880 nd2898 1.028912837734e+03
RINT5455 nd2881 nd2899 1.686509700373e+05
RINT5456 nd2882 nd2900 2.030835376982e+03
RINT5457 nd2883 nd2901 1.018829491924e+09
RINT5458 nd2884 nd2902 1.698049153207e+08
RINT5459 nd2885 nd2903 2.910941405497e+08
RINT5460 nd2886 nd2904 2.910941405497e+08
RINT5461 nd2887 nd2905 2.910941405497e+08
RINT5462 nd2888 nd2906 2.910941405497e+08
RINT5463 nd2889 nd2907 2.910941405497e+08
RINT5464 nd2890 nd2908 2.910941405497e+08
RINT5465 nd2891 nd2909 2.910941405497e+08
RINT5466 nd2892 nd2910 2.455010823914e+07
RINT5467 nd2893 nd2911 5.094147459621e+05
RINT5468 nd2894 nd2912 8.490245766034e+02
RINT5469 nd2895 nd2913 8.490245766034e+02
RINT5470 nd2896 nd2914 8.490245766034e+02
RINT5471 nd2897 nd2915 8.490245766034e+02
RINT5472 nd2898 nd2916 1.952118819613e+03
RINT5473 nd2899 nd2917 3.199753375426e+05
RINT5474 nd2900 nd2918 3.853029929797e+03
RINT5475 nd2901 nd2919 1.932988055181e+09
RINT5476 nd2902 nd2920 3.221646758634e+08
RINT5477 nd2903 nd2921 5.522823014802e+08
RINT5478 nd2904 nd2922 5.522823014802e+08
RINT5479 nd2905 nd2923 5.522823014802e+08
RINT5480 nd2906 nd2924 5.522823014802e+08
RINT5481 nd2907 nd2925 5.522823014802e+08
RINT5482 nd2908 nd2926 5.522823014802e+08
RINT5483 nd2909 nd2927 5.522823014802e+08
RINT5484 nd2910 nd2928 4.657802542604e+07
RINT5485 nd2911 nd2929 9.664940275904e+05
RINT5486 nd2912 nd2930 1.610823379317e+03
RINT5487 nd2913 nd2931 1.610823379317e+03
RINT5488 nd2914 nd2932 1.610823379317e+03
RINT5489 nd2915 nd2933 1.610823379317e+03
RINT5490 nd2916 nd2934 1.028912667832e+03
RINT5491 nd2917 nd2935 1.686509421884e+05
RINT5492 nd2918 nd2936 2.030835041635e+03
RINT5493 nd2919 nd2937 1.018829323687e+09
RINT5494 nd2920 nd2938 1.698048872812e+08
RINT5495 nd2921 nd2939 2.910940924821e+08
RINT5496 nd2922 nd2940 2.910940924821e+08
RINT5497 nd2923 nd2941 2.910940924821e+08
RINT5498 nd2924 nd2942 2.910940924821e+08
RINT5499 nd2925 nd2943 2.910940924821e+08
RINT5500 nd2926 nd2944 2.910940924821e+08
RINT5501 nd2927 nd2945 2.910940924821e+08
RINT5502 nd2928 nd2946 2.455010418523e+07
RINT5503 nd2929 nd2947 5.094146618436e+05
RINT5504 nd2930 nd2948 8.490244364060e+02
RINT5505 nd2931 nd2949 8.490244364060e+02
RINT5506 nd2932 nd2950 8.490244364060e+02
RINT5507 nd2933 nd2951 8.490244364060e+02
RINT5508 nd2934 nd2952 9.146347700053e+02
RINT5509 nd2935 nd2953 1.499194446159e+05
RINT5510 nd2936 nd2954 1.805276967906e+03
RINT5511 nd2937 nd2955 9.056713492593e+08
RINT5512 nd2938 nd2956 1.509452248765e+08
RINT5513 nd2939 nd2957 2.587632426455e+08
RINT5514 nd2940 nd2958 2.587632426455e+08
RINT5515 nd2941 nd2959 2.587632426455e+08
RINT5516 nd2942 nd2960 2.587632426455e+08
RINT5517 nd2943 nd2961 2.587632426455e+08
RINT5518 nd2944 nd2962 2.587632426455e+08
RINT5519 nd2945 nd2963 2.587632426455e+08
RINT5520 nd2946 nd2964 2.182340600625e+07
RINT5521 nd2947 nd2965 4.528356746296e+05
RINT5522 nd2948 nd2966 7.547261243827e+02
RINT5523 nd2949 nd2967 7.547261243827e+02
RINT5524 nd2950 nd2968 7.547261243827e+02
RINT5525 nd2951 nd2969 7.547261243827e+02
RINT5526 nd2952 nd2970 1.723563023960e+03
RINT5527 nd2953 nd2971 2.825123423977e+05
RINT5528 nd2954 nd2972 3.401913782341e+03
RINT5529 nd2955 nd2973 1.706672106325e+09
RINT5530 nd2956 nd2974 2.844453510541e+08
RINT5531 nd2957 nd2975 4.876206018071e+08
RINT5532 nd2958 nd2976 4.876206018071e+08
RINT5533 nd2959 nd2977 4.876206018071e+08
RINT5534 nd2960 nd2978 4.876206018071e+08
RINT5535 nd2961 nd2979 4.876206018071e+08
RINT5536 nd2962 nd2980 4.876206018071e+08
RINT5537 nd2963 nd2981 4.876206018071e+08
RINT5538 nd2964 nd2982 4.112462906807e+07
RINT5539 nd2965 nd2983 8.533360531624e+05
RINT5540 nd2966 nd2984 1.422226755271e+03
RINT5541 nd2967 nd2985 1.422226755271e+03
RINT5542 nd2968 nd2986 1.422226755271e+03
RINT5543 nd2969 nd2987 1.422226755271e+03
RINT5544 nd2970 nd2988 1.090337307633e+03
RINT5545 nd2971 nd2989 1.787191663438e+05
RINT5546 nd2972 nd2990 2.152073038627e+03
RINT5547 nd2973 nd2991 1.079652002018e+09
RINT5548 nd2974 nd2992 1.799420003364e+08
RINT5549 nd2975 nd2993 3.084720005767e+08
RINT5550 nd2976 nd2994 3.084720005767e+08
RINT5551 nd2977 nd2995 3.084720005767e+08
RINT5552 nd2978 nd2996 3.084720005767e+08
RINT5553 nd2979 nd2997 3.084720005767e+08
RINT5554 nd2980 nd2998 3.084720005767e+08
RINT5555 nd2981 nd2999 3.084720005767e+08
RINT5556 nd2982 nd3000 2.601571089201e+07
RINT5557 nd2983 nd3001 5.398260010091e+05
RINT5558 nd2984 nd3002 8.997100016819e+02
RINT5559 nd2985 nd3003 8.997100016819e+02
RINT5560 nd2986 nd3004 8.997100016819e+02
RINT5561 nd2987 nd3005 8.997100016819e+02
RINT5562 nd2988 nd3006 2.343615140353e+02
RINT5563 nd2989 nd3007 3.841462097851e+04
RINT5564 nd2990 nd3008 4.625752894230e+02
RINT5565 nd2991 nd3009 2.320647711977e+08
RINT5566 nd2992 nd3010 3.867746186629e+07
RINT5567 nd2993 nd3011 6.630422034221e+07
RINT5568 nd2994 nd3012 6.630422034221e+07
RINT5569 nd2995 nd3013 6.630422034221e+07
RINT5570 nd2996 nd3014 6.630422034221e+07
RINT5571 nd2997 nd3015 6.630422034221e+07
RINT5572 nd2998 nd3016 6.630422034221e+07
RINT5573 nd2999 nd3017 6.630422034221e+07
RINT5574 nd3000 nd3018 5.591922197536e+06
RINT5575 nd3001 nd3019 1.160323855989e+05
RINT5576 nd3002 nd3020 1.933873093314e+02
RINT5577 nd3003 nd3021 1.933873093314e+02
RINT5578 nd3004 nd3022 1.933873093314e+02
RINT5579 nd3005 nd3023 1.933873093314e+02
RINT5580 nd0 nd1 5.341900564497e+04
RINT5581 nd1 nd2 5.581391083234e+04
RINT5582 nd2 nd3 4.972282960304e+05
RINT5583 nd3 nd4 3.446468079207e+06
RINT5584 nd4 nd5 4.677349536066e+06
RINT5585 nd5 nd6 3.446468079207e+06
RINT5586 nd6 nd7 3.446468079207e+06
RINT5587 nd7 nd8 3.446468079207e+06
RINT5588 nd8 nd9 3.446468079207e+06
RINT5589 nd9 nd10 3.446468079207e+06
RINT5590 nd10 nd11 3.446468079207e+06
RINT5591 nd11 nd12 2.215586622347e+07
RINT5592 nd12 nd13 2.045724981300e+07
RINT5593 nd13 nd14 2.692553186880e+04
RINT5594 nd14 nd15 4.615805463223e+03
RINT5595 nd15 nd16 4.615805463223e+03
RINT5596 nd16 nd17 4.615805463223e+03
RINT5597 nd18 nd19 1.356896796877e+03
RINT5598 nd19 nd20 1.417729811987e+03
RINT5599 nd20 nd21 1.263010185334e+04
RINT5600 nd21 nd22 8.754377661567e+04
RINT5601 nd22 nd23 1.188094111213e+05
RINT5602 nd23 nd24 8.754377661567e+04
RINT5603 nd24 nd25 8.754377661567e+04
RINT5604 nd25 nd26 8.754377661567e+04
RINT5605 nd26 nd27 8.754377661567e+04
RINT5606 nd27 nd28 8.754377661567e+04
RINT5607 nd28 nd29 8.754377661567e+04
RINT5608 nd29 nd30 5.627814211007e+05
RINT5609 nd30 nd31 5.196348454830e+05
RINT5610 nd31 nd32 6.839357548099e+02
RINT5611 nd32 nd33 1.172461293960e+02
RINT5612 nd33 nd34 1.172461293960e+02
RINT5613 nd34 nd35 1.172461293960e+02
RINT5614 nd36 nd37 3.598668835644e+02
RINT5615 nd37 nd38 3.760005995669e+02
RINT5616 nd38 nd39 3.349669188935e+03
RINT5617 nd39 nd40 2.321776139398e+04
RINT5618 nd40 nd41 3.150981903468e+04
RINT5619 nd41 nd42 2.321776139398e+04
RINT5620 nd42 nd43 2.321776139398e+04
RINT5621 nd43 nd44 2.321776139398e+04
RINT5622 nd44 nd45 2.321776139398e+04
RINT5623 nd45 nd46 2.321776139398e+04
RINT5624 nd46 nd47 2.321776139398e+04
RINT5625 nd47 nd48 1.492570375327e+05
RINT5626 nd48 nd49 1.378139979885e+05
RINT5627 nd49 nd50 1.813887608904e+02
RINT5628 nd50 nd51 3.109521615265e+01
RINT5629 nd51 nd52 3.109521615265e+01
RINT5630 nd52 nd53 3.109521615265e+01
RINT5631 nd54 nd55 3.598668835644e+02
RINT5632 nd55 nd56 3.760005995669e+02
RINT5633 nd56 nd57 3.349669188935e+03
RINT5634 nd57 nd58 2.321776139398e+04
RINT5635 nd58 nd59 3.150981903468e+04
RINT5636 nd59 nd60 2.321776139398e+04
RINT5637 nd60 nd61 2.321776139398e+04
RINT5638 nd61 nd62 2.321776139398e+04
RINT5639 nd62 nd63 2.321776139398e+04
RINT5640 nd63 nd64 2.321776139398e+04
RINT5641 nd64 nd65 2.321776139398e+04
RINT5642 nd65 nd66 1.492570375327e+05
RINT5643 nd66 nd67 1.378139979885e+05
RINT5644 nd67 nd68 1.813887608904e+02
RINT5645 nd68 nd69 3.109521615265e+01
RINT5646 nd69 nd70 3.109521615265e+01
RINT5647 nd70 nd71 3.109521615265e+01
RINT5648 nd72 nd73 5.867672905821e+03
RINT5649 nd73 nd74 6.130735089594e+03
RINT5650 nd74 nd75 5.461675981046e+04
RINT5651 nd75 nd76 3.785683976138e+05
RINT5652 nd76 nd77 5.137713967615e+05
RINT5653 nd77 nd78 3.785683976138e+05
RINT5654 nd78 nd79 3.785683976138e+05
RINT5655 nd79 nd80 3.785683976138e+05
RINT5656 nd80 nd81 3.785683976138e+05
RINT5657 nd81 nd82 3.785683976138e+05
RINT5658 nd82 nd83 3.785683976138e+05
RINT5659 nd83 nd84 2.433653984660e+06
RINT5660 nd84 nd85 2.247073845836e+06
RINT5661 nd85 nd86 2.957565606358e+03
RINT5662 nd86 nd87 5.070112468042e+02
RINT5663 nd87 nd88 5.070112468042e+02
RINT5664 nd88 nd89 5.070112468042e+02
RINT5665 nd90 nd91 3.177333509762e+02
RINT5666 nd91 nd92 3.319781172586e+02
RINT5667 nd92 nd93 2.957486961624e+03
RINT5668 nd93 nd94 2.049940538236e+04
RINT5669 nd94 nd95 2.782062159034e+04
RINT5670 nd95 nd96 2.049940538236e+04
RINT5671 nd96 nd97 2.049940538236e+04
RINT5672 nd97 nd98 2.049940538236e+04
RINT5673 nd98 nd99 2.049940538236e+04
RINT5674 nd99 nd100 2.049940538236e+04
RINT5675 nd100 nd101 2.049940538236e+04
RINT5676 nd101 nd102 1.317818917437e+05
RINT5677 nd102 nd103 1.216786133767e+05
RINT5678 nd103 nd104 1.601516045497e+02
RINT5679 nd104 nd105 2.745456077994e+01
RINT5680 nd105 nd106 2.745456077994e+01
RINT5681 nd106 nd107 2.745456077994e+01
RINT5682 nd108 nd109 3.177333509762e+02
RINT5683 nd109 nd110 3.319781172586e+02
RINT5684 nd110 nd111 2.957486961624e+03
RINT5685 nd111 nd112 2.049940538236e+04
RINT5686 nd112 nd113 2.782062159034e+04
RINT5687 nd113 nd114 2.049940538236e+04
RINT5688 nd114 nd115 2.049940538236e+04
RINT5689 nd115 nd116 2.049940538236e+04
RINT5690 nd116 nd117 2.049940538236e+04
RINT5691 nd117 nd118 2.049940538236e+04
RINT5692 nd118 nd119 2.049940538236e+04
RINT5693 nd119 nd120 1.317818917437e+05
RINT5694 nd120 nd121 1.216786133767e+05
RINT5695 nd121 nd122 1.601516045497e+02
RINT5696 nd122 nd123 2.745456077994e+01
RINT5697 nd123 nd124 2.745456077994e+01
RINT5698 nd124 nd125 2.745456077994e+01
RINT5699 nd126 nd127 5.867691768024e+03
RINT5700 nd127 nd128 6.130754797435e+03
RINT5701 nd128 nd129 5.461693538132e+04
RINT5702 nd129 nd130 3.785696145585e+05
RINT5703 nd130 nd131 5.137730483295e+05
RINT5704 nd131 nd132 3.785696145585e+05
RINT5705 nd132 nd133 3.785696145585e+05
RINT5706 nd133 nd134 3.785696145585e+05
RINT5707 nd134 nd135 3.785696145585e+05
RINT5708 nd135 nd136 3.785696145585e+05
RINT5709 nd136 nd137 3.785696145585e+05
RINT5710 nd137 nd138 2.433661807876e+06
RINT5711 nd138 nd139 2.247081069273e+06
RINT5712 nd139 nd140 2.957575113739e+03
RINT5713 nd140 nd141 5.070128766409e+02
RINT5714 nd141 nd142 5.070128766409e+02
RINT5715 nd142 nd143 5.070128766409e+02
RINT5716 nd144 nd145 3.598668835644e+02
RINT5717 nd145 nd146 3.760005995669e+02
RINT5718 nd146 nd147 3.349669188935e+03
RINT5719 nd147 nd148 2.321776139398e+04
RINT5720 nd148 nd149 3.150981903468e+04
RINT5721 nd149 nd150 2.321776139398e+04
RINT5722 nd150 nd151 2.321776139398e+04
RINT5723 nd151 nd152 2.321776139398e+04
RINT5724 nd152 nd153 2.321776139398e+04
RINT5725 nd153 nd154 2.321776139398e+04
RINT5726 nd154 nd155 2.321776139398e+04
RINT5727 nd155 nd156 1.492570375327e+05
RINT5728 nd156 nd157 1.378139979885e+05
RINT5729 nd157 nd158 1.813887608904e+02
RINT5730 nd158 nd159 3.109521615265e+01
RINT5731 nd159 nd160 3.109521615265e+01
RINT5732 nd160 nd161 3.109521615265e+01
RINT5733 nd162 nd163 3.598668835644e+02
RINT5734 nd163 nd164 3.760005995669e+02
RINT5735 nd164 nd165 3.349669188935e+03
RINT5736 nd165 nd166 2.321776139398e+04
RINT5737 nd166 nd167 3.150981903468e+04
RINT5738 nd167 nd168 2.321776139398e+04
RINT5739 nd168 nd169 2.321776139398e+04
RINT5740 nd169 nd170 2.321776139398e+04
RINT5741 nd170 nd171 2.321776139398e+04
RINT5742 nd171 nd172 2.321776139398e+04
RINT5743 nd172 nd173 2.321776139398e+04
RINT5744 nd173 nd174 1.492570375327e+05
RINT5745 nd174 nd175 1.378139979885e+05
RINT5746 nd175 nd176 1.813887608904e+02
RINT5747 nd176 nd177 3.109521615265e+01
RINT5748 nd177 nd178 3.109521615265e+01
RINT5749 nd178 nd179 3.109521615265e+01
RINT5750 nd180 nd181 1.356896796877e+03
RINT5751 nd181 nd182 1.417729811987e+03
RINT5752 nd182 nd183 1.263010185334e+04
RINT5753 nd183 nd184 8.754377661567e+04
RINT5754 nd184 nd185 1.188094111213e+05
RINT5755 nd185 nd186 8.754377661567e+04
RINT5756 nd186 nd187 8.754377661567e+04
RINT5757 nd187 nd188 8.754377661567e+04
RINT5758 nd188 nd189 8.754377661567e+04
RINT5759 nd189 nd190 8.754377661567e+04
RINT5760 nd190 nd191 8.754377661567e+04
RINT5761 nd191 nd192 5.627814211007e+05
RINT5762 nd192 nd193 5.196348454830e+05
RINT5763 nd193 nd194 6.839357548099e+02
RINT5764 nd194 nd195 1.172461293960e+02
RINT5765 nd195 nd196 1.172461293960e+02
RINT5766 nd196 nd197 1.172461293960e+02
RINT5767 nd198 nd199 5.341744236015e+04
RINT5768 nd199 nd200 5.581227746162e+04
RINT5769 nd200 nd201 4.972137448526e+05
RINT5770 nd201 nd202 3.446367219762e+06
RINT5771 nd202 nd203 4.677212655391e+06
RINT5772 nd203 nd204 3.446367219762e+06
RINT5773 nd204 nd205 3.446367219762e+06
RINT5774 nd205 nd206 3.446367219762e+06
RINT5775 nd206 nd207 3.446367219762e+06
RINT5776 nd207 nd208 3.446367219762e+06
RINT5777 nd208 nd209 3.446367219762e+06
RINT5778 nd209 nd210 2.215521784133e+07
RINT5779 nd210 nd211 2.045665114016e+07
RINT5780 nd211 nd212 2.692474390439e+04
RINT5781 nd212 nd213 4.615670383610e+03
RINT5782 nd213 nd214 4.615670383610e+03
RINT5783 nd214 nd215 4.615670383610e+03
RINT5784 nd216 nd217 2.187171135207e+04
RINT5785 nd217 nd218 2.285227387549e+04
RINT5786 nd218 nd219 2.035836054145e+05
RINT5787 nd219 nd220 1.411111159828e+06
RINT5788 nd220 nd221 1.915079431195e+06
RINT5789 nd221 nd222 1.411111159828e+06
RINT5790 nd222 nd223 1.411111159828e+06
RINT5791 nd223 nd224 1.411111159828e+06
RINT5792 nd224 nd225 1.411111159828e+06
RINT5793 nd225 nd226 1.411111159828e+06
RINT5794 nd226 nd227 1.411111159828e+06
RINT5795 nd227 nd228 9.071428884609e+06
RINT5796 nd228 nd229 8.375952670122e+06
RINT5797 nd229 nd230 1.102430593616e+04
RINT5798 nd230 nd231 1.889881017627e+03
RINT5799 nd231 nd232 1.889881017627e+03
RINT5800 nd232 nd233 1.889881017627e+03
RINT5801 nd234 nd235 5.555635998373e+02
RINT5802 nd235 nd236 5.804708801413e+02
RINT5803 nd236 nd237 1.307161107384e+02
RINT5804 nd237 nd238 5.600570520531e+02
RINT5805 nd238 nd239 7.600774277863e+02
RINT5806 nd239 nd240 5.600570520531e+02
RINT5807 nd240 nd241 5.600570520531e+02
RINT5808 nd241 nd242 5.600570520531e+02
RINT5809 nd242 nd243 5.600570520531e+02
RINT5810 nd243 nd244 5.600570520531e+02
RINT5811 nd244 nd245 5.600570520531e+02
RINT5812 nd245 nd246 3.600366763198e+03
RINT5813 nd246 nd247 3.576364318110e+03
RINT5814 nd247 nd248 2.800285260265e+02
RINT5815 nd248 nd249 4.800489017598e+01
RINT5816 nd249 nd250 4.800489017598e+01
RINT5817 nd250 nd251 4.800489017598e+01
RINT5818 nd252 nd253 1.473427763669e+02
RINT5819 nd253 nd254 1.539485148149e+02
RINT5820 nd254 nd255 3.466763243260e+01
RINT5821 nd255 nd256 1.485344990161e+02
RINT5822 nd256 nd257 2.015825343789e+02
RINT5823 nd257 nd258 1.485344990161e+02
RINT5824 nd258 nd259 1.485344990161e+02
RINT5825 nd259 nd260 1.485344990161e+02
RINT5826 nd260 nd261 1.485344990161e+02
RINT5827 nd261 nd262 1.485344990161e+02
RINT5828 nd262 nd263 1.485344990161e+02
RINT5829 nd263 nd264 9.548646365318e+02
RINT5830 nd264 nd265 9.484988722882e+02
RINT5831 nd265 nd266 7.426724950803e+01
RINT5832 nd266 nd267 1.273152848709e+01
RINT5833 nd267 nd268 1.273152848709e+01
RINT5834 nd268 nd269 1.273152848709e+01
RINT5835 nd270 nd271 1.473427763669e+02
RINT5836 nd271 nd272 1.539485148149e+02
RINT5837 nd272 nd273 3.466763243260e+01
RINT5838 nd273 nd274 1.485344990161e+02
RINT5839 nd274 nd275 2.015825343789e+02
RINT5840 nd275 nd276 1.485344990161e+02
RINT5841 nd276 nd277 1.485344990161e+02
RINT5842 nd277 nd278 1.485344990161e+02
RINT5843 nd278 nd279 1.485344990161e+02
RINT5844 nd279 nd280 1.485344990161e+02
RINT5845 nd280 nd281 1.485344990161e+02
RINT5846 nd281 nd282 9.548646365318e+02
RINT5847 nd282 nd283 9.484988722882e+02
RINT5848 nd283 nd284 7.426724950803e+01
RINT5849 nd284 nd285 1.273152848709e+01
RINT5850 nd285 nd286 1.273152848709e+01
RINT5851 nd286 nd287 1.273152848709e+01
RINT5852 nd288 nd289 2.402441725655e+03
RINT5853 nd289 nd290 2.510149087139e+03
RINT5854 nd290 nd291 5.652599247780e+02
RINT5855 nd291 nd292 2.421872907069e+03
RINT5856 nd292 nd293 3.286827516737e+03
RINT5857 nd293 nd294 2.421872907069e+03
RINT5858 nd294 nd295 2.421872907069e+03
RINT5859 nd295 nd296 2.421872907069e+03
RINT5860 nd296 nd297 2.421872907069e+03
RINT5861 nd297 nd298 2.421872907069e+03
RINT5862 nd298 nd299 2.421872907069e+03
RINT5863 nd299 nd300 1.556918297402e+04
RINT5864 nd300 nd301 1.546538842086e+04
RINT5865 nd301 nd302 1.210936453535e+03
RINT5866 nd302 nd303 2.075891063202e+02
RINT5867 nd303 nd304 2.075891063202e+02
RINT5868 nd304 nd305 2.075891063202e+02
RINT5869 nd306 nd307 1.300917539661e+02
RINT5870 nd307 nd308 1.359240867219e+02
RINT5871 nd308 nd309 1.225018928626e+01
RINT5872 nd309 nd310 1.878240669084e+00
RINT5873 nd310 nd311 3.819334482112e+00
RINT5874 nd311 nd312 4.634835007103e+00
RINT5875 nd312 nd313 4.634835007103e+00
RINT5876 nd313 nd314 4.634835007103e+00
RINT5877 nd314 nd315 4.634835007103e+00
RINT5878 nd315 nd316 4.634835007103e+00
RINT5879 nd316 nd317 4.634835007103e+00
RINT5880 nd317 nd318 1.414697587132e+01
RINT5881 nd318 nd319 7.178107776196e+01
RINT5882 nd319 nd320 6.557197433740e+01
RINT5883 nd320 nd321 1.124090988641e+01
RINT5884 nd321 nd322 1.124090988641e+01
RINT5885 nd322 nd323 1.124090988641e+01
RINT5886 nd324 nd325 1.300917539661e+02
RINT5887 nd325 nd326 1.359240867219e+02
RINT5888 nd326 nd327 1.225018928626e+01
RINT5889 nd327 nd328 1.878240669084e+00
RINT5890 nd328 nd329 3.819334482112e+00
RINT5891 nd329 nd330 4.634835007103e+00
RINT5892 nd330 nd331 4.634835007103e+00
RINT5893 nd331 nd332 4.634835007103e+00
RINT5894 nd332 nd333 4.634835007103e+00
RINT5895 nd333 nd334 4.634835007103e+00
RINT5896 nd334 nd335 4.634835007103e+00
RINT5897 nd335 nd336 1.414697587132e+01
RINT5898 nd336 nd337 7.178107776196e+01
RINT5899 nd337 nd338 6.557197433740e+01
RINT5900 nd338 nd339 1.124090988641e+01
RINT5901 nd339 nd340 1.124090988641e+01
RINT5902 nd340 nd341 1.124090988641e+01
RINT5903 nd342 nd343 2.402449448537e+03
RINT5904 nd343 nd344 2.510157156257e+03
RINT5905 nd344 nd345 5.652617418608e+02
RINT5906 nd345 nd346 2.421880692414e+03
RINT5907 nd346 nd347 3.286838082562e+03
RINT5908 nd347 nd348 2.421880692414e+03
RINT5909 nd348 nd349 2.421880692414e+03
RINT5910 nd349 nd350 2.421880692414e+03
RINT5911 nd350 nd351 2.421880692414e+03
RINT5912 nd351 nd352 2.421880692414e+03
RINT5913 nd352 nd353 2.421880692414e+03
RINT5914 nd353 nd354 1.556923302266e+04
RINT5915 nd354 nd355 1.546543813585e+04
RINT5916 nd355 nd356 1.210940346207e+03
RINT5917 nd356 nd357 2.075897736355e+02
RINT5918 nd357 nd358 2.075897736355e+02
RINT5919 nd358 nd359 2.075897736355e+02
RINT5920 nd360 nd361 1.473427763669e+02
RINT5921 nd361 nd362 1.539485148149e+02
RINT5922 nd362 nd363 3.466763243260e+01
RINT5923 nd363 nd364 1.485344990161e+02
RINT5924 nd364 nd365 2.015825343789e+02
RINT5925 nd365 nd366 1.485344990161e+02
RINT5926 nd366 nd367 1.485344990161e+02
RINT5927 nd367 nd368 1.485344990161e+02
RINT5928 nd368 nd369 1.485344990161e+02
RINT5929 nd369 nd370 1.485344990161e+02
RINT5930 nd370 nd371 1.485344990161e+02
RINT5931 nd371 nd372 9.548646365318e+02
RINT5932 nd372 nd373 9.484988722882e+02
RINT5933 nd373 nd374 7.426724950803e+01
RINT5934 nd374 nd375 1.273152848709e+01
RINT5935 nd375 nd376 1.273152848709e+01
RINT5936 nd376 nd377 1.273152848709e+01
RINT5937 nd378 nd379 1.473427763669e+02
RINT5938 nd379 nd380 1.539485148149e+02
RINT5939 nd380 nd381 3.466763243260e+01
RINT5940 nd381 nd382 1.485344990161e+02
RINT5941 nd382 nd383 2.015825343789e+02
RINT5942 nd383 nd384 1.485344990161e+02
RINT5943 nd384 nd385 1.485344990161e+02
RINT5944 nd385 nd386 1.485344990161e+02
RINT5945 nd386 nd387 1.485344990161e+02
RINT5946 nd387 nd388 1.485344990161e+02
RINT5947 nd388 nd389 1.485344990161e+02
RINT5948 nd389 nd390 9.548646365318e+02
RINT5949 nd390 nd391 9.484988722882e+02
RINT5950 nd391 nd392 7.426724950803e+01
RINT5951 nd392 nd393 1.273152848709e+01
RINT5952 nd393 nd394 1.273152848709e+01
RINT5953 nd394 nd395 1.273152848709e+01
RINT5954 nd396 nd397 5.555635998373e+02
RINT5955 nd397 nd398 5.804708801413e+02
RINT5956 nd398 nd399 1.307161107384e+02
RINT5957 nd399 nd400 5.600570520531e+02
RINT5958 nd400 nd401 7.600774277863e+02
RINT5959 nd401 nd402 5.600570520531e+02
RINT5960 nd402 nd403 5.600570520531e+02
RINT5961 nd403 nd404 5.600570520531e+02
RINT5962 nd404 nd405 5.600570520531e+02
RINT5963 nd405 nd406 5.600570520531e+02
RINT5964 nd406 nd407 5.600570520531e+02
RINT5965 nd407 nd408 3.600366763198e+03
RINT5966 nd408 nd409 3.576364318110e+03
RINT5967 nd409 nd410 2.800285260265e+02
RINT5968 nd410 nd411 4.800489017598e+01
RINT5969 nd411 nd412 4.800489017598e+01
RINT5970 nd412 nd413 4.800489017598e+01
RINT5971 nd414 nd415 2.187107128560e+04
RINT5972 nd415 nd416 2.285160511327e+04
RINT5973 nd416 nd417 2.035776476255e+05
RINT5974 nd417 nd418 1.411069864251e+06
RINT5975 nd418 nd419 1.915023387198e+06
RINT5976 nd419 nd420 1.411069864251e+06
RINT5977 nd420 nd421 1.411069864251e+06
RINT5978 nd421 nd422 1.411069864251e+06
RINT5979 nd422 nd423 1.411069864251e+06
RINT5980 nd423 nd424 1.411069864251e+06
RINT5981 nd424 nd425 1.411069864251e+06
RINT5982 nd425 nd426 9.071163413043e+06
RINT5983 nd426 nd427 8.375707551376e+06
RINT5984 nd427 nd428 1.102398331446e+04
RINT5985 nd428 nd429 1.889825711051e+03
RINT5986 nd429 nd430 1.889825711051e+03
RINT5987 nd430 nd431 1.889825711051e+03
RINT5988 nd432 nd433 8.432218599453e+01
RINT5989 nd433 nd434 8.810255663623e+01
RINT5990 nd434 nd435 7.848775235218e+02
RINT5991 nd435 nd436 5.440268288230e+03
RINT5992 nd436 nd437 7.383221248312e+03
RINT5993 nd437 nd438 5.440268288230e+03
RINT5994 nd438 nd439 5.440268288230e+03
RINT5995 nd439 nd440 5.440268288230e+03
RINT5996 nd440 nd441 5.440268288230e+03
RINT5997 nd441 nd442 5.440268288230e+03
RINT5998 nd442 nd443 5.440268288230e+03
RINT5999 nd443 nd444 3.497315328148e+04
RINT6000 nd444 nd445 3.229187819656e+04
RINT6001 nd445 nd446 4.250209600179e+01
RINT6002 nd446 nd447 7.286073600307e+00
RINT6003 nd447 nd448 7.286073600307e+00
RINT6004 nd448 nd449 7.286073600307e+00
RINT6005 nd450 nd451 2.141868847992e+00
RINT6006 nd451 nd452 2.237894087563e+00
RINT6007 nd452 nd453 2.016907145482e-01
RINT6008 nd453 nd454 3.092390605473e-02
RINT6009 nd454 nd455 6.288264473266e-02
RINT6010 nd455 nd456 7.630928490583e-02
RINT6011 nd456 nd457 7.630928490583e-02
RINT6012 nd457 nd458 7.630928490583e-02
RINT6013 nd458 nd459 7.630928490583e-02
RINT6014 nd459 nd460 7.630928490583e-02
RINT6015 nd460 nd461 7.630928490583e-02
RINT6016 nd461 nd462 2.329199660109e-01
RINT6017 nd462 nd463 1.181824747891e+00
RINT6018 nd463 nd464 1.079596245364e+00
RINT6019 nd464 nd465 1.850736420624e-01
RINT6020 nd465 nd466 1.850736420624e-01
RINT6021 nd466 nd467 1.850736420624e-01
RINT6022 nd468 nd469 5.680517995949e-01
RINT6023 nd469 nd470 5.935189565574e-01
RINT6024 nd470 nd471 5.349103119367e-02
RINT6025 nd471 nd472 8.201426759329e-03
RINT6026 nd472 nd473 1.667730474588e-02
RINT6027 nd473 nd474 2.023822637749e-02
RINT6028 nd474 nd475 2.023822637749e-02
RINT6029 nd475 nd476 2.023822637749e-02
RINT6030 nd476 nd477 2.023822637749e-02
RINT6031 nd477 nd478 2.023822637749e-02
RINT6032 nd478 nd479 2.023822637749e-02
RINT6033 nd479 nd480 6.177343957269e-02
RINT6034 nd480 nd481 3.134354727063e-01
RINT6035 nd481 nd482 2.863231287901e-01
RINT6036 nd482 nd483 4.908396493544e-02
RINT6037 nd483 nd484 4.908396493544e-02
RINT6038 nd484 nd485 4.908396493544e-02
RINT6039 nd486 nd487 5.680517995949e-01
RINT6040 nd487 nd488 5.935189565574e-01
RINT6041 nd488 nd489 5.349103119367e-02
RINT6042 nd489 nd490 8.201426759329e-03
RINT6043 nd490 nd491 1.667730474588e-02
RINT6044 nd491 nd492 2.023822637749e-02
RINT6045 nd492 nd493 2.023822637749e-02
RINT6046 nd493 nd494 2.023822637749e-02
RINT6047 nd494 nd495 2.023822637749e-02
RINT6048 nd495 nd496 2.023822637749e-02
RINT6049 nd496 nd497 2.023822637749e-02
RINT6050 nd497 nd498 6.177343957269e-02
RINT6051 nd498 nd499 3.134354727063e-01
RINT6052 nd499 nd500 2.863231287901e-01
RINT6053 nd500 nd501 4.908396493544e-02
RINT6054 nd501 nd502 4.908396493544e-02
RINT6055 nd502 nd503 4.908396493544e-02
RINT6056 nd504 nd505 9.262153051071e+00
RINT6057 nd505 nd506 9.677398114516e+00
RINT6058 nd506 nd507 2.179251168102e+00
RINT6059 nd507 nd508 9.337066242221e+00
RINT6060 nd508 nd509 1.267173275730e+01
RINT6061 nd509 nd510 9.337066242221e+00
RINT6062 nd510 nd511 9.337066242221e+00
RINT6063 nd511 nd512 9.337066242221e+00
RINT6064 nd512 nd513 9.337066242221e+00
RINT6065 nd513 nd514 9.337066242221e+00
RINT6066 nd514 nd515 9.337066242221e+00
RINT6067 nd515 nd516 6.002399727142e+01
RINT6068 nd516 nd517 5.962383728961e+01
RINT6069 nd517 nd518 4.668533121110e+00
RINT6070 nd518 nd519 8.003199636189e-01
RINT6071 nd519 nd520 8.003199636189e-01
RINT6072 nd520 nd521 8.003199636189e-01
RINT6073 nd522 nd523 5.015437931537e-01
RINT6074 nd523 nd524 5.240292328847e-01
RINT6075 nd524 nd525 4.722825401436e-02
RINT6076 nd525 nd526 7.241196470252e-03
RINT6077 nd526 nd527 1.472471117563e-02
RINT6078 nd527 nd528 1.786871695735e-02
RINT6079 nd528 nd529 1.786871695735e-02
RINT6080 nd529 nd530 1.786871695735e-02
RINT6081 nd530 nd531 1.786871695735e-02
RINT6082 nd531 nd532 1.786871695735e-02
RINT6083 nd532 nd533 1.786871695735e-02
RINT6084 nd533 nd534 5.454095070473e-02
RINT6085 nd534 nd535 2.767381707129e-01
RINT6086 nd535 nd536 2.528001639700e-01
RINT6087 nd536 nd537 4.333717096628e-02
RINT6088 nd537 nd538 4.333717096628e-02
RINT6089 nd538 nd539 4.333717096628e-02
RINT6090 nd540 nd541 5.015437931537e-01
RINT6091 nd541 nd542 5.240292328847e-01
RINT6092 nd542 nd543 4.722825401436e-02
RINT6093 nd543 nd544 7.241196470252e-03
RINT6094 nd544 nd545 1.472471117563e-02
RINT6095 nd545 nd546 1.786871695735e-02
RINT6096 nd546 nd547 1.786871695735e-02
RINT6097 nd547 nd548 1.786871695735e-02
RINT6098 nd548 nd549 1.786871695735e-02
RINT6099 nd549 nd550 1.786871695735e-02
RINT6100 nd550 nd551 1.786871695735e-02
RINT6101 nd551 nd552 5.454095070473e-02
RINT6102 nd552 nd553 2.767381707129e-01
RINT6103 nd553 nd554 2.528001639700e-01
RINT6104 nd554 nd555 4.333717096628e-02
RINT6105 nd555 nd556 4.333717096628e-02
RINT6106 nd556 nd557 4.333717096628e-02
RINT6107 nd558 nd559 9.262182825159e+00
RINT6108 nd559 nd560 9.677429223449e+00
RINT6109 nd560 nd561 2.179258173516e+00
RINT6110 nd561 nd562 9.337096257125e+00
RINT6111 nd562 nd563 1.267177349181e+01
RINT6112 nd563 nd564 9.337096257125e+00
RINT6113 nd564 nd565 9.337096257125e+00
RINT6114 nd565 nd566 9.337096257125e+00
RINT6115 nd566 nd567 9.337096257125e+00
RINT6116 nd567 nd568 9.337096257125e+00
RINT6117 nd568 nd569 9.337096257125e+00
RINT6118 nd569 nd570 6.002419022437e+01
RINT6119 nd570 nd571 5.962402895621e+01
RINT6120 nd571 nd572 4.668548128562e+00
RINT6121 nd572 nd573 8.003225363250e-01
RINT6122 nd573 nd574 8.003225363250e-01
RINT6123 nd574 nd575 8.003225363250e-01
RINT6124 nd576 nd577 5.680517995949e-01
RINT6125 nd577 nd578 5.935189565574e-01
RINT6126 nd578 nd579 5.349103119367e-02
RINT6127 nd579 nd580 8.201426759329e-03
RINT6128 nd580 nd581 1.667730474588e-02
RINT6129 nd581 nd582 2.023822637749e-02
RINT6130 nd582 nd583 2.023822637749e-02
RINT6131 nd583 nd584 2.023822637749e-02
RINT6132 nd584 nd585 2.023822637749e-02
RINT6133 nd585 nd586 2.023822637749e-02
RINT6134 nd586 nd587 2.023822637749e-02
RINT6135 nd587 nd588 6.177343957269e-02
RINT6136 nd588 nd589 3.134354727063e-01
RINT6137 nd589 nd590 2.863231287901e-01
RINT6138 nd590 nd591 4.908396493544e-02
RINT6139 nd591 nd592 4.908396493544e-02
RINT6140 nd592 nd593 4.908396493544e-02
RINT6141 nd594 nd595 5.680517995949e-01
RINT6142 nd595 nd596 5.935189565574e-01
RINT6143 nd596 nd597 5.349103119367e-02
RINT6144 nd597 nd598 8.201426759329e-03
RINT6145 nd598 nd599 1.667730474588e-02
RINT6146 nd599 nd600 2.023822637749e-02
RINT6147 nd600 nd601 2.023822637749e-02
RINT6148 nd601 nd602 2.023822637749e-02
RINT6149 nd602 nd603 2.023822637749e-02
RINT6150 nd603 nd604 2.023822637749e-02
RINT6151 nd604 nd605 2.023822637749e-02
RINT6152 nd605 nd606 6.177343957269e-02
RINT6153 nd606 nd607 3.134354727063e-01
RINT6154 nd607 nd608 2.863231287901e-01
RINT6155 nd608 nd609 4.908396493544e-02
RINT6156 nd609 nd610 4.908396493544e-02
RINT6157 nd610 nd611 4.908396493544e-02
RINT6158 nd612 nd613 2.141868847992e+00
RINT6159 nd613 nd614 2.237894087563e+00
RINT6160 nd614 nd615 2.016907145482e-01
RINT6161 nd615 nd616 3.092390605473e-02
RINT6162 nd616 nd617 6.288264473266e-02
RINT6163 nd617 nd618 7.630928490583e-02
RINT6164 nd618 nd619 7.630928490583e-02
RINT6165 nd619 nd620 7.630928490583e-02
RINT6166 nd620 nd621 7.630928490583e-02
RINT6167 nd621 nd622 7.630928490583e-02
RINT6168 nd622 nd623 7.630928490583e-02
RINT6169 nd623 nd624 2.329199660109e-01
RINT6170 nd624 nd625 1.181824747891e+00
RINT6171 nd625 nd626 1.079596245364e+00
RINT6172 nd626 nd627 1.850736420624e-01
RINT6173 nd627 nd628 1.850736420624e-01
RINT6174 nd628 nd629 1.850736420624e-01
RINT6175 nd630 nd631 8.431971834108e+01
RINT6176 nd631 nd632 8.809997835181e+01
RINT6177 nd632 nd633 7.848545544098e+02
RINT6178 nd633 nd634 5.440109081057e+03
RINT6179 nd634 nd635 7.383005181435e+03
RINT6180 nd635 nd636 5.440109081057e+03
RINT6181 nd636 nd637 5.440109081057e+03
RINT6182 nd637 nd638 5.440109081057e+03
RINT6183 nd638 nd639 5.440109081057e+03
RINT6184 nd639 nd640 5.440109081057e+03
RINT6185 nd640 nd641 5.440109081057e+03
RINT6186 nd641 nd642 3.497212980680e+04
RINT6187 nd642 nd643 3.229093318827e+04
RINT6188 nd643 nd644 4.250085219576e+01
RINT6189 nd644 nd645 7.285860376416e+00
RINT6190 nd645 nd646 7.285860376416e+00
RINT6191 nd646 nd647 7.285860376416e+00
RINT6192 nd648 nd649 2.187171135207e+04
RINT6193 nd649 nd650 2.285227387549e+04
RINT6194 nd650 nd651 2.035836054145e+05
RINT6195 nd651 nd652 1.411111159828e+06
RINT6196 nd652 nd653 1.915079431195e+06
RINT6197 nd653 nd654 1.411111159828e+06
RINT6198 nd654 nd655 1.411111159828e+06
RINT6199 nd655 nd656 1.411111159828e+06
RINT6200 nd656 nd657 1.411111159828e+06
RINT6201 nd657 nd658 1.411111159828e+06
RINT6202 nd658 nd659 1.411111159828e+06
RINT6203 nd659 nd660 9.071428884609e+06
RINT6204 nd660 nd661 8.375952670122e+06
RINT6205 nd661 nd662 1.102430593616e+04
RINT6206 nd662 nd663 1.889881017627e+03
RINT6207 nd663 nd664 1.889881017627e+03
RINT6208 nd664 nd665 1.889881017627e+03
RINT6209 nd666 nd667 5.555635998373e+02
RINT6210 nd667 nd668 5.804708801413e+02
RINT6211 nd668 nd669 5.231507033365e+01
RINT6212 nd669 nd670 8.021124442285e+00
RINT6213 nd670 nd671 1.631066650403e+01
RINT6214 nd671 nd672 1.979330390049e+01
RINT6215 nd672 nd673 1.979330390049e+01
RINT6216 nd673 nd674 1.979330390049e+01
RINT6217 nd674 nd675 1.979330390049e+01
RINT6218 nd675 nd676 1.979330390049e+01
RINT6219 nd676 nd677 1.979330390049e+01
RINT6220 nd677 nd678 6.041539607446e+01
RINT6221 nd678 nd679 3.065448250628e+02
RINT6222 nd679 nd680 2.800285260265e+02
RINT6223 nd680 nd681 4.800489017598e+01
RINT6224 nd681 nd682 4.800489017598e+01
RINT6225 nd682 nd683 4.800489017598e+01
RINT6226 nd684 nd685 1.473427763669e+02
RINT6227 nd685 nd686 1.539485148149e+02
RINT6228 nd686 nd687 1.387464497503e+01
RINT6229 nd687 nd688 2.127307738047e+00
RINT6230 nd688 nd689 4.325803360412e+00
RINT6231 nd689 nd690 5.249444619890e+00
RINT6232 nd690 nd691 5.249444619890e+00
RINT6233 nd691 nd692 5.249444619890e+00
RINT6234 nd692 nd693 5.249444619890e+00
RINT6235 nd693 nd694 5.249444619890e+00
RINT6236 nd694 nd695 5.249444619890e+00
RINT6237 nd695 nd696 1.602295793952e+01
RINT6238 nd696 nd697 8.129972089405e+01
RINT6239 nd697 nd698 7.426724950803e+01
RINT6240 nd698 nd699 1.273152848709e+01
RINT6241 nd699 nd700 1.273152848709e+01
RINT6242 nd700 nd701 1.273152848709e+01
RINT6243 nd702 nd703 1.473427763669e+02
RINT6244 nd703 nd704 1.539485148149e+02
RINT6245 nd704 nd705 1.387464497503e+01
RINT6246 nd705 nd706 2.127307738047e+00
RINT6247 nd706 nd707 4.325803360412e+00
RINT6248 nd707 nd708 5.249444619890e+00
RINT6249 nd708 nd709 5.249444619890e+00
RINT6250 nd709 nd710 5.249444619890e+00
RINT6251 nd710 nd711 5.249444619890e+00
RINT6252 nd711 nd712 5.249444619890e+00
RINT6253 nd712 nd713 5.249444619890e+00
RINT6254 nd713 nd714 1.602295793952e+01
RINT6255 nd714 nd715 8.129972089405e+01
RINT6256 nd715 nd716 7.426724950803e+01
RINT6257 nd716 nd717 1.273152848709e+01
RINT6258 nd717 nd718 1.273152848709e+01
RINT6259 nd718 nd719 1.273152848709e+01
RINT6260 nd720 nd721 2.402441725655e+03
RINT6261 nd721 nd722 2.510149087139e+03
RINT6262 nd722 nd723 5.652599247780e+02
RINT6263 nd723 nd724 2.421872907069e+03
RINT6264 nd724 nd725 3.286827516737e+03
RINT6265 nd725 nd726 2.421872907069e+03
RINT6266 nd726 nd727 2.421872907069e+03
RINT6267 nd727 nd728 2.421872907069e+03
RINT6268 nd728 nd729 2.421872907069e+03
RINT6269 nd729 nd730 2.421872907069e+03
RINT6270 nd730 nd731 2.421872907069e+03
RINT6271 nd731 nd732 1.556918297402e+04
RINT6272 nd732 nd733 1.546538842086e+04
RINT6273 nd733 nd734 1.210936453535e+03
RINT6274 nd734 nd735 2.075891063202e+02
RINT6275 nd735 nd736 2.075891063202e+02
RINT6276 nd736 nd737 2.075891063202e+02
RINT6277 nd738 nd739 1.300917539661e+02
RINT6278 nd739 nd740 1.359240867219e+02
RINT6279 nd740 nd741 3.060871540642e+01
RINT6280 nd741 nd742 1.311439486748e+02
RINT6281 nd742 nd743 1.779810732015e+02
RINT6282 nd743 nd744 1.311439486748e+02
RINT6283 nd744 nd745 1.311439486748e+02
RINT6284 nd745 nd746 1.311439486748e+02
RINT6285 nd746 nd747 1.311439486748e+02
RINT6286 nd747 nd748 1.311439486748e+02
RINT6287 nd748 nd749 1.311439486748e+02
RINT6288 nd749 nd750 8.430682414809e+02
RINT6289 nd750 nd751 8.374477865377e+02
RINT6290 nd751 nd752 6.557197433740e+01
RINT6291 nd752 nd753 1.124090988641e+01
RINT6292 nd753 nd754 1.124090988641e+01
RINT6293 nd754 nd755 1.124090988641e+01
RINT6294 nd756 nd757 1.300917539661e+02
RINT6295 nd757 nd758 1.359240867219e+02
RINT6296 nd758 nd759 3.060871540642e+01
RINT6297 nd759 nd760 1.311439486748e+02
RINT6298 nd760 nd761 1.779810732015e+02
RINT6299 nd761 nd762 1.311439486748e+02
RINT6300 nd762 nd763 1.311439486748e+02
RINT6301 nd763 nd764 1.311439486748e+02
RINT6302 nd764 nd765 1.311439486748e+02
RINT6303 nd765 nd766 1.311439486748e+02
RINT6304 nd766 nd767 1.311439486748e+02
RINT6305 nd767 nd768 8.430682414809e+02
RINT6306 nd768 nd769 8.374477865377e+02
RINT6307 nd769 nd770 6.557197433740e+01
RINT6308 nd770 nd771 1.124090988641e+01
RINT6309 nd771 nd772 1.124090988641e+01
RINT6310 nd772 nd773 1.124090988641e+01
RINT6311 nd774 nd775 2.402449448537e+03
RINT6312 nd775 nd776 2.510157156257e+03
RINT6313 nd776 nd777 5.652617418608e+02
RINT6314 nd777 nd778 2.421880692414e+03
RINT6315 nd778 nd779 3.286838082562e+03
RINT6316 nd779 nd780 2.421880692414e+03
RINT6317 nd780 nd781 2.421880692414e+03
RINT6318 nd781 nd782 2.421880692414e+03
RINT6319 nd782 nd783 2.421880692414e+03
RINT6320 nd783 nd784 2.421880692414e+03
RINT6321 nd784 nd785 2.421880692414e+03
RINT6322 nd785 nd786 1.556923302266e+04
RINT6323 nd786 nd787 1.546543813585e+04
RINT6324 nd787 nd788 1.210940346207e+03
RINT6325 nd788 nd789 2.075897736355e+02
RINT6326 nd789 nd790 2.075897736355e+02
RINT6327 nd790 nd791 2.075897736355e+02
RINT6328 nd792 nd793 1.473427763669e+02
RINT6329 nd793 nd794 1.539485148149e+02
RINT6330 nd794 nd795 1.387464497503e+01
RINT6331 nd795 nd796 2.127307738047e+00
RINT6332 nd796 nd797 4.325803360412e+00
RINT6333 nd797 nd798 5.249444619890e+00
RINT6334 nd798 nd799 5.249444619890e+00
RINT6335 nd799 nd800 5.249444619890e+00
RINT6336 nd800 nd801 5.249444619890e+00
RINT6337 nd801 nd802 5.249444619890e+00
RINT6338 nd802 nd803 5.249444619890e+00
RINT6339 nd803 nd804 1.602295793952e+01
RINT6340 nd804 nd805 8.129972089405e+01
RINT6341 nd805 nd806 7.426724950803e+01
RINT6342 nd806 nd807 1.273152848709e+01
RINT6343 nd807 nd808 1.273152848709e+01
RINT6344 nd808 nd809 1.273152848709e+01
RINT6345 nd810 nd811 1.473427763669e+02
RINT6346 nd811 nd812 1.539485148149e+02
RINT6347 nd812 nd813 1.387464497503e+01
RINT6348 nd813 nd814 2.127307738047e+00
RINT6349 nd814 nd815 4.325803360412e+00
RINT6350 nd815 nd816 5.249444619890e+00
RINT6351 nd816 nd817 5.249444619890e+00
RINT6352 nd817 nd818 5.249444619890e+00
RINT6353 nd818 nd819 5.249444619890e+00
RINT6354 nd819 nd820 5.249444619890e+00
RINT6355 nd820 nd821 5.249444619890e+00
RINT6356 nd821 nd822 1.602295793952e+01
RINT6357 nd822 nd823 8.129972089405e+01
RINT6358 nd823 nd824 7.426724950803e+01
RINT6359 nd824 nd825 1.273152848709e+01
RINT6360 nd825 nd826 1.273152848709e+01
RINT6361 nd826 nd827 1.273152848709e+01
RINT6362 nd828 nd829 5.555635998373e+02
RINT6363 nd829 nd830 5.804708801413e+02
RINT6364 nd830 nd831 5.231507033365e+01
RINT6365 nd831 nd832 8.021124442285e+00
RINT6366 nd832 nd833 1.631066650403e+01
RINT6367 nd833 nd834 1.979330390049e+01
RINT6368 nd834 nd835 1.979330390049e+01
RINT6369 nd835 nd836 1.979330390049e+01
RINT6370 nd836 nd837 1.979330390049e+01
RINT6371 nd837 nd838 1.979330390049e+01
RINT6372 nd838 nd839 1.979330390049e+01
RINT6373 nd839 nd840 6.041539607446e+01
RINT6374 nd840 nd841 3.065448250628e+02
RINT6375 nd841 nd842 2.800285260265e+02
RINT6376 nd842 nd843 4.800489017598e+01
RINT6377 nd843 nd844 4.800489017598e+01
RINT6378 nd844 nd845 4.800489017598e+01
RINT6379 nd846 nd847 2.187107128560e+04
RINT6380 nd847 nd848 2.285160511327e+04
RINT6381 nd848 nd849 2.035776476255e+05
RINT6382 nd849 nd850 1.411069864251e+06
RINT6383 nd850 nd851 1.915023387198e+06
RINT6384 nd851 nd852 1.411069864251e+06
RINT6385 nd852 nd853 1.411069864251e+06
RINT6386 nd853 nd854 1.411069864251e+06
RINT6387 nd854 nd855 1.411069864251e+06
RINT6388 nd855 nd856 1.411069864251e+06
RINT6389 nd856 nd857 1.411069864251e+06
RINT6390 nd857 nd858 9.071163413043e+06
RINT6391 nd858 nd859 8.375707551376e+06
RINT6392 nd859 nd860 1.102398331446e+04
RINT6393 nd860 nd861 1.889825711051e+03
RINT6394 nd861 nd862 1.889825711051e+03
RINT6395 nd862 nd863 1.889825711051e+03
RINT6396 nd864 nd865 1.864708536256e+03
RINT6397 nd865 nd866 1.948307998517e+03
RINT6398 nd866 nd867 1.735685336860e+04
RINT6399 nd867 nd868 1.203065906906e+05
RINT6400 nd868 nd869 1.632732302230e+05
RINT6401 nd869 nd870 1.203065906906e+05
RINT6402 nd870 nd871 1.203065906906e+05
RINT6403 nd871 nd872 1.203065906906e+05
RINT6404 nd872 nd873 1.203065906906e+05
RINT6405 nd873 nd874 1.203065906906e+05
RINT6406 nd874 nd875 1.203065906906e+05
RINT6407 nd875 nd876 7.733995115827e+05
RINT6408 nd876 nd877 7.141055490281e+05
RINT6409 nd877 nd878 9.398952397707e+02
RINT6410 nd878 nd879 1.611248982464e+02
RINT6411 nd879 nd880 1.611248982464e+02
RINT6412 nd880 nd881 1.611248982464e+02
RINT6413 nd882 nd883 4.736548367769e+01
RINT6414 nd883 nd884 4.948899461153e+01
RINT6415 nd884 nd885 1.114441588939e+01
RINT6416 nd885 nd886 4.774858029822e+01
RINT6417 nd886 nd887 6.480164469044e+01
RINT6418 nd887 nd888 4.774858029822e+01
RINT6419 nd888 nd889 4.774858029822e+01
RINT6420 nd889 nd890 4.774858029822e+01
RINT6421 nd890 nd891 4.774858029822e+01
RINT6422 nd891 nd892 4.774858029822e+01
RINT6423 nd892 nd893 4.774858029822e+01
RINT6424 nd893 nd894 3.069551590600e+02
RINT6425 nd894 nd895 3.049087913329e+02
RINT6426 nd895 nd896 2.387429014911e+01
RINT6427 nd896 nd897 4.092735454133e+00
RINT6428 nd897 nd898 4.092735454133e+00
RINT6429 nd898 nd899 4.092735454133e+00
RINT6430 nd900 nd901 1.256194947091e+01
RINT6431 nd901 nd902 1.312513251013e+01
RINT6432 nd902 nd903 2.955645723751e+00
RINT6433 nd903 nd904 1.266355173517e+01
RINT6434 nd904 nd905 1.718624878345e+01
RINT6435 nd905 nd906 1.266355173517e+01
RINT6436 nd906 nd907 1.266355173517e+01
RINT6437 nd907 nd908 1.266355173517e+01
RINT6438 nd908 nd909 1.266355173517e+01
RINT6439 nd909 nd910 1.266355173517e+01
RINT6440 nd910 nd911 1.266355173517e+01
RINT6441 nd911 nd912 8.140854686898e+01
RINT6442 nd912 nd913 8.086582322319e+01
RINT6443 nd913 nd914 6.331775867587e+00
RINT6444 nd914 nd915 1.085447291586e+00
RINT6445 nd915 nd916 1.085447291586e+00
RINT6446 nd916 nd917 1.085447291586e+00
RINT6447 nd918 nd919 1.256194947091e+01
RINT6448 nd919 nd920 1.312513251013e+01
RINT6449 nd920 nd921 2.955645723751e+00
RINT6450 nd921 nd922 1.266355173517e+01
RINT6451 nd922 nd923 1.718624878345e+01
RINT6452 nd923 nd924 1.266355173517e+01
RINT6453 nd924 nd925 1.266355173517e+01
RINT6454 nd925 nd926 1.266355173517e+01
RINT6455 nd926 nd927 1.266355173517e+01
RINT6456 nd927 nd928 1.266355173517e+01
RINT6457 nd928 nd929 1.266355173517e+01
RINT6458 nd929 nd930 8.140854686898e+01
RINT6459 nd930 nd931 8.086582322319e+01
RINT6460 nd931 nd932 6.331775867587e+00
RINT6461 nd932 nd933 1.085447291586e+00
RINT6462 nd933 nd934 1.085447291586e+00
RINT6463 nd934 nd935 1.085447291586e+00
RINT6464 nd936 nd937 2.048241000247e+02
RINT6465 nd937 nd938 2.140068673511e+02
RINT6466 nd938 nd939 4.819215972495e+01
RINT6467 nd939 nd940 2.064807371880e+02
RINT6468 nd940 nd941 2.802238576123e+02
RINT6469 nd941 nd942 2.064807371880e+02
RINT6470 nd942 nd943 2.064807371880e+02
RINT6471 nd943 nd944 2.064807371880e+02
RINT6472 nd944 nd945 2.064807371880e+02
RINT6473 nd945 nd946 2.064807371880e+02
RINT6474 nd946 nd947 2.064807371880e+02
RINT6475 nd947 nd948 1.327376167637e+03
RINT6476 nd948 nd949 1.318526993186e+03
RINT6477 nd949 nd950 1.032403685940e+02
RINT6478 nd950 nd951 1.769834890183e+01
RINT6479 nd951 nd952 1.769834890183e+01
RINT6480 nd952 nd953 1.769834890183e+01
RINT6481 nd954 nd955 1.109118533123e+01
RINT6482 nd955 nd956 1.158843040278e+01
RINT6483 nd956 nd957 2.609596111773e+00
RINT6484 nd957 nd958 1.118089191265e+01
RINT6485 nd958 nd959 1.517406759574e+01
RINT6486 nd959 nd960 1.118089191265e+01
RINT6487 nd960 nd961 1.118089191265e+01
RINT6488 nd961 nd962 1.118089191265e+01
RINT6489 nd962 nd963 1.118089191265e+01
RINT6490 nd963 nd964 1.118089191265e+01
RINT6491 nd964 nd965 1.118089191265e+01
RINT6492 nd965 nd966 7.187716229562e+01
RINT6493 nd966 nd967 7.139798121365e+01
RINT6494 nd967 nd968 5.590445956326e+00
RINT6495 nd968 nd969 9.583621639417e-01
RINT6496 nd969 nd970 9.583621639417e-01
RINT6497 nd970 nd971 9.583621639417e-01
RINT6498 nd972 nd973 1.109118533123e+01
RINT6499 nd973 nd974 1.158843040278e+01
RINT6500 nd974 nd975 2.609596111773e+00
RINT6501 nd975 nd976 1.118089191265e+01
RINT6502 nd976 nd977 1.517406759574e+01
RINT6503 nd977 nd978 1.118089191265e+01
RINT6504 nd978 nd979 1.118089191265e+01
RINT6505 nd979 nd980 1.118089191265e+01
RINT6506 nd980 nd981 1.118089191265e+01
RINT6507 nd981 nd982 1.118089191265e+01
RINT6508 nd982 nd983 1.118089191265e+01
RINT6509 nd983 nd984 7.187716229562e+01
RINT6510 nd984 nd985 7.139798121365e+01
RINT6511 nd985 nd986 5.590445956326e+00
RINT6512 nd986 nd987 9.583621639417e-01
RINT6513 nd987 nd988 9.583621639417e-01
RINT6514 nd988 nd989 9.583621639417e-01
RINT6515 nd990 nd991 2.048247584516e+02
RINT6516 nd991 nd992 2.140075552969e+02
RINT6517 nd992 nd993 4.819231464332e+01
RINT6518 nd993 nd994 2.064814009404e+02
RINT6519 nd994 nd995 2.802247584191e+02
RINT6520 nd995 nd996 2.064814009404e+02
RINT6521 nd996 nd997 2.064814009404e+02
RINT6522 nd997 nd998 2.064814009404e+02
RINT6523 nd998 nd999 2.064814009404e+02
RINT6524 nd999 nd1000 2.064814009404e+02
RINT6525 nd1000 nd1001 2.064814009404e+02
RINT6526 nd1001 nd1002 1.327380434617e+03
RINT6527 nd1002 nd1003 1.318531231719e+03
RINT6528 nd1003 nd1004 1.032407004702e+02
RINT6529 nd1004 nd1005 1.769840579489e+01
RINT6530 nd1005 nd1006 1.769840579489e+01
RINT6531 nd1006 nd1007 1.769840579489e+01
RINT6532 nd1008 nd1009 1.256194947091e+01
RINT6533 nd1009 nd1010 1.312513251013e+01
RINT6534 nd1010 nd1011 2.955645723751e+00
RINT6535 nd1011 nd1012 1.266355173517e+01
RINT6536 nd1012 nd1013 1.718624878345e+01
RINT6537 nd1013 nd1014 1.266355173517e+01
RINT6538 nd1014 nd1015 1.266355173517e+01
RINT6539 nd1015 nd1016 1.266355173517e+01
RINT6540 nd1016 nd1017 1.266355173517e+01
RINT6541 nd1017 nd1018 1.266355173517e+01
RINT6542 nd1018 nd1019 1.266355173517e+01
RINT6543 nd1019 nd1020 8.140854686898e+01
RINT6544 nd1020 nd1021 8.086582322319e+01
RINT6545 nd1021 nd1022 6.331775867587e+00
RINT6546 nd1022 nd1023 1.085447291586e+00
RINT6547 nd1023 nd1024 1.085447291586e+00
RINT6548 nd1024 nd1025 1.085447291586e+00
RINT6549 nd1026 nd1027 1.256194947091e+01
RINT6550 nd1027 nd1028 1.312513251013e+01
RINT6551 nd1028 nd1029 2.955645723751e+00
RINT6552 nd1029 nd1030 1.266355173517e+01
RINT6553 nd1030 nd1031 1.718624878345e+01
RINT6554 nd1031 nd1032 1.266355173517e+01
RINT6555 nd1032 nd1033 1.266355173517e+01
RINT6556 nd1033 nd1034 1.266355173517e+01
RINT6557 nd1034 nd1035 1.266355173517e+01
RINT6558 nd1035 nd1036 1.266355173517e+01
RINT6559 nd1036 nd1037 1.266355173517e+01
RINT6560 nd1037 nd1038 8.140854686898e+01
RINT6561 nd1038 nd1039 8.086582322319e+01
RINT6562 nd1039 nd1040 6.331775867587e+00
RINT6563 nd1040 nd1041 1.085447291586e+00
RINT6564 nd1041 nd1042 1.085447291586e+00
RINT6565 nd1042 nd1043 1.085447291586e+00
RINT6566 nd1044 nd1045 4.736548367769e+01
RINT6567 nd1045 nd1046 4.948899461153e+01
RINT6568 nd1046 nd1047 1.114441588939e+01
RINT6569 nd1047 nd1048 4.774858029822e+01
RINT6570 nd1048 nd1049 6.480164469044e+01
RINT6571 nd1049 nd1050 4.774858029822e+01
RINT6572 nd1050 nd1051 4.774858029822e+01
RINT6573 nd1051 nd1052 4.774858029822e+01
RINT6574 nd1052 nd1053 4.774858029822e+01
RINT6575 nd1053 nd1054 4.774858029822e+01
RINT6576 nd1054 nd1055 4.774858029822e+01
RINT6577 nd1055 nd1056 3.069551590600e+02
RINT6578 nd1056 nd1057 3.049087913329e+02
RINT6579 nd1057 nd1058 2.387429014911e+01
RINT6580 nd1058 nd1059 4.092735454133e+00
RINT6581 nd1059 nd1060 4.092735454133e+00
RINT6582 nd1060 nd1061 4.092735454133e+00
RINT6583 nd1062 nd1063 1.864653966342e+03
RINT6584 nd1063 nd1064 1.948250982099e+03
RINT6585 nd1064 nd1065 1.735634542755e+04
RINT6586 nd1065 nd1066 1.203030699687e+05
RINT6587 nd1066 nd1067 1.632684521003e+05
RINT6588 nd1067 nd1068 1.203030699687e+05
RINT6589 nd1068 nd1069 1.203030699687e+05
RINT6590 nd1069 nd1070 1.203030699687e+05
RINT6591 nd1070 nd1071 1.203030699687e+05
RINT6592 nd1071 nd1072 1.203030699687e+05
RINT6593 nd1072 nd1073 1.203030699687e+05
RINT6594 nd1073 nd1074 7.733768783700e+05
RINT6595 nd1074 nd1075 7.140846510283e+05
RINT6596 nd1075 nd1076 9.398677341302e+02
RINT6597 nd1076 nd1077 1.611201829938e+02
RINT6598 nd1077 nd1078 1.611201829938e+02
RINT6599 nd1078 nd1079 1.611201829938e+02
RINT6600 nd1080 nd1081 9.961726771726e+01
RINT6601 nd1081 nd1082 1.040833544279e+02
RINT6602 nd1082 nd1083 9.272453443154e+02
RINT6603 nd1083 nd1084 6.427070837056e+03
RINT6604 nd1084 nd1085 8.722453278862e+03
RINT6605 nd1085 nd1086 6.427070837056e+03
RINT6606 nd1086 nd1087 6.427070837056e+03
RINT6607 nd1087 nd1088 6.427070837056e+03
RINT6608 nd1088 nd1089 6.427070837056e+03
RINT6609 nd1089 nd1090 6.427070837056e+03
RINT6610 nd1090 nd1091 6.427070837056e+03
RINT6611 nd1091 nd1092 4.131688395250e+04
RINT6612 nd1092 nd1093 3.814925618281e+04
RINT6613 nd1093 nd1094 5.021149091450e+01
RINT6614 nd1094 nd1095 8.607684156772e+00
RINT6615 nd1095 nd1096 8.607684156772e+00
RINT6616 nd1096 nd1097 8.607684156772e+00
RINT6617 nd1098 nd1099 2.530379400500e+00
RINT6618 nd1099 nd1100 2.643822522083e+00
RINT6619 nd1100 nd1101 5.953618164021e-01
RINT6620 nd1101 nd1102 2.550845354222e+00
RINT6621 nd1102 nd1103 3.461861552158e+00
RINT6622 nd1103 nd1104 2.550845354222e+00
RINT6623 nd1104 nd1105 2.550845354222e+00
RINT6624 nd1105 nd1106 2.550845354222e+00
RINT6625 nd1106 nd1107 2.550845354222e+00
RINT6626 nd1107 nd1108 2.550845354222e+00
RINT6627 nd1108 nd1109 2.550845354222e+00
RINT6628 nd1109 nd1110 1.639829156285e+01
RINT6629 nd1110 nd1111 1.628896961910e+01
RINT6630 nd1111 nd1112 1.275422677111e+00
RINT6631 nd1112 nd1113 2.186438875047e-01
RINT6632 nd1113 nd1114 2.186438875047e-01
RINT6633 nd1114 nd1115 2.186438875047e-01
RINT6634 nd1116 nd1117 6.710899098510e-01
RINT6635 nd1117 nd1118 7.011765182948e-01
RINT6636 nd1118 nd1119 6.319085459980e-02
RINT6637 nd1119 nd1120 1.077461063435e-02
RINT6638 nd1120 nd1121 1.399057115758e-02
RINT6639 nd1121 nd1122 1.030884190558e-02
RINT6640 nd1122 nd1123 1.030884190558e-02
RINT6641 nd1123 nd1124 1.030884190558e-02
RINT6642 nd1124 nd1125 1.030884190558e-02
RINT6643 nd1125 nd1126 1.030884190558e-02
RINT6644 nd1126 nd1127 1.030884190558e-02
RINT6645 nd1127 nd1128 6.639309009356e-02
RINT6646 nd1128 nd1129 3.705039263083e-01
RINT6647 nd1129 nd1130 3.382588750269e-01
RINT6648 nd1130 nd1131 5.798723571891e-02
RINT6649 nd1131 nd1132 5.798723571891e-02
RINT6650 nd1132 nd1133 5.798723571891e-02
RINT6651 nd1134 nd1135 6.710899098510e-01
RINT6652 nd1135 nd1136 7.011765182948e-01
RINT6653 nd1136 nd1137 6.319085459980e-02
RINT6654 nd1137 nd1138 1.077461063435e-02
RINT6655 nd1138 nd1139 1.399057115758e-02
RINT6656 nd1139 nd1140 1.030884190558e-02
RINT6657 nd1140 nd1141 1.030884190558e-02
RINT6658 nd1141 nd1142 1.030884190558e-02
RINT6659 nd1142 nd1143 1.030884190558e-02
RINT6660 nd1143 nd1144 1.030884190558e-02
RINT6661 nd1144 nd1145 1.030884190558e-02
RINT6662 nd1145 nd1146 6.639309009356e-02
RINT6663 nd1146 nd1147 3.705039263083e-01
RINT6664 nd1147 nd1148 3.382588750269e-01
RINT6665 nd1148 nd1149 5.798723571891e-02
RINT6666 nd1149 nd1150 5.798723571891e-02
RINT6667 nd1150 nd1151 5.798723571891e-02
RINT6668 nd1152 nd1153 1.094220185642e+01
RINT6669 nd1153 nd1154 1.143276763298e+01
RINT6670 nd1154 nd1155 1.030334499686e+00
RINT6671 nd1155 nd1156 1.756813248936e-01
RINT6672 nd1156 nd1157 2.281179487959e-01
RINT6673 nd1157 nd1158 1.680869096391e-01
RINT6674 nd1158 nd1159 1.680869096391e-01
RINT6675 nd1159 nd1160 1.680869096391e-01
RINT6676 nd1160 nd1161 1.680869096391e-01
RINT6677 nd1161 nd1162 1.680869096391e-01
RINT6678 nd1162 nd1163 1.680869096391e-01
RINT6679 nd1163 nd1164 1.082547335329e+00
RINT6680 nd1164 nd1165 6.041111169681e+00
RINT6681 nd1165 nd1166 5.515351722531e+00
RINT6682 nd1166 nd1167 9.454888667197e-01
RINT6683 nd1167 nd1168 9.454888667197e-01
RINT6684 nd1168 nd1169 9.454888667197e-01
RINT6685 nd1170 nd1171 5.925181104504e-01
RINT6686 nd1171 nd1172 6.190821522028e-01
RINT6687 nd1172 nd1173 5.579241352851e-02
RINT6688 nd1173 nd1174 9.513109704359e-03
RINT6689 nd1174 nd1175 1.235254272896e-02
RINT6690 nd1175 nd1176 9.101873589760e-03
RINT6691 nd1176 nd1177 9.101873589760e-03
RINT6692 nd1177 nd1178 9.101873589760e-03
RINT6693 nd1178 nd1179 9.101873589760e-03
RINT6694 nd1179 nd1180 9.101873589760e-03
RINT6695 nd1180 nd1181 9.101873589760e-03
RINT6696 nd1181 nd1182 5.861972846221e-02
RINT6697 nd1182 nd1183 3.271249993601e-01
RINT6698 nd1183 nd1184 2.986552271640e-01
RINT6699 nd1184 nd1185 5.119803894240e-02
RINT6700 nd1185 nd1186 5.119803894240e-02
RINT6701 nd1186 nd1187 5.119803894240e-02
RINT6702 nd1188 nd1189 5.925181104504e-01
RINT6703 nd1189 nd1190 6.190821522028e-01
RINT6704 nd1190 nd1191 5.579241352851e-02
RINT6705 nd1191 nd1192 9.513109704359e-03
RINT6706 nd1192 nd1193 1.235254272896e-02
RINT6707 nd1193 nd1194 9.101873589760e-03
RINT6708 nd1194 nd1195 9.101873589760e-03
RINT6709 nd1195 nd1196 9.101873589760e-03
RINT6710 nd1196 nd1197 9.101873589760e-03
RINT6711 nd1197 nd1198 9.101873589760e-03
RINT6712 nd1198 nd1199 9.101873589760e-03
RINT6713 nd1199 nd1200 5.861972846221e-02
RINT6714 nd1200 nd1201 3.271249993601e-01
RINT6715 nd1201 nd1202 2.986552271640e-01
RINT6716 nd1202 nd1203 5.119803894240e-02
RINT6717 nd1203 nd1204 5.119803894240e-02
RINT6718 nd1204 nd1205 5.119803894240e-02
RINT6719 nd1206 nd1207 1.094223703119e+01
RINT6720 nd1207 nd1208 1.143280438472e+01
RINT6721 nd1208 nd1209 1.030337811796e+00
RINT6722 nd1209 nd1210 1.756818896382e-01
RINT6723 nd1210 nd1211 2.281186821031e-01
RINT6724 nd1211 nd1212 1.680874499707e-01
RINT6725 nd1212 nd1213 1.680874499707e-01
RINT6726 nd1213 nd1214 1.680874499707e-01
RINT6727 nd1214 nd1215 1.680874499707e-01
RINT6728 nd1215 nd1216 1.680874499707e-01
RINT6729 nd1216 nd1217 1.680874499707e-01
RINT6730 nd1217 nd1218 1.082550815282e+00
RINT6731 nd1218 nd1219 6.041130589418e+00
RINT6732 nd1219 nd1220 5.515369452164e+00
RINT6733 nd1220 nd1221 9.454919060852e-01
RINT6734 nd1221 nd1222 9.454919060852e-01
RINT6735 nd1222 nd1223 9.454919060852e-01
RINT6736 nd1224 nd1225 6.710899098510e-01
RINT6737 nd1225 nd1226 7.011765182948e-01
RINT6738 nd1226 nd1227 6.319085459980e-02
RINT6739 nd1227 nd1228 1.077461063435e-02
RINT6740 nd1228 nd1229 1.399057115758e-02
RINT6741 nd1229 nd1230 1.030884190558e-02
RINT6742 nd1230 nd1231 1.030884190558e-02
RINT6743 nd1231 nd1232 1.030884190558e-02
RINT6744 nd1232 nd1233 1.030884190558e-02
RINT6745 nd1233 nd1234 1.030884190558e-02
RINT6746 nd1234 nd1235 1.030884190558e-02
RINT6747 nd1235 nd1236 6.639309009356e-02
RINT6748 nd1236 nd1237 3.705039263083e-01
RINT6749 nd1237 nd1238 3.382588750269e-01
RINT6750 nd1238 nd1239 5.798723571891e-02
RINT6751 nd1239 nd1240 5.798723571891e-02
RINT6752 nd1240 nd1241 5.798723571891e-02
RINT6753 nd1242 nd1243 6.710899098510e-01
RINT6754 nd1243 nd1244 7.011765182948e-01
RINT6755 nd1244 nd1245 6.319085459980e-02
RINT6756 nd1245 nd1246 1.077461063435e-02
RINT6757 nd1246 nd1247 1.399057115758e-02
RINT6758 nd1247 nd1248 1.030884190558e-02
RINT6759 nd1248 nd1249 1.030884190558e-02
RINT6760 nd1249 nd1250 1.030884190558e-02
RINT6761 nd1250 nd1251 1.030884190558e-02
RINT6762 nd1251 nd1252 1.030884190558e-02
RINT6763 nd1252 nd1253 1.030884190558e-02
RINT6764 nd1253 nd1254 6.639309009356e-02
RINT6765 nd1254 nd1255 3.705039263083e-01
RINT6766 nd1255 nd1256 3.382588750269e-01
RINT6767 nd1256 nd1257 5.798723571891e-02
RINT6768 nd1257 nd1258 5.798723571891e-02
RINT6769 nd1258 nd1259 5.798723571891e-02
RINT6770 nd1260 nd1261 2.530379400500e+00
RINT6771 nd1261 nd1262 2.643822522083e+00
RINT6772 nd1262 nd1263 5.953618164021e-01
RINT6773 nd1263 nd1264 2.550845354222e+00
RINT6774 nd1264 nd1265 3.461861552158e+00
RINT6775 nd1265 nd1266 2.550845354222e+00
RINT6776 nd1266 nd1267 2.550845354222e+00
RINT6777 nd1267 nd1268 2.550845354222e+00
RINT6778 nd1268 nd1269 2.550845354222e+00
RINT6779 nd1269 nd1270 2.550845354222e+00
RINT6780 nd1270 nd1271 2.550845354222e+00
RINT6781 nd1271 nd1272 1.639829156285e+01
RINT6782 nd1272 nd1273 1.628896961910e+01
RINT6783 nd1273 nd1274 1.275422677111e+00
RINT6784 nd1274 nd1275 2.186438875047e-01
RINT6785 nd1275 nd1276 2.186438875047e-01
RINT6786 nd1276 nd1277 2.186438875047e-01
RINT6787 nd1278 nd1279 9.961435245965e+01
RINT6788 nd1279 nd1280 1.040803084722e+02
RINT6789 nd1280 nd1281 9.272182088688e+02
RINT6790 nd1281 nd1282 6.426882751520e+03
RINT6791 nd1282 nd1283 8.722198019921e+03
RINT6792 nd1283 nd1284 6.426882751520e+03
RINT6793 nd1284 nd1285 6.426882751520e+03
RINT6794 nd1285 nd1286 6.426882751520e+03
RINT6795 nd1286 nd1287 6.426882751520e+03
RINT6796 nd1287 nd1288 6.426882751520e+03
RINT6797 nd1288 nd1289 6.426882751520e+03
RINT6798 nd1289 nd1290 4.131567483120e+04
RINT6799 nd1290 nd1291 3.814813976081e+04
RINT6800 nd1291 nd1292 5.021002149625e+01
RINT6801 nd1292 nd1293 8.607432256501e+00
RINT6802 nd1293 nd1294 8.607432256501e+00
RINT6803 nd1294 nd1295 8.607432256501e+00
RINT6804 nd1296 nd1297 9.961726771726e+01
RINT6805 nd1297 nd1298 1.040833544279e+02
RINT6806 nd1298 nd1299 9.272453443154e+02
RINT6807 nd1299 nd1300 6.427070837056e+03
RINT6808 nd1300 nd1301 8.722453278862e+03
RINT6809 nd1301 nd1302 6.427070837056e+03
RINT6810 nd1302 nd1303 6.427070837056e+03
RINT6811 nd1303 nd1304 6.427070837056e+03
RINT6812 nd1304 nd1305 6.427070837056e+03
RINT6813 nd1305 nd1306 6.427070837056e+03
RINT6814 nd1306 nd1307 6.427070837056e+03
RINT6815 nd1307 nd1308 4.131688395250e+04
RINT6816 nd1308 nd1309 3.814925618281e+04
RINT6817 nd1309 nd1310 5.021149091450e+01
RINT6818 nd1310 nd1311 8.607684156772e+00
RINT6819 nd1311 nd1312 8.607684156772e+00
RINT6820 nd1312 nd1313 8.607684156772e+00
RINT6821 nd1314 nd1315 2.530379400500e+00
RINT6822 nd1315 nd1316 2.643822522083e+00
RINT6823 nd1316 nd1317 5.953618164021e-01
RINT6824 nd1317 nd1318 2.550845354222e+00
RINT6825 nd1318 nd1319 3.461861552158e+00
RINT6826 nd1319 nd1320 2.550845354222e+00
RINT6827 nd1320 nd1321 2.550845354222e+00
RINT6828 nd1321 nd1322 2.550845354222e+00
RINT6829 nd1322 nd1323 2.550845354222e+00
RINT6830 nd1323 nd1324 2.550845354222e+00
RINT6831 nd1324 nd1325 2.550845354222e+00
RINT6832 nd1325 nd1326 1.639829156285e+01
RINT6833 nd1326 nd1327 1.628896961910e+01
RINT6834 nd1327 nd1328 1.275422677111e+00
RINT6835 nd1328 nd1329 2.186438875047e-01
RINT6836 nd1329 nd1330 2.186438875047e-01
RINT6837 nd1330 nd1331 2.186438875047e-01
RINT6838 nd1332 nd1333 6.710899098510e-01
RINT6839 nd1333 nd1334 7.011765182948e-01
RINT6840 nd1334 nd1335 6.319085459980e-02
RINT6841 nd1335 nd1336 1.077461063435e-02
RINT6842 nd1336 nd1337 1.399057115758e-02
RINT6843 nd1337 nd1338 1.030884190558e-02
RINT6844 nd1338 nd1339 1.030884190558e-02
RINT6845 nd1339 nd1340 1.030884190558e-02
RINT6846 nd1340 nd1341 1.030884190558e-02
RINT6847 nd1341 nd1342 1.030884190558e-02
RINT6848 nd1342 nd1343 1.030884190558e-02
RINT6849 nd1343 nd1344 6.639309009356e-02
RINT6850 nd1344 nd1345 3.705039263083e-01
RINT6851 nd1345 nd1346 3.382588750269e-01
RINT6852 nd1346 nd1347 5.798723571891e-02
RINT6853 nd1347 nd1348 5.798723571891e-02
RINT6854 nd1348 nd1349 5.798723571891e-02
RINT6855 nd1350 nd1351 6.710899098510e-01
RINT6856 nd1351 nd1352 7.011765182948e-01
RINT6857 nd1352 nd1353 6.319085459980e-02
RINT6858 nd1353 nd1354 1.077461063435e-02
RINT6859 nd1354 nd1355 1.399057115758e-02
RINT6860 nd1355 nd1356 1.030884190558e-02
RINT6861 nd1356 nd1357 1.030884190558e-02
RINT6862 nd1357 nd1358 1.030884190558e-02
RINT6863 nd1358 nd1359 1.030884190558e-02
RINT6864 nd1359 nd1360 1.030884190558e-02
RINT6865 nd1360 nd1361 1.030884190558e-02
RINT6866 nd1361 nd1362 6.639309009356e-02
RINT6867 nd1362 nd1363 3.705039263083e-01
RINT6868 nd1363 nd1364 3.382588750269e-01
RINT6869 nd1364 nd1365 5.798723571891e-02
RINT6870 nd1365 nd1366 5.798723571891e-02
RINT6871 nd1366 nd1367 5.798723571891e-02
RINT6872 nd1368 nd1369 1.094220185642e+01
RINT6873 nd1369 nd1370 1.143276763298e+01
RINT6874 nd1370 nd1371 1.030334499686e+00
RINT6875 nd1371 nd1372 1.756813248936e-01
RINT6876 nd1372 nd1373 2.281179487959e-01
RINT6877 nd1373 nd1374 1.680869096391e-01
RINT6878 nd1374 nd1375 1.680869096391e-01
RINT6879 nd1375 nd1376 1.680869096391e-01
RINT6880 nd1376 nd1377 1.680869096391e-01
RINT6881 nd1377 nd1378 1.680869096391e-01
RINT6882 nd1378 nd1379 1.680869096391e-01
RINT6883 nd1379 nd1380 1.082547335329e+00
RINT6884 nd1380 nd1381 6.041111169681e+00
RINT6885 nd1381 nd1382 5.515351722531e+00
RINT6886 nd1382 nd1383 9.454888667197e-01
RINT6887 nd1383 nd1384 9.454888667197e-01
RINT6888 nd1384 nd1385 9.454888667197e-01
RINT6889 nd1386 nd1387 5.925181104504e-01
RINT6890 nd1387 nd1388 6.190821522028e-01
RINT6891 nd1388 nd1389 5.579241352851e-02
RINT6892 nd1389 nd1390 9.513109704359e-03
RINT6893 nd1390 nd1391 1.235254272896e-02
RINT6894 nd1391 nd1392 9.101873589760e-03
RINT6895 nd1392 nd1393 9.101873589760e-03
RINT6896 nd1393 nd1394 9.101873589760e-03
RINT6897 nd1394 nd1395 9.101873589760e-03
RINT6898 nd1395 nd1396 9.101873589760e-03
RINT6899 nd1396 nd1397 9.101873589760e-03
RINT6900 nd1397 nd1398 5.861972846221e-02
RINT6901 nd1398 nd1399 3.271249993601e-01
RINT6902 nd1399 nd1400 2.986552271640e-01
RINT6903 nd1400 nd1401 5.119803894240e-02
RINT6904 nd1401 nd1402 5.119803894240e-02
RINT6905 nd1402 nd1403 5.119803894240e-02
RINT6906 nd1404 nd1405 5.925181104504e-01
RINT6907 nd1405 nd1406 6.190821522028e-01
RINT6908 nd1406 nd1407 5.579241352851e-02
RINT6909 nd1407 nd1408 9.513109704359e-03
RINT6910 nd1408 nd1409 1.235254272896e-02
RINT6911 nd1409 nd1410 9.101873589760e-03
RINT6912 nd1410 nd1411 9.101873589760e-03
RINT6913 nd1411 nd1412 9.101873589760e-03
RINT6914 nd1412 nd1413 9.101873589760e-03
RINT6915 nd1413 nd1414 9.101873589760e-03
RINT6916 nd1414 nd1415 9.101873589760e-03
RINT6917 nd1415 nd1416 5.861972846221e-02
RINT6918 nd1416 nd1417 3.271249993601e-01
RINT6919 nd1417 nd1418 2.986552271640e-01
RINT6920 nd1418 nd1419 5.119803894240e-02
RINT6921 nd1419 nd1420 5.119803894240e-02
RINT6922 nd1420 nd1421 5.119803894240e-02
RINT6923 nd1422 nd1423 1.094223703119e+01
RINT6924 nd1423 nd1424 1.143280438472e+01
RINT6925 nd1424 nd1425 1.030337811796e+00
RINT6926 nd1425 nd1426 1.756818896382e-01
RINT6927 nd1426 nd1427 2.281186821031e-01
RINT6928 nd1427 nd1428 1.680874499707e-01
RINT6929 nd1428 nd1429 1.680874499707e-01
RINT6930 nd1429 nd1430 1.680874499707e-01
RINT6931 nd1430 nd1431 1.680874499707e-01
RINT6932 nd1431 nd1432 1.680874499707e-01
RINT6933 nd1432 nd1433 1.680874499707e-01
RINT6934 nd1433 nd1434 1.082550815282e+00
RINT6935 nd1434 nd1435 6.041130589418e+00
RINT6936 nd1435 nd1436 5.515369452164e+00
RINT6937 nd1436 nd1437 9.454919060852e-01
RINT6938 nd1437 nd1438 9.454919060852e-01
RINT6939 nd1438 nd1439 9.454919060852e-01
RINT6940 nd1440 nd1441 6.710899098510e-01
RINT6941 nd1441 nd1442 7.011765182948e-01
RINT6942 nd1442 nd1443 6.319085459980e-02
RINT6943 nd1443 nd1444 1.077461063435e-02
RINT6944 nd1444 nd1445 1.399057115758e-02
RINT6945 nd1445 nd1446 1.030884190558e-02
RINT6946 nd1446 nd1447 1.030884190558e-02
RINT6947 nd1447 nd1448 1.030884190558e-02
RINT6948 nd1448 nd1449 1.030884190558e-02
RINT6949 nd1449 nd1450 1.030884190558e-02
RINT6950 nd1450 nd1451 1.030884190558e-02
RINT6951 nd1451 nd1452 6.639309009356e-02
RINT6952 nd1452 nd1453 3.705039263083e-01
RINT6953 nd1453 nd1454 3.382588750269e-01
RINT6954 nd1454 nd1455 5.798723571891e-02
RINT6955 nd1455 nd1456 5.798723571891e-02
RINT6956 nd1456 nd1457 5.798723571891e-02
RINT6957 nd1458 nd1459 6.710899098510e-01
RINT6958 nd1459 nd1460 7.011765182948e-01
RINT6959 nd1460 nd1461 6.319085459980e-02
RINT6960 nd1461 nd1462 1.077461063435e-02
RINT6961 nd1462 nd1463 1.399057115758e-02
RINT6962 nd1463 nd1464 1.030884190558e-02
RINT6963 nd1464 nd1465 1.030884190558e-02
RINT6964 nd1465 nd1466 1.030884190558e-02
RINT6965 nd1466 nd1467 1.030884190558e-02
RINT6966 nd1467 nd1468 1.030884190558e-02
RINT6967 nd1468 nd1469 1.030884190558e-02
RINT6968 nd1469 nd1470 6.639309009356e-02
RINT6969 nd1470 nd1471 3.705039263083e-01
RINT6970 nd1471 nd1472 3.382588750269e-01
RINT6971 nd1472 nd1473 5.798723571891e-02
RINT6972 nd1473 nd1474 5.798723571891e-02
RINT6973 nd1474 nd1475 5.798723571891e-02
RINT6974 nd1476 nd1477 2.530379400500e+00
RINT6975 nd1477 nd1478 2.643822522083e+00
RINT6976 nd1478 nd1479 5.953618164021e-01
RINT6977 nd1479 nd1480 2.550845354222e+00
RINT6978 nd1480 nd1481 3.461861552158e+00
RINT6979 nd1481 nd1482 2.550845354222e+00
RINT6980 nd1482 nd1483 2.550845354222e+00
RINT6981 nd1483 nd1484 2.550845354222e+00
RINT6982 nd1484 nd1485 2.550845354222e+00
RINT6983 nd1485 nd1486 2.550845354222e+00
RINT6984 nd1486 nd1487 2.550845354222e+00
RINT6985 nd1487 nd1488 1.639829156285e+01
RINT6986 nd1488 nd1489 1.628896961910e+01
RINT6987 nd1489 nd1490 1.275422677111e+00
RINT6988 nd1490 nd1491 2.186438875047e-01
RINT6989 nd1491 nd1492 2.186438875047e-01
RINT6990 nd1492 nd1493 2.186438875047e-01
RINT6991 nd1494 nd1495 9.961435245965e+01
RINT6992 nd1495 nd1496 1.040803084722e+02
RINT6993 nd1496 nd1497 9.272182088688e+02
RINT6994 nd1497 nd1498 6.426882751520e+03
RINT6995 nd1498 nd1499 8.722198019921e+03
RINT6996 nd1499 nd1500 6.426882751520e+03
RINT6997 nd1500 nd1501 6.426882751520e+03
RINT6998 nd1501 nd1502 6.426882751520e+03
RINT6999 nd1502 nd1503 6.426882751520e+03
RINT7000 nd1503 nd1504 6.426882751520e+03
RINT7001 nd1504 nd1505 6.426882751520e+03
RINT7002 nd1505 nd1506 4.131567483120e+04
RINT7003 nd1506 nd1507 3.814813976081e+04
RINT7004 nd1507 nd1508 5.021002149625e+01
RINT7005 nd1508 nd1509 8.607432256501e+00
RINT7006 nd1509 nd1510 8.607432256501e+00
RINT7007 nd1510 nd1511 8.607432256501e+00
RINT7008 nd1512 nd1513 9.961726771726e+01
RINT7009 nd1513 nd1514 1.040833544279e+02
RINT7010 nd1514 nd1515 9.272453443154e+02
RINT7011 nd1515 nd1516 6.427070837056e+03
RINT7012 nd1516 nd1517 8.722453278862e+03
RINT7013 nd1517 nd1518 6.427070837056e+03
RINT7014 nd1518 nd1519 6.427070837056e+03
RINT7015 nd1519 nd1520 6.427070837056e+03
RINT7016 nd1520 nd1521 6.427070837056e+03
RINT7017 nd1521 nd1522 6.427070837056e+03
RINT7018 nd1522 nd1523 6.427070837056e+03
RINT7019 nd1523 nd1524 4.131688395250e+04
RINT7020 nd1524 nd1525 3.814925618281e+04
RINT7021 nd1525 nd1526 5.021149091450e+01
RINT7022 nd1526 nd1527 8.607684156772e+00
RINT7023 nd1527 nd1528 8.607684156772e+00
RINT7024 nd1528 nd1529 8.607684156772e+00
RINT7025 nd1530 nd1531 2.530379400500e+00
RINT7026 nd1531 nd1532 2.643822522083e+00
RINT7027 nd1532 nd1533 5.953618164021e-01
RINT7028 nd1533 nd1534 2.550845354222e+00
RINT7029 nd1534 nd1535 3.461861552158e+00
RINT7030 nd1535 nd1536 2.550845354222e+00
RINT7031 nd1536 nd1537 2.550845354222e+00
RINT7032 nd1537 nd1538 2.550845354222e+00
RINT7033 nd1538 nd1539 2.550845354222e+00
RINT7034 nd1539 nd1540 2.550845354222e+00
RINT7035 nd1540 nd1541 2.550845354222e+00
RINT7036 nd1541 nd1542 1.639829156285e+01
RINT7037 nd1542 nd1543 1.628896961910e+01
RINT7038 nd1543 nd1544 1.275422677111e+00
RINT7039 nd1544 nd1545 2.186438875047e-01
RINT7040 nd1545 nd1546 2.186438875047e-01
RINT7041 nd1546 nd1547 2.186438875047e-01
RINT7042 nd1548 nd1549 6.710899098510e-01
RINT7043 nd1549 nd1550 7.011765182948e-01
RINT7044 nd1550 nd1551 6.319085459980e-02
RINT7045 nd1551 nd1552 1.077461063435e-02
RINT7046 nd1552 nd1553 1.399057115758e-02
RINT7047 nd1553 nd1554 1.030884190558e-02
RINT7048 nd1554 nd1555 1.030884190558e-02
RINT7049 nd1555 nd1556 1.030884190558e-02
RINT7050 nd1556 nd1557 1.030884190558e-02
RINT7051 nd1557 nd1558 1.030884190558e-02
RINT7052 nd1558 nd1559 1.030884190558e-02
RINT7053 nd1559 nd1560 6.639309009356e-02
RINT7054 nd1560 nd1561 3.705039263083e-01
RINT7055 nd1561 nd1562 3.382588750269e-01
RINT7056 nd1562 nd1563 5.798723571891e-02
RINT7057 nd1563 nd1564 5.798723571891e-02
RINT7058 nd1564 nd1565 5.798723571891e-02
RINT7059 nd1566 nd1567 6.710899098510e-01
RINT7060 nd1567 nd1568 7.011765182948e-01
RINT7061 nd1568 nd1569 6.319085459980e-02
RINT7062 nd1569 nd1570 1.077461063435e-02
RINT7063 nd1570 nd1571 1.399057115758e-02
RINT7064 nd1571 nd1572 1.030884190558e-02
RINT7065 nd1572 nd1573 1.030884190558e-02
RINT7066 nd1573 nd1574 1.030884190558e-02
RINT7067 nd1574 nd1575 1.030884190558e-02
RINT7068 nd1575 nd1576 1.030884190558e-02
RINT7069 nd1576 nd1577 1.030884190558e-02
RINT7070 nd1577 nd1578 6.639309009356e-02
RINT7071 nd1578 nd1579 3.705039263083e-01
RINT7072 nd1579 nd1580 3.382588750269e-01
RINT7073 nd1580 nd1581 5.798723571891e-02
RINT7074 nd1581 nd1582 5.798723571891e-02
RINT7075 nd1582 nd1583 5.798723571891e-02
RINT7076 nd1584 nd1585 1.094220185642e+01
RINT7077 nd1585 nd1586 1.143276763298e+01
RINT7078 nd1586 nd1587 1.030334499686e+00
RINT7079 nd1587 nd1588 1.756813248936e-01
RINT7080 nd1588 nd1589 2.281179487959e-01
RINT7081 nd1589 nd1590 1.680869096391e-01
RINT7082 nd1590 nd1591 1.680869096391e-01
RINT7083 nd1591 nd1592 1.680869096391e-01
RINT7084 nd1592 nd1593 1.680869096391e-01
RINT7085 nd1593 nd1594 1.680869096391e-01
RINT7086 nd1594 nd1595 1.680869096391e-01
RINT7087 nd1595 nd1596 1.082547335329e+00
RINT7088 nd1596 nd1597 6.041111169681e+00
RINT7089 nd1597 nd1598 5.515351722531e+00
RINT7090 nd1598 nd1599 9.454888667197e-01
RINT7091 nd1599 nd1600 9.454888667197e-01
RINT7092 nd1600 nd1601 9.454888667197e-01
RINT7093 nd1602 nd1603 5.925181104504e-01
RINT7094 nd1603 nd1604 6.190821522028e-01
RINT7095 nd1604 nd1605 5.579241352851e-02
RINT7096 nd1605 nd1606 9.513109704359e-03
RINT7097 nd1606 nd1607 1.235254272896e-02
RINT7098 nd1607 nd1608 9.101873589760e-03
RINT7099 nd1608 nd1609 9.101873589760e-03
RINT7100 nd1609 nd1610 9.101873589760e-03
RINT7101 nd1610 nd1611 9.101873589760e-03
RINT7102 nd1611 nd1612 9.101873589760e-03
RINT7103 nd1612 nd1613 9.101873589760e-03
RINT7104 nd1613 nd1614 5.861972846221e-02
RINT7105 nd1614 nd1615 3.271249993601e-01
RINT7106 nd1615 nd1616 2.986552271640e-01
RINT7107 nd1616 nd1617 5.119803894240e-02
RINT7108 nd1617 nd1618 5.119803894240e-02
RINT7109 nd1618 nd1619 5.119803894240e-02
RINT7110 nd1620 nd1621 5.925181104504e-01
RINT7111 nd1621 nd1622 6.190821522028e-01
RINT7112 nd1622 nd1623 5.579241352851e-02
RINT7113 nd1623 nd1624 9.513109704359e-03
RINT7114 nd1624 nd1625 1.235254272896e-02
RINT7115 nd1625 nd1626 9.101873589760e-03
RINT7116 nd1626 nd1627 9.101873589760e-03
RINT7117 nd1627 nd1628 9.101873589760e-03
RINT7118 nd1628 nd1629 9.101873589760e-03
RINT7119 nd1629 nd1630 9.101873589760e-03
RINT7120 nd1630 nd1631 9.101873589760e-03
RINT7121 nd1631 nd1632 5.861972846221e-02
RINT7122 nd1632 nd1633 3.271249993601e-01
RINT7123 nd1633 nd1634 2.986552271640e-01
RINT7124 nd1634 nd1635 5.119803894240e-02
RINT7125 nd1635 nd1636 5.119803894240e-02
RINT7126 nd1636 nd1637 5.119803894240e-02
RINT7127 nd1638 nd1639 1.094223703119e+01
RINT7128 nd1639 nd1640 1.143280438472e+01
RINT7129 nd1640 nd1641 1.030337811796e+00
RINT7130 nd1641 nd1642 1.756818896382e-01
RINT7131 nd1642 nd1643 2.281186821031e-01
RINT7132 nd1643 nd1644 1.680874499707e-01
RINT7133 nd1644 nd1645 1.680874499707e-01
RINT7134 nd1645 nd1646 1.680874499707e-01
RINT7135 nd1646 nd1647 1.680874499707e-01
RINT7136 nd1647 nd1648 1.680874499707e-01
RINT7137 nd1648 nd1649 1.680874499707e-01
RINT7138 nd1649 nd1650 1.082550815282e+00
RINT7139 nd1650 nd1651 6.041130589418e+00
RINT7140 nd1651 nd1652 5.515369452164e+00
RINT7141 nd1652 nd1653 9.454919060852e-01
RINT7142 nd1653 nd1654 9.454919060852e-01
RINT7143 nd1654 nd1655 9.454919060852e-01
RINT7144 nd1656 nd1657 6.710899098510e-01
RINT7145 nd1657 nd1658 7.011765182948e-01
RINT7146 nd1658 nd1659 6.319085459980e-02
RINT7147 nd1659 nd1660 1.077461063435e-02
RINT7148 nd1660 nd1661 1.399057115758e-02
RINT7149 nd1661 nd1662 1.030884190558e-02
RINT7150 nd1662 nd1663 1.030884190558e-02
RINT7151 nd1663 nd1664 1.030884190558e-02
RINT7152 nd1664 nd1665 1.030884190558e-02
RINT7153 nd1665 nd1666 1.030884190558e-02
RINT7154 nd1666 nd1667 1.030884190558e-02
RINT7155 nd1667 nd1668 6.639309009356e-02
RINT7156 nd1668 nd1669 3.705039263083e-01
RINT7157 nd1669 nd1670 3.382588750269e-01
RINT7158 nd1670 nd1671 5.798723571891e-02
RINT7159 nd1671 nd1672 5.798723571891e-02
RINT7160 nd1672 nd1673 5.798723571891e-02
RINT7161 nd1674 nd1675 6.710899098510e-01
RINT7162 nd1675 nd1676 7.011765182948e-01
RINT7163 nd1676 nd1677 6.319085459980e-02
RINT7164 nd1677 nd1678 1.077461063435e-02
RINT7165 nd1678 nd1679 1.399057115758e-02
RINT7166 nd1679 nd1680 1.030884190558e-02
RINT7167 nd1680 nd1681 1.030884190558e-02
RINT7168 nd1681 nd1682 1.030884190558e-02
RINT7169 nd1682 nd1683 1.030884190558e-02
RINT7170 nd1683 nd1684 1.030884190558e-02
RINT7171 nd1684 nd1685 1.030884190558e-02
RINT7172 nd1685 nd1686 6.639309009356e-02
RINT7173 nd1686 nd1687 3.705039263083e-01
RINT7174 nd1687 nd1688 3.382588750269e-01
RINT7175 nd1688 nd1689 5.798723571891e-02
RINT7176 nd1689 nd1690 5.798723571891e-02
RINT7177 nd1690 nd1691 5.798723571891e-02
RINT7178 nd1692 nd1693 2.530379400500e+00
RINT7179 nd1693 nd1694 2.643822522083e+00
RINT7180 nd1694 nd1695 5.953618164021e-01
RINT7181 nd1695 nd1696 2.550845354222e+00
RINT7182 nd1696 nd1697 3.461861552158e+00
RINT7183 nd1697 nd1698 2.550845354222e+00
RINT7184 nd1698 nd1699 2.550845354222e+00
RINT7185 nd1699 nd1700 2.550845354222e+00
RINT7186 nd1700 nd1701 2.550845354222e+00
RINT7187 nd1701 nd1702 2.550845354222e+00
RINT7188 nd1702 nd1703 2.550845354222e+00
RINT7189 nd1703 nd1704 1.639829156285e+01
RINT7190 nd1704 nd1705 1.628896961910e+01
RINT7191 nd1705 nd1706 1.275422677111e+00
RINT7192 nd1706 nd1707 2.186438875047e-01
RINT7193 nd1707 nd1708 2.186438875047e-01
RINT7194 nd1708 nd1709 2.186438875047e-01
RINT7195 nd1710 nd1711 9.961435245965e+01
RINT7196 nd1711 nd1712 1.040803084722e+02
RINT7197 nd1712 nd1713 9.272182088688e+02
RINT7198 nd1713 nd1714 6.426882751520e+03
RINT7199 nd1714 nd1715 8.722198019921e+03
RINT7200 nd1715 nd1716 6.426882751520e+03
RINT7201 nd1716 nd1717 6.426882751520e+03
RINT7202 nd1717 nd1718 6.426882751520e+03
RINT7203 nd1718 nd1719 6.426882751520e+03
RINT7204 nd1719 nd1720 6.426882751520e+03
RINT7205 nd1720 nd1721 6.426882751520e+03
RINT7206 nd1721 nd1722 4.131567483120e+04
RINT7207 nd1722 nd1723 3.814813976081e+04
RINT7208 nd1723 nd1724 5.021002149625e+01
RINT7209 nd1724 nd1725 8.607432256501e+00
RINT7210 nd1725 nd1726 8.607432256501e+00
RINT7211 nd1726 nd1727 8.607432256501e+00
RINT7212 nd1728 nd1729 9.961726771726e+01
RINT7213 nd1729 nd1730 1.040833544279e+02
RINT7214 nd1730 nd1731 9.272453443154e+02
RINT7215 nd1731 nd1732 6.427070837056e+03
RINT7216 nd1732 nd1733 8.722453278862e+03
RINT7217 nd1733 nd1734 6.427070837056e+03
RINT7218 nd1734 nd1735 6.427070837056e+03
RINT7219 nd1735 nd1736 6.427070837056e+03
RINT7220 nd1736 nd1737 6.427070837056e+03
RINT7221 nd1737 nd1738 6.427070837056e+03
RINT7222 nd1738 nd1739 6.427070837056e+03
RINT7223 nd1739 nd1740 4.131688395250e+04
RINT7224 nd1740 nd1741 3.814925618281e+04
RINT7225 nd1741 nd1742 5.021149091450e+01
RINT7226 nd1742 nd1743 8.607684156772e+00
RINT7227 nd1743 nd1744 8.607684156772e+00
RINT7228 nd1744 nd1745 8.607684156772e+00
RINT7229 nd1746 nd1747 2.530379400500e+00
RINT7230 nd1747 nd1748 2.643822522083e+00
RINT7231 nd1748 nd1749 5.953618164021e-01
RINT7232 nd1749 nd1750 2.550845354222e+00
RINT7233 nd1750 nd1751 3.461861552158e+00
RINT7234 nd1751 nd1752 2.550845354222e+00
RINT7235 nd1752 nd1753 2.550845354222e+00
RINT7236 nd1753 nd1754 2.550845354222e+00
RINT7237 nd1754 nd1755 2.550845354222e+00
RINT7238 nd1755 nd1756 2.550845354222e+00
RINT7239 nd1756 nd1757 2.550845354222e+00
RINT7240 nd1757 nd1758 1.639829156285e+01
RINT7241 nd1758 nd1759 1.628896961910e+01
RINT7242 nd1759 nd1760 1.275422677111e+00
RINT7243 nd1760 nd1761 2.186438875047e-01
RINT7244 nd1761 nd1762 2.186438875047e-01
RINT7245 nd1762 nd1763 2.186438875047e-01
RINT7246 nd1764 nd1765 6.710899098510e-01
RINT7247 nd1765 nd1766 7.011765182948e-01
RINT7248 nd1766 nd1767 6.319085459980e-02
RINT7249 nd1767 nd1768 1.077461063435e-02
RINT7250 nd1768 nd1769 1.399057115758e-02
RINT7251 nd1769 nd1770 1.030884190558e-02
RINT7252 nd1770 nd1771 1.030884190558e-02
RINT7253 nd1771 nd1772 1.030884190558e-02
RINT7254 nd1772 nd1773 1.030884190558e-02
RINT7255 nd1773 nd1774 1.030884190558e-02
RINT7256 nd1774 nd1775 1.030884190558e-02
RINT7257 nd1775 nd1776 6.639309009356e-02
RINT7258 nd1776 nd1777 3.705039263083e-01
RINT7259 nd1777 nd1778 3.382588750269e-01
RINT7260 nd1778 nd1779 5.798723571891e-02
RINT7261 nd1779 nd1780 5.798723571891e-02
RINT7262 nd1780 nd1781 5.798723571891e-02
RINT7263 nd1782 nd1783 6.710899098510e-01
RINT7264 nd1783 nd1784 7.011765182948e-01
RINT7265 nd1784 nd1785 6.319085459980e-02
RINT7266 nd1785 nd1786 1.077461063435e-02
RINT7267 nd1786 nd1787 1.399057115758e-02
RINT7268 nd1787 nd1788 1.030884190558e-02
RINT7269 nd1788 nd1789 1.030884190558e-02
RINT7270 nd1789 nd1790 1.030884190558e-02
RINT7271 nd1790 nd1791 1.030884190558e-02
RINT7272 nd1791 nd1792 1.030884190558e-02
RINT7273 nd1792 nd1793 1.030884190558e-02
RINT7274 nd1793 nd1794 6.639309009356e-02
RINT7275 nd1794 nd1795 3.705039263083e-01
RINT7276 nd1795 nd1796 3.382588750269e-01
RINT7277 nd1796 nd1797 5.798723571891e-02
RINT7278 nd1797 nd1798 5.798723571891e-02
RINT7279 nd1798 nd1799 5.798723571891e-02
RINT7280 nd1800 nd1801 1.094220185642e+01
RINT7281 nd1801 nd1802 1.143276763298e+01
RINT7282 nd1802 nd1803 1.030334499686e+00
RINT7283 nd1803 nd1804 1.756813248936e-01
RINT7284 nd1804 nd1805 2.281179487959e-01
RINT7285 nd1805 nd1806 1.680869096391e-01
RINT7286 nd1806 nd1807 1.680869096391e-01
RINT7287 nd1807 nd1808 1.680869096391e-01
RINT7288 nd1808 nd1809 1.680869096391e-01
RINT7289 nd1809 nd1810 1.680869096391e-01
RINT7290 nd1810 nd1811 1.680869096391e-01
RINT7291 nd1811 nd1812 1.082547335329e+00
RINT7292 nd1812 nd1813 6.041111169681e+00
RINT7293 nd1813 nd1814 5.515351722531e+00
RINT7294 nd1814 nd1815 9.454888667197e-01
RINT7295 nd1815 nd1816 9.454888667197e-01
RINT7296 nd1816 nd1817 9.454888667197e-01
RINT7297 nd1818 nd1819 5.925181104504e-01
RINT7298 nd1819 nd1820 6.190821522028e-01
RINT7299 nd1820 nd1821 5.579241352851e-02
RINT7300 nd1821 nd1822 9.513109704359e-03
RINT7301 nd1822 nd1823 1.235254272896e-02
RINT7302 nd1823 nd1824 9.101873589760e-03
RINT7303 nd1824 nd1825 9.101873589760e-03
RINT7304 nd1825 nd1826 9.101873589760e-03
RINT7305 nd1826 nd1827 9.101873589760e-03
RINT7306 nd1827 nd1828 9.101873589760e-03
RINT7307 nd1828 nd1829 9.101873589760e-03
RINT7308 nd1829 nd1830 5.861972846221e-02
RINT7309 nd1830 nd1831 3.271249993601e-01
RINT7310 nd1831 nd1832 2.986552271640e-01
RINT7311 nd1832 nd1833 5.119803894240e-02
RINT7312 nd1833 nd1834 5.119803894240e-02
RINT7313 nd1834 nd1835 5.119803894240e-02
RINT7314 nd1836 nd1837 5.925181104504e-01
RINT7315 nd1837 nd1838 6.190821522028e-01
RINT7316 nd1838 nd1839 5.579241352851e-02
RINT7317 nd1839 nd1840 9.513109704359e-03
RINT7318 nd1840 nd1841 1.235254272896e-02
RINT7319 nd1841 nd1842 9.101873589760e-03
RINT7320 nd1842 nd1843 9.101873589760e-03
RINT7321 nd1843 nd1844 9.101873589760e-03
RINT7322 nd1844 nd1845 9.101873589760e-03
RINT7323 nd1845 nd1846 9.101873589760e-03
RINT7324 nd1846 nd1847 9.101873589760e-03
RINT7325 nd1847 nd1848 5.861972846221e-02
RINT7326 nd1848 nd1849 3.271249993601e-01
RINT7327 nd1849 nd1850 2.986552271640e-01
RINT7328 nd1850 nd1851 5.119803894240e-02
RINT7329 nd1851 nd1852 5.119803894240e-02
RINT7330 nd1852 nd1853 5.119803894240e-02
RINT7331 nd1854 nd1855 1.094223703119e+01
RINT7332 nd1855 nd1856 1.143280438472e+01
RINT7333 nd1856 nd1857 1.030337811796e+00
RINT7334 nd1857 nd1858 1.756818896382e-01
RINT7335 nd1858 nd1859 2.281186821031e-01
RINT7336 nd1859 nd1860 1.680874499707e-01
RINT7337 nd1860 nd1861 1.680874499707e-01
RINT7338 nd1861 nd1862 1.680874499707e-01
RINT7339 nd1862 nd1863 1.680874499707e-01
RINT7340 nd1863 nd1864 1.680874499707e-01
RINT7341 nd1864 nd1865 1.680874499707e-01
RINT7342 nd1865 nd1866 1.082550815282e+00
RINT7343 nd1866 nd1867 6.041130589418e+00
RINT7344 nd1867 nd1868 5.515369452164e+00
RINT7345 nd1868 nd1869 9.454919060852e-01
RINT7346 nd1869 nd1870 9.454919060852e-01
RINT7347 nd1870 nd1871 9.454919060852e-01
RINT7348 nd1872 nd1873 6.710899098510e-01
RINT7349 nd1873 nd1874 7.011765182948e-01
RINT7350 nd1874 nd1875 6.319085459980e-02
RINT7351 nd1875 nd1876 1.077461063435e-02
RINT7352 nd1876 nd1877 1.399057115758e-02
RINT7353 nd1877 nd1878 1.030884190558e-02
RINT7354 nd1878 nd1879 1.030884190558e-02
RINT7355 nd1879 nd1880 1.030884190558e-02
RINT7356 nd1880 nd1881 1.030884190558e-02
RINT7357 nd1881 nd1882 1.030884190558e-02
RINT7358 nd1882 nd1883 1.030884190558e-02
RINT7359 nd1883 nd1884 6.639309009356e-02
RINT7360 nd1884 nd1885 3.705039263083e-01
RINT7361 nd1885 nd1886 3.382588750269e-01
RINT7362 nd1886 nd1887 5.798723571891e-02
RINT7363 nd1887 nd1888 5.798723571891e-02
RINT7364 nd1888 nd1889 5.798723571891e-02
RINT7365 nd1890 nd1891 6.710899098510e-01
RINT7366 nd1891 nd1892 7.011765182948e-01
RINT7367 nd1892 nd1893 6.319085459980e-02
RINT7368 nd1893 nd1894 1.077461063435e-02
RINT7369 nd1894 nd1895 1.399057115758e-02
RINT7370 nd1895 nd1896 1.030884190558e-02
RINT7371 nd1896 nd1897 1.030884190558e-02
RINT7372 nd1897 nd1898 1.030884190558e-02
RINT7373 nd1898 nd1899 1.030884190558e-02
RINT7374 nd1899 nd1900 1.030884190558e-02
RINT7375 nd1900 nd1901 1.030884190558e-02
RINT7376 nd1901 nd1902 6.639309009356e-02
RINT7377 nd1902 nd1903 3.705039263083e-01
RINT7378 nd1903 nd1904 3.382588750269e-01
RINT7379 nd1904 nd1905 5.798723571891e-02
RINT7380 nd1905 nd1906 5.798723571891e-02
RINT7381 nd1906 nd1907 5.798723571891e-02
RINT7382 nd1908 nd1909 2.530379400500e+00
RINT7383 nd1909 nd1910 2.643822522083e+00
RINT7384 nd1910 nd1911 5.953618164021e-01
RINT7385 nd1911 nd1912 2.550845354222e+00
RINT7386 nd1912 nd1913 3.461861552158e+00
RINT7387 nd1913 nd1914 2.550845354222e+00
RINT7388 nd1914 nd1915 2.550845354222e+00
RINT7389 nd1915 nd1916 2.550845354222e+00
RINT7390 nd1916 nd1917 2.550845354222e+00
RINT7391 nd1917 nd1918 2.550845354222e+00
RINT7392 nd1918 nd1919 2.550845354222e+00
RINT7393 nd1919 nd1920 1.639829156285e+01
RINT7394 nd1920 nd1921 1.628896961910e+01
RINT7395 nd1921 nd1922 1.275422677111e+00
RINT7396 nd1922 nd1923 2.186438875047e-01
RINT7397 nd1923 nd1924 2.186438875047e-01
RINT7398 nd1924 nd1925 2.186438875047e-01
RINT7399 nd1926 nd1927 9.961435245965e+01
RINT7400 nd1927 nd1928 1.040803084722e+02
RINT7401 nd1928 nd1929 9.272182088688e+02
RINT7402 nd1929 nd1930 6.426882751520e+03
RINT7403 nd1930 nd1931 8.722198019921e+03
RINT7404 nd1931 nd1932 6.426882751520e+03
RINT7405 nd1932 nd1933 6.426882751520e+03
RINT7406 nd1933 nd1934 6.426882751520e+03
RINT7407 nd1934 nd1935 6.426882751520e+03
RINT7408 nd1935 nd1936 6.426882751520e+03
RINT7409 nd1936 nd1937 6.426882751520e+03
RINT7410 nd1937 nd1938 4.131567483120e+04
RINT7411 nd1938 nd1939 3.814813976081e+04
RINT7412 nd1939 nd1940 5.021002149625e+01
RINT7413 nd1940 nd1941 8.607432256501e+00
RINT7414 nd1941 nd1942 8.607432256501e+00
RINT7415 nd1942 nd1943 8.607432256501e+00
RINT7416 nd1944 nd1945 1.864708536256e+03
RINT7417 nd1945 nd1946 1.948307998517e+03
RINT7418 nd1946 nd1947 1.735685336860e+04
RINT7419 nd1947 nd1948 1.203065906906e+05
RINT7420 nd1948 nd1949 1.632732302230e+05
RINT7421 nd1949 nd1950 1.203065906906e+05
RINT7422 nd1950 nd1951 1.203065906906e+05
RINT7423 nd1951 nd1952 1.203065906906e+05
RINT7424 nd1952 nd1953 1.203065906906e+05
RINT7425 nd1953 nd1954 1.203065906906e+05
RINT7426 nd1954 nd1955 1.203065906906e+05
RINT7427 nd1955 nd1956 7.733995115827e+05
RINT7428 nd1956 nd1957 7.141055490281e+05
RINT7429 nd1957 nd1958 9.398952397707e+02
RINT7430 nd1958 nd1959 1.611248982464e+02
RINT7431 nd1959 nd1960 1.611248982464e+02
RINT7432 nd1960 nd1961 1.611248982464e+02
RINT7433 nd1962 nd1963 4.736548367769e+01
RINT7434 nd1963 nd1964 4.948899461153e+01
RINT7435 nd1964 nd1965 1.114441588939e+01
RINT7436 nd1965 nd1966 4.774858029822e+01
RINT7437 nd1966 nd1967 6.480164469044e+01
RINT7438 nd1967 nd1968 4.774858029822e+01
RINT7439 nd1968 nd1969 4.774858029822e+01
RINT7440 nd1969 nd1970 4.774858029822e+01
RINT7441 nd1970 nd1971 4.774858029822e+01
RINT7442 nd1971 nd1972 4.774858029822e+01
RINT7443 nd1972 nd1973 4.774858029822e+01
RINT7444 nd1973 nd1974 3.069551590600e+02
RINT7445 nd1974 nd1975 3.049087913329e+02
RINT7446 nd1975 nd1976 2.387429014911e+01
RINT7447 nd1976 nd1977 4.092735454133e+00
RINT7448 nd1977 nd1978 4.092735454133e+00
RINT7449 nd1978 nd1979 4.092735454133e+00
RINT7450 nd1980 nd1981 1.256194947091e+01
RINT7451 nd1981 nd1982 1.312513251013e+01
RINT7452 nd1982 nd1983 2.955645723751e+00
RINT7453 nd1983 nd1984 1.266355173517e+01
RINT7454 nd1984 nd1985 1.718624878345e+01
RINT7455 nd1985 nd1986 1.266355173517e+01
RINT7456 nd1986 nd1987 1.266355173517e+01
RINT7457 nd1987 nd1988 1.266355173517e+01
RINT7458 nd1988 nd1989 1.266355173517e+01
RINT7459 nd1989 nd1990 1.266355173517e+01
RINT7460 nd1990 nd1991 1.266355173517e+01
RINT7461 nd1991 nd1992 8.140854686898e+01
RINT7462 nd1992 nd1993 8.086582322319e+01
RINT7463 nd1993 nd1994 6.331775867587e+00
RINT7464 nd1994 nd1995 1.085447291586e+00
RINT7465 nd1995 nd1996 1.085447291586e+00
RINT7466 nd1996 nd1997 1.085447291586e+00
RINT7467 nd1998 nd1999 1.256194947091e+01
RINT7468 nd1999 nd2000 1.312513251013e+01
RINT7469 nd2000 nd2001 2.955645723751e+00
RINT7470 nd2001 nd2002 1.266355173517e+01
RINT7471 nd2002 nd2003 1.718624878345e+01
RINT7472 nd2003 nd2004 1.266355173517e+01
RINT7473 nd2004 nd2005 1.266355173517e+01
RINT7474 nd2005 nd2006 1.266355173517e+01
RINT7475 nd2006 nd2007 1.266355173517e+01
RINT7476 nd2007 nd2008 1.266355173517e+01
RINT7477 nd2008 nd2009 1.266355173517e+01
RINT7478 nd2009 nd2010 8.140854686898e+01
RINT7479 nd2010 nd2011 8.086582322319e+01
RINT7480 nd2011 nd2012 6.331775867587e+00
RINT7481 nd2012 nd2013 1.085447291586e+00
RINT7482 nd2013 nd2014 1.085447291586e+00
RINT7483 nd2014 nd2015 1.085447291586e+00
RINT7484 nd2016 nd2017 2.048241000247e+02
RINT7485 nd2017 nd2018 2.140068673511e+02
RINT7486 nd2018 nd2019 4.819215972495e+01
RINT7487 nd2019 nd2020 2.064807371880e+02
RINT7488 nd2020 nd2021 2.802238576123e+02
RINT7489 nd2021 nd2022 2.064807371880e+02
RINT7490 nd2022 nd2023 2.064807371880e+02
RINT7491 nd2023 nd2024 2.064807371880e+02
RINT7492 nd2024 nd2025 2.064807371880e+02
RINT7493 nd2025 nd2026 2.064807371880e+02
RINT7494 nd2026 nd2027 2.064807371880e+02
RINT7495 nd2027 nd2028 1.327376167637e+03
RINT7496 nd2028 nd2029 1.318526993186e+03
RINT7497 nd2029 nd2030 1.032403685940e+02
RINT7498 nd2030 nd2031 1.769834890183e+01
RINT7499 nd2031 nd2032 1.769834890183e+01
RINT7500 nd2032 nd2033 1.769834890183e+01
RINT7501 nd2034 nd2035 1.109118533123e+01
RINT7502 nd2035 nd2036 1.158843040278e+01
RINT7503 nd2036 nd2037 2.609596111773e+00
RINT7504 nd2037 nd2038 1.118089191265e+01
RINT7505 nd2038 nd2039 1.517406759574e+01
RINT7506 nd2039 nd2040 1.118089191265e+01
RINT7507 nd2040 nd2041 1.118089191265e+01
RINT7508 nd2041 nd2042 1.118089191265e+01
RINT7509 nd2042 nd2043 1.118089191265e+01
RINT7510 nd2043 nd2044 1.118089191265e+01
RINT7511 nd2044 nd2045 1.118089191265e+01
RINT7512 nd2045 nd2046 7.187716229562e+01
RINT7513 nd2046 nd2047 7.139798121365e+01
RINT7514 nd2047 nd2048 5.590445956326e+00
RINT7515 nd2048 nd2049 9.583621639417e-01
RINT7516 nd2049 nd2050 9.583621639417e-01
RINT7517 nd2050 nd2051 9.583621639417e-01
RINT7518 nd2052 nd2053 1.109118533123e+01
RINT7519 nd2053 nd2054 1.158843040278e+01
RINT7520 nd2054 nd2055 2.609596111773e+00
RINT7521 nd2055 nd2056 1.118089191265e+01
RINT7522 nd2056 nd2057 1.517406759574e+01
RINT7523 nd2057 nd2058 1.118089191265e+01
RINT7524 nd2058 nd2059 1.118089191265e+01
RINT7525 nd2059 nd2060 1.118089191265e+01
RINT7526 nd2060 nd2061 1.118089191265e+01
RINT7527 nd2061 nd2062 1.118089191265e+01
RINT7528 nd2062 nd2063 1.118089191265e+01
RINT7529 nd2063 nd2064 7.187716229562e+01
RINT7530 nd2064 nd2065 7.139798121365e+01
RINT7531 nd2065 nd2066 5.590445956326e+00
RINT7532 nd2066 nd2067 9.583621639417e-01
RINT7533 nd2067 nd2068 9.583621639417e-01
RINT7534 nd2068 nd2069 9.583621639417e-01
RINT7535 nd2070 nd2071 2.048247584516e+02
RINT7536 nd2071 nd2072 2.140075552969e+02
RINT7537 nd2072 nd2073 4.819231464332e+01
RINT7538 nd2073 nd2074 2.064814009404e+02
RINT7539 nd2074 nd2075 2.802247584191e+02
RINT7540 nd2075 nd2076 2.064814009404e+02
RINT7541 nd2076 nd2077 2.064814009404e+02
RINT7542 nd2077 nd2078 2.064814009404e+02
RINT7543 nd2078 nd2079 2.064814009404e+02
RINT7544 nd2079 nd2080 2.064814009404e+02
RINT7545 nd2080 nd2081 2.064814009404e+02
RINT7546 nd2081 nd2082 1.327380434617e+03
RINT7547 nd2082 nd2083 1.318531231719e+03
RINT7548 nd2083 nd2084 1.032407004702e+02
RINT7549 nd2084 nd2085 1.769840579489e+01
RINT7550 nd2085 nd2086 1.769840579489e+01
RINT7551 nd2086 nd2087 1.769840579489e+01
RINT7552 nd2088 nd2089 1.256194947091e+01
RINT7553 nd2089 nd2090 1.312513251013e+01
RINT7554 nd2090 nd2091 2.955645723751e+00
RINT7555 nd2091 nd2092 1.266355173517e+01
RINT7556 nd2092 nd2093 1.718624878345e+01
RINT7557 nd2093 nd2094 1.266355173517e+01
RINT7558 nd2094 nd2095 1.266355173517e+01
RINT7559 nd2095 nd2096 1.266355173517e+01
RINT7560 nd2096 nd2097 1.266355173517e+01
RINT7561 nd2097 nd2098 1.266355173517e+01
RINT7562 nd2098 nd2099 1.266355173517e+01
RINT7563 nd2099 nd2100 8.140854686898e+01
RINT7564 nd2100 nd2101 8.086582322319e+01
RINT7565 nd2101 nd2102 6.331775867587e+00
RINT7566 nd2102 nd2103 1.085447291586e+00
RINT7567 nd2103 nd2104 1.085447291586e+00
RINT7568 nd2104 nd2105 1.085447291586e+00
RINT7569 nd2106 nd2107 1.256194947091e+01
RINT7570 nd2107 nd2108 1.312513251013e+01
RINT7571 nd2108 nd2109 2.955645723751e+00
RINT7572 nd2109 nd2110 1.266355173517e+01
RINT7573 nd2110 nd2111 1.718624878345e+01
RINT7574 nd2111 nd2112 1.266355173517e+01
RINT7575 nd2112 nd2113 1.266355173517e+01
RINT7576 nd2113 nd2114 1.266355173517e+01
RINT7577 nd2114 nd2115 1.266355173517e+01
RINT7578 nd2115 nd2116 1.266355173517e+01
RINT7579 nd2116 nd2117 1.266355173517e+01
RINT7580 nd2117 nd2118 8.140854686898e+01
RINT7581 nd2118 nd2119 8.086582322319e+01
RINT7582 nd2119 nd2120 6.331775867587e+00
RINT7583 nd2120 nd2121 1.085447291586e+00
RINT7584 nd2121 nd2122 1.085447291586e+00
RINT7585 nd2122 nd2123 1.085447291586e+00
RINT7586 nd2124 nd2125 4.736548367769e+01
RINT7587 nd2125 nd2126 4.948899461153e+01
RINT7588 nd2126 nd2127 1.114441588939e+01
RINT7589 nd2127 nd2128 4.774858029822e+01
RINT7590 nd2128 nd2129 6.480164469044e+01
RINT7591 nd2129 nd2130 4.774858029822e+01
RINT7592 nd2130 nd2131 4.774858029822e+01
RINT7593 nd2131 nd2132 4.774858029822e+01
RINT7594 nd2132 nd2133 4.774858029822e+01
RINT7595 nd2133 nd2134 4.774858029822e+01
RINT7596 nd2134 nd2135 4.774858029822e+01
RINT7597 nd2135 nd2136 3.069551590600e+02
RINT7598 nd2136 nd2137 3.049087913329e+02
RINT7599 nd2137 nd2138 2.387429014911e+01
RINT7600 nd2138 nd2139 4.092735454133e+00
RINT7601 nd2139 nd2140 4.092735454133e+00
RINT7602 nd2140 nd2141 4.092735454133e+00
RINT7603 nd2142 nd2143 1.864653966342e+03
RINT7604 nd2143 nd2144 1.948250982099e+03
RINT7605 nd2144 nd2145 1.735634542755e+04
RINT7606 nd2145 nd2146 1.203030699687e+05
RINT7607 nd2146 nd2147 1.632684521003e+05
RINT7608 nd2147 nd2148 1.203030699687e+05
RINT7609 nd2148 nd2149 1.203030699687e+05
RINT7610 nd2149 nd2150 1.203030699687e+05
RINT7611 nd2150 nd2151 1.203030699687e+05
RINT7612 nd2151 nd2152 1.203030699687e+05
RINT7613 nd2152 nd2153 1.203030699687e+05
RINT7614 nd2153 nd2154 7.733768783700e+05
RINT7615 nd2154 nd2155 7.140846510283e+05
RINT7616 nd2155 nd2156 9.398677341302e+02
RINT7617 nd2156 nd2157 1.611201829938e+02
RINT7618 nd2157 nd2158 1.611201829938e+02
RINT7619 nd2158 nd2159 1.611201829938e+02
RINT7620 nd2160 nd2161 2.187171135207e+04
RINT7621 nd2161 nd2162 2.285227387549e+04
RINT7622 nd2162 nd2163 2.035836054145e+05
RINT7623 nd2163 nd2164 1.411111159828e+06
RINT7624 nd2164 nd2165 1.915079431195e+06
RINT7625 nd2165 nd2166 1.411111159828e+06
RINT7626 nd2166 nd2167 1.411111159828e+06
RINT7627 nd2167 nd2168 1.411111159828e+06
RINT7628 nd2168 nd2169 1.411111159828e+06
RINT7629 nd2169 nd2170 1.411111159828e+06
RINT7630 nd2170 nd2171 1.411111159828e+06
RINT7631 nd2171 nd2172 9.071428884609e+06
RINT7632 nd2172 nd2173 8.375952670122e+06
RINT7633 nd2173 nd2174 1.102430593616e+04
RINT7634 nd2174 nd2175 1.889881017627e+03
RINT7635 nd2175 nd2176 1.889881017627e+03
RINT7636 nd2176 nd2177 1.889881017627e+03
RINT7637 nd2178 nd2179 5.555635998372e+02
RINT7638 nd2179 nd2180 5.804708801413e+02
RINT7639 nd2180 nd2181 5.231507033365e+01
RINT7640 nd2181 nd2182 8.021124442285e+00
RINT7641 nd2182 nd2183 1.631066650403e+01
RINT7642 nd2183 nd2184 1.979330390049e+01
RINT7643 nd2184 nd2185 1.979330390049e+01
RINT7644 nd2185 nd2186 1.979330390049e+01
RINT7645 nd2186 nd2187 1.979330390049e+01
RINT7646 nd2187 nd2188 1.979330390049e+01
RINT7647 nd2188 nd2189 1.979330390049e+01
RINT7648 nd2189 nd2190 6.041539607445e+01
RINT7649 nd2190 nd2191 3.065448250628e+02
RINT7650 nd2191 nd2192 2.800285260265e+02
RINT7651 nd2192 nd2193 4.800489017598e+01
RINT7652 nd2193 nd2194 4.800489017598e+01
RINT7653 nd2194 nd2195 4.800489017598e+01
RINT7654 nd2196 nd2197 1.473427763669e+02
RINT7655 nd2197 nd2198 1.539485148149e+02
RINT7656 nd2198 nd2199 1.387464497503e+01
RINT7657 nd2199 nd2200 2.127307738047e+00
RINT7658 nd2200 nd2201 4.325803360412e+00
RINT7659 nd2201 nd2202 5.249444619890e+00
RINT7660 nd2202 nd2203 5.249444619890e+00
RINT7661 nd2203 nd2204 5.249444619890e+00
RINT7662 nd2204 nd2205 5.249444619890e+00
RINT7663 nd2205 nd2206 5.249444619890e+00
RINT7664 nd2206 nd2207 5.249444619890e+00
RINT7665 nd2207 nd2208 1.602295793952e+01
RINT7666 nd2208 nd2209 8.129972089405e+01
RINT7667 nd2209 nd2210 7.426724950803e+01
RINT7668 nd2210 nd2211 1.273152848709e+01
RINT7669 nd2211 nd2212 1.273152848709e+01
RINT7670 nd2212 nd2213 1.273152848709e+01
RINT7671 nd2214 nd2215 1.473427763669e+02
RINT7672 nd2215 nd2216 1.539485148149e+02
RINT7673 nd2216 nd2217 1.387464497503e+01
RINT7674 nd2217 nd2218 2.127307738047e+00
RINT7675 nd2218 nd2219 4.325803360412e+00
RINT7676 nd2219 nd2220 5.249444619890e+00
RINT7677 nd2220 nd2221 5.249444619890e+00
RINT7678 nd2221 nd2222 5.249444619890e+00
RINT7679 nd2222 nd2223 5.249444619890e+00
RINT7680 nd2223 nd2224 5.249444619890e+00
RINT7681 nd2224 nd2225 5.249444619890e+00
RINT7682 nd2225 nd2226 1.602295793952e+01
RINT7683 nd2226 nd2227 8.129972089405e+01
RINT7684 nd2227 nd2228 7.426724950803e+01
RINT7685 nd2228 nd2229 1.273152848709e+01
RINT7686 nd2229 nd2230 1.273152848709e+01
RINT7687 nd2230 nd2231 1.273152848709e+01
RINT7688 nd2232 nd2233 2.402441725655e+03
RINT7689 nd2233 nd2234 2.510149087139e+03
RINT7690 nd2234 nd2235 5.652599247780e+02
RINT7691 nd2235 nd2236 2.421872907069e+03
RINT7692 nd2236 nd2237 3.286827516737e+03
RINT7693 nd2237 nd2238 2.421872907069e+03
RINT7694 nd2238 nd2239 2.421872907069e+03
RINT7695 nd2239 nd2240 2.421872907069e+03
RINT7696 nd2240 nd2241 2.421872907069e+03
RINT7697 nd2241 nd2242 2.421872907069e+03
RINT7698 nd2242 nd2243 2.421872907069e+03
RINT7699 nd2243 nd2244 1.556918297402e+04
RINT7700 nd2244 nd2245 1.546538842086e+04
RINT7701 nd2245 nd2246 1.210936453535e+03
RINT7702 nd2246 nd2247 2.075891063202e+02
RINT7703 nd2247 nd2248 2.075891063202e+02
RINT7704 nd2248 nd2249 2.075891063202e+02
RINT7705 nd2250 nd2251 1.300917539661e+02
RINT7706 nd2251 nd2252 1.359240867219e+02
RINT7707 nd2252 nd2253 3.060871540642e+01
RINT7708 nd2253 nd2254 1.311439486748e+02
RINT7709 nd2254 nd2255 1.779810732015e+02
RINT7710 nd2255 nd2256 1.311439486748e+02
RINT7711 nd2256 nd2257 1.311439486748e+02
RINT7712 nd2257 nd2258 1.311439486748e+02
RINT7713 nd2258 nd2259 1.311439486748e+02
RINT7714 nd2259 nd2260 1.311439486748e+02
RINT7715 nd2260 nd2261 1.311439486748e+02
RINT7716 nd2261 nd2262 8.430682414809e+02
RINT7717 nd2262 nd2263 8.374477865377e+02
RINT7718 nd2263 nd2264 6.557197433740e+01
RINT7719 nd2264 nd2265 1.124090988641e+01
RINT7720 nd2265 nd2266 1.124090988641e+01
RINT7721 nd2266 nd2267 1.124090988641e+01
RINT7722 nd2268 nd2269 1.300917539661e+02
RINT7723 nd2269 nd2270 1.359240867219e+02
RINT7724 nd2270 nd2271 3.060871540642e+01
RINT7725 nd2271 nd2272 1.311439486748e+02
RINT7726 nd2272 nd2273 1.779810732015e+02
RINT7727 nd2273 nd2274 1.311439486748e+02
RINT7728 nd2274 nd2275 1.311439486748e+02
RINT7729 nd2275 nd2276 1.311439486748e+02
RINT7730 nd2276 nd2277 1.311439486748e+02
RINT7731 nd2277 nd2278 1.311439486748e+02
RINT7732 nd2278 nd2279 1.311439486748e+02
RINT7733 nd2279 nd2280 8.430682414809e+02
RINT7734 nd2280 nd2281 8.374477865377e+02
RINT7735 nd2281 nd2282 6.557197433740e+01
RINT7736 nd2282 nd2283 1.124090988641e+01
RINT7737 nd2283 nd2284 1.124090988641e+01
RINT7738 nd2284 nd2285 1.124090988641e+01
RINT7739 nd2286 nd2287 2.402449448537e+03
RINT7740 nd2287 nd2288 2.510157156257e+03
RINT7741 nd2288 nd2289 5.652617418608e+02
RINT7742 nd2289 nd2290 2.421880692414e+03
RINT7743 nd2290 nd2291 3.286838082562e+03
RINT7744 nd2291 nd2292 2.421880692414e+03
RINT7745 nd2292 nd2293 2.421880692414e+03
RINT7746 nd2293 nd2294 2.421880692414e+03
RINT7747 nd2294 nd2295 2.421880692414e+03
RINT7748 nd2295 nd2296 2.421880692414e+03
RINT7749 nd2296 nd2297 2.421880692414e+03
RINT7750 nd2297 nd2298 1.556923302266e+04
RINT7751 nd2298 nd2299 1.546543813585e+04
RINT7752 nd2299 nd2300 1.210940346207e+03
RINT7753 nd2300 nd2301 2.075897736355e+02
RINT7754 nd2301 nd2302 2.075897736355e+02
RINT7755 nd2302 nd2303 2.075897736355e+02
RINT7756 nd2304 nd2305 1.473427763669e+02
RINT7757 nd2305 nd2306 1.539485148149e+02
RINT7758 nd2306 nd2307 1.387464497503e+01
RINT7759 nd2307 nd2308 2.127307738047e+00
RINT7760 nd2308 nd2309 4.325803360412e+00
RINT7761 nd2309 nd2310 5.249444619890e+00
RINT7762 nd2310 nd2311 5.249444619890e+00
RINT7763 nd2311 nd2312 5.249444619890e+00
RINT7764 nd2312 nd2313 5.249444619890e+00
RINT7765 nd2313 nd2314 5.249444619890e+00
RINT7766 nd2314 nd2315 5.249444619890e+00
RINT7767 nd2315 nd2316 1.602295793952e+01
RINT7768 nd2316 nd2317 8.129972089405e+01
RINT7769 nd2317 nd2318 7.426724950803e+01
RINT7770 nd2318 nd2319 1.273152848709e+01
RINT7771 nd2319 nd2320 1.273152848709e+01
RINT7772 nd2320 nd2321 1.273152848709e+01
RINT7773 nd2322 nd2323 1.473427763669e+02
RINT7774 nd2323 nd2324 1.539485148149e+02
RINT7775 nd2324 nd2325 1.387464497503e+01
RINT7776 nd2325 nd2326 2.127307738047e+00
RINT7777 nd2326 nd2327 4.325803360412e+00
RINT7778 nd2327 nd2328 5.249444619890e+00
RINT7779 nd2328 nd2329 5.249444619890e+00
RINT7780 nd2329 nd2330 5.249444619890e+00
RINT7781 nd2330 nd2331 5.249444619890e+00
RINT7782 nd2331 nd2332 5.249444619890e+00
RINT7783 nd2332 nd2333 5.249444619890e+00
RINT7784 nd2333 nd2334 1.602295793952e+01
RINT7785 nd2334 nd2335 8.129972089405e+01
RINT7786 nd2335 nd2336 7.426724950803e+01
RINT7787 nd2336 nd2337 1.273152848709e+01
RINT7788 nd2337 nd2338 1.273152848709e+01
RINT7789 nd2338 nd2339 1.273152848709e+01
RINT7790 nd2340 nd2341 5.555635998372e+02
RINT7791 nd2341 nd2342 5.804708801413e+02
RINT7792 nd2342 nd2343 5.231507033365e+01
RINT7793 nd2343 nd2344 8.021124442285e+00
RINT7794 nd2344 nd2345 1.631066650403e+01
RINT7795 nd2345 nd2346 1.979330390049e+01
RINT7796 nd2346 nd2347 1.979330390049e+01
RINT7797 nd2347 nd2348 1.979330390049e+01
RINT7798 nd2348 nd2349 1.979330390049e+01
RINT7799 nd2349 nd2350 1.979330390049e+01
RINT7800 nd2350 nd2351 1.979330390049e+01
RINT7801 nd2351 nd2352 6.041539607445e+01
RINT7802 nd2352 nd2353 3.065448250628e+02
RINT7803 nd2353 nd2354 2.800285260265e+02
RINT7804 nd2354 nd2355 4.800489017598e+01
RINT7805 nd2355 nd2356 4.800489017598e+01
RINT7806 nd2356 nd2357 4.800489017598e+01
RINT7807 nd2358 nd2359 2.187107128560e+04
RINT7808 nd2359 nd2360 2.285160511327e+04
RINT7809 nd2360 nd2361 2.035776476255e+05
RINT7810 nd2361 nd2362 1.411069864251e+06
RINT7811 nd2362 nd2363 1.915023387198e+06
RINT7812 nd2363 nd2364 1.411069864251e+06
RINT7813 nd2364 nd2365 1.411069864251e+06
RINT7814 nd2365 nd2366 1.411069864251e+06
RINT7815 nd2366 nd2367 1.411069864251e+06
RINT7816 nd2367 nd2368 1.411069864251e+06
RINT7817 nd2368 nd2369 1.411069864251e+06
RINT7818 nd2369 nd2370 9.071163413042e+06
RINT7819 nd2370 nd2371 8.375707551376e+06
RINT7820 nd2371 nd2372 1.102398331446e+04
RINT7821 nd2372 nd2373 1.889825711051e+03
RINT7822 nd2373 nd2374 1.889825711051e+03
RINT7823 nd2374 nd2375 1.889825711051e+03
RINT7824 nd2376 nd2377 8.432218599453e+01
RINT7825 nd2377 nd2378 8.810255663623e+01
RINT7826 nd2378 nd2379 7.848775235218e+02
RINT7827 nd2379 nd2380 5.440268288230e+03
RINT7828 nd2380 nd2381 7.383221248312e+03
RINT7829 nd2381 nd2382 5.440268288230e+03
RINT7830 nd2382 nd2383 5.440268288230e+03
RINT7831 nd2383 nd2384 5.440268288230e+03
RINT7832 nd2384 nd2385 5.440268288230e+03
RINT7833 nd2385 nd2386 5.440268288230e+03
RINT7834 nd2386 nd2387 5.440268288230e+03
RINT7835 nd2387 nd2388 3.497315328148e+04
RINT7836 nd2388 nd2389 3.229187819656e+04
RINT7837 nd2389 nd2390 4.250209600179e+01
RINT7838 nd2390 nd2391 7.286073600307e+00
RINT7839 nd2391 nd2392 7.286073600307e+00
RINT7840 nd2392 nd2393 7.286073600307e+00
RINT7841 nd2394 nd2395 2.141868847992e+00
RINT7842 nd2395 nd2396 2.237894087563e+00
RINT7843 nd2396 nd2397 2.016907145482e-01
RINT7844 nd2397 nd2398 3.092390605473e-02
RINT7845 nd2398 nd2399 6.288264473266e-02
RINT7846 nd2399 nd2400 7.630928490583e-02
RINT7847 nd2400 nd2401 7.630928490583e-02
RINT7848 nd2401 nd2402 7.630928490583e-02
RINT7849 nd2402 nd2403 7.630928490583e-02
RINT7850 nd2403 nd2404 7.630928490583e-02
RINT7851 nd2404 nd2405 7.630928490583e-02
RINT7852 nd2405 nd2406 2.329199660109e-01
RINT7853 nd2406 nd2407 1.181824747891e+00
RINT7854 nd2407 nd2408 1.079596245364e+00
RINT7855 nd2408 nd2409 1.850736420624e-01
RINT7856 nd2409 nd2410 1.850736420624e-01
RINT7857 nd2410 nd2411 1.850736420624e-01
RINT7858 nd2412 nd2413 5.680517995949e-01
RINT7859 nd2413 nd2414 5.935189565574e-01
RINT7860 nd2414 nd2415 5.349103119367e-02
RINT7861 nd2415 nd2416 8.201426759329e-03
RINT7862 nd2416 nd2417 1.667730474588e-02
RINT7863 nd2417 nd2418 2.023822637749e-02
RINT7864 nd2418 nd2419 2.023822637749e-02
RINT7865 nd2419 nd2420 2.023822637749e-02
RINT7866 nd2420 nd2421 2.023822637749e-02
RINT7867 nd2421 nd2422 2.023822637749e-02
RINT7868 nd2422 nd2423 2.023822637749e-02
RINT7869 nd2423 nd2424 6.177343957269e-02
RINT7870 nd2424 nd2425 3.134354727063e-01
RINT7871 nd2425 nd2426 2.863231287901e-01
RINT7872 nd2426 nd2427 4.908396493544e-02
RINT7873 nd2427 nd2428 4.908396493544e-02
RINT7874 nd2428 nd2429 4.908396493544e-02
RINT7875 nd2430 nd2431 5.680517995949e-01
RINT7876 nd2431 nd2432 5.935189565574e-01
RINT7877 nd2432 nd2433 5.349103119367e-02
RINT7878 nd2433 nd2434 8.201426759329e-03
RINT7879 nd2434 nd2435 1.667730474588e-02
RINT7880 nd2435 nd2436 2.023822637749e-02
RINT7881 nd2436 nd2437 2.023822637749e-02
RINT7882 nd2437 nd2438 2.023822637749e-02
RINT7883 nd2438 nd2439 2.023822637749e-02
RINT7884 nd2439 nd2440 2.023822637749e-02
RINT7885 nd2440 nd2441 2.023822637749e-02
RINT7886 nd2441 nd2442 6.177343957269e-02
RINT7887 nd2442 nd2443 3.134354727063e-01
RINT7888 nd2443 nd2444 2.863231287901e-01
RINT7889 nd2444 nd2445 4.908396493544e-02
RINT7890 nd2445 nd2446 4.908396493544e-02
RINT7891 nd2446 nd2447 4.908396493544e-02
RINT7892 nd2448 nd2449 9.262153051071e+00
RINT7893 nd2449 nd2450 9.677398114516e+00
RINT7894 nd2450 nd2451 2.179251168102e+00
RINT7895 nd2451 nd2452 9.337066242221e+00
RINT7896 nd2452 nd2453 1.267173275730e+01
RINT7897 nd2453 nd2454 9.337066242221e+00
RINT7898 nd2454 nd2455 9.337066242221e+00
RINT7899 nd2455 nd2456 9.337066242221e+00
RINT7900 nd2456 nd2457 9.337066242221e+00
RINT7901 nd2457 nd2458 9.337066242221e+00
RINT7902 nd2458 nd2459 9.337066242221e+00
RINT7903 nd2459 nd2460 6.002399727142e+01
RINT7904 nd2460 nd2461 5.962383728961e+01
RINT7905 nd2461 nd2462 4.668533121110e+00
RINT7906 nd2462 nd2463 8.003199636189e-01
RINT7907 nd2463 nd2464 8.003199636189e-01
RINT7908 nd2464 nd2465 8.003199636189e-01
RINT7909 nd2466 nd2467 5.015437931537e-01
RINT7910 nd2467 nd2468 5.240292328847e-01
RINT7911 nd2468 nd2469 4.722825401436e-02
RINT7912 nd2469 nd2470 7.241196470252e-03
RINT7913 nd2470 nd2471 1.472471117563e-02
RINT7914 nd2471 nd2472 1.786871695735e-02
RINT7915 nd2472 nd2473 1.786871695735e-02
RINT7916 nd2473 nd2474 1.786871695735e-02
RINT7917 nd2474 nd2475 1.786871695735e-02
RINT7918 nd2475 nd2476 1.786871695735e-02
RINT7919 nd2476 nd2477 1.786871695735e-02
RINT7920 nd2477 nd2478 5.454095070473e-02
RINT7921 nd2478 nd2479 2.767381707129e-01
RINT7922 nd2479 nd2480 2.528001639700e-01
RINT7923 nd2480 nd2481 4.333717096628e-02
RINT7924 nd2481 nd2482 4.333717096628e-02
RINT7925 nd2482 nd2483 4.333717096628e-02
RINT7926 nd2484 nd2485 5.015437931537e-01
RINT7927 nd2485 nd2486 5.240292328847e-01
RINT7928 nd2486 nd2487 4.722825401436e-02
RINT7929 nd2487 nd2488 7.241196470252e-03
RINT7930 nd2488 nd2489 1.472471117563e-02
RINT7931 nd2489 nd2490 1.786871695735e-02
RINT7932 nd2490 nd2491 1.786871695735e-02
RINT7933 nd2491 nd2492 1.786871695735e-02
RINT7934 nd2492 nd2493 1.786871695735e-02
RINT7935 nd2493 nd2494 1.786871695735e-02
RINT7936 nd2494 nd2495 1.786871695735e-02
RINT7937 nd2495 nd2496 5.454095070473e-02
RINT7938 nd2496 nd2497 2.767381707129e-01
RINT7939 nd2497 nd2498 2.528001639700e-01
RINT7940 nd2498 nd2499 4.333717096628e-02
RINT7941 nd2499 nd2500 4.333717096628e-02
RINT7942 nd2500 nd2501 4.333717096628e-02
RINT7943 nd2502 nd2503 9.262182825159e+00
RINT7944 nd2503 nd2504 9.677429223449e+00
RINT7945 nd2504 nd2505 2.179258173516e+00
RINT7946 nd2505 nd2506 9.337096257125e+00
RINT7947 nd2506 nd2507 1.267177349181e+01
RINT7948 nd2507 nd2508 9.337096257125e+00
RINT7949 nd2508 nd2509 9.337096257125e+00
RINT7950 nd2509 nd2510 9.337096257125e+00
RINT7951 nd2510 nd2511 9.337096257125e+00
RINT7952 nd2511 nd2512 9.337096257125e+00
RINT7953 nd2512 nd2513 9.337096257125e+00
RINT7954 nd2513 nd2514 6.002419022437e+01
RINT7955 nd2514 nd2515 5.962402895621e+01
RINT7956 nd2515 nd2516 4.668548128562e+00
RINT7957 nd2516 nd2517 8.003225363250e-01
RINT7958 nd2517 nd2518 8.003225363250e-01
RINT7959 nd2518 nd2519 8.003225363250e-01
RINT7960 nd2520 nd2521 5.680517995949e-01
RINT7961 nd2521 nd2522 5.935189565574e-01
RINT7962 nd2522 nd2523 5.349103119367e-02
RINT7963 nd2523 nd2524 8.201426759329e-03
RINT7964 nd2524 nd2525 1.667730474588e-02
RINT7965 nd2525 nd2526 2.023822637749e-02
RINT7966 nd2526 nd2527 2.023822637749e-02
RINT7967 nd2527 nd2528 2.023822637749e-02
RINT7968 nd2528 nd2529 2.023822637749e-02
RINT7969 nd2529 nd2530 2.023822637749e-02
RINT7970 nd2530 nd2531 2.023822637749e-02
RINT7971 nd2531 nd2532 6.177343957269e-02
RINT7972 nd2532 nd2533 3.134354727063e-01
RINT7973 nd2533 nd2534 2.863231287901e-01
RINT7974 nd2534 nd2535 4.908396493544e-02
RINT7975 nd2535 nd2536 4.908396493544e-02
RINT7976 nd2536 nd2537 4.908396493544e-02
RINT7977 nd2538 nd2539 5.680517995949e-01
RINT7978 nd2539 nd2540 5.935189565574e-01
RINT7979 nd2540 nd2541 5.349103119367e-02
RINT7980 nd2541 nd2542 8.201426759329e-03
RINT7981 nd2542 nd2543 1.667730474588e-02
RINT7982 nd2543 nd2544 2.023822637749e-02
RINT7983 nd2544 nd2545 2.023822637749e-02
RINT7984 nd2545 nd2546 2.023822637749e-02
RINT7985 nd2546 nd2547 2.023822637749e-02
RINT7986 nd2547 nd2548 2.023822637749e-02
RINT7987 nd2548 nd2549 2.023822637749e-02
RINT7988 nd2549 nd2550 6.177343957269e-02
RINT7989 nd2550 nd2551 3.134354727063e-01
RINT7990 nd2551 nd2552 2.863231287901e-01
RINT7991 nd2552 nd2553 4.908396493544e-02
RINT7992 nd2553 nd2554 4.908396493544e-02
RINT7993 nd2554 nd2555 4.908396493544e-02
RINT7994 nd2556 nd2557 2.141868847992e+00
RINT7995 nd2557 nd2558 2.237894087563e+00
RINT7996 nd2558 nd2559 2.016907145482e-01
RINT7997 nd2559 nd2560 3.092390605473e-02
RINT7998 nd2560 nd2561 6.288264473266e-02
RINT7999 nd2561 nd2562 7.630928490583e-02
RINT8000 nd2562 nd2563 7.630928490583e-02
RINT8001 nd2563 nd2564 7.630928490583e-02
RINT8002 nd2564 nd2565 7.630928490583e-02
RINT8003 nd2565 nd2566 7.630928490583e-02
RINT8004 nd2566 nd2567 7.630928490584e-02
RINT8005 nd2567 nd2568 2.329199660109e-01
RINT8006 nd2568 nd2569 1.181824747891e+00
RINT8007 nd2569 nd2570 1.079596245364e+00
RINT8008 nd2570 nd2571 1.850736420624e-01
RINT8009 nd2571 nd2572 1.850736420624e-01
RINT8010 nd2572 nd2573 1.850736420624e-01
RINT8011 nd2574 nd2575 8.431971834108e+01
RINT8012 nd2575 nd2576 8.809997835181e+01
RINT8013 nd2576 nd2577 7.848545544098e+02
RINT8014 nd2577 nd2578 5.440109081057e+03
RINT8015 nd2578 nd2579 7.383005181435e+03
RINT8016 nd2579 nd2580 5.440109081057e+03
RINT8017 nd2580 nd2581 5.440109081057e+03
RINT8018 nd2581 nd2582 5.440109081057e+03
RINT8019 nd2582 nd2583 5.440109081057e+03
RINT8020 nd2583 nd2584 5.440109081057e+03
RINT8021 nd2584 nd2585 5.440109081057e+03
RINT8022 nd2585 nd2586 3.497212980680e+04
RINT8023 nd2586 nd2587 3.229093318827e+04
RINT8024 nd2587 nd2588 4.250085219576e+01
RINT8025 nd2588 nd2589 7.285860376416e+00
RINT8026 nd2589 nd2590 7.285860376416e+00
RINT8027 nd2590 nd2591 7.285860376416e+00
RINT8028 nd2592 nd2593 2.187171135207e+04
RINT8029 nd2593 nd2594 2.285227387549e+04
RINT8030 nd2594 nd2595 2.035836054145e+05
RINT8031 nd2595 nd2596 1.411111159828e+06
RINT8032 nd2596 nd2597 1.915079431195e+06
RINT8033 nd2597 nd2598 1.411111159828e+06
RINT8034 nd2598 nd2599 1.411111159828e+06
RINT8035 nd2599 nd2600 1.411111159828e+06
RINT8036 nd2600 nd2601 1.411111159828e+06
RINT8037 nd2601 nd2602 1.411111159828e+06
RINT8038 nd2602 nd2603 1.411111159828e+06
RINT8039 nd2603 nd2604 9.071428884609e+06
RINT8040 nd2604 nd2605 8.375952670122e+06
RINT8041 nd2605 nd2606 1.102430593616e+04
RINT8042 nd2606 nd2607 1.889881017627e+03
RINT8043 nd2607 nd2608 1.889881017627e+03
RINT8044 nd2608 nd2609 1.889881017627e+03
RINT8045 nd2610 nd2611 5.555635998372e+02
RINT8046 nd2611 nd2612 5.804708801413e+02
RINT8047 nd2612 nd2613 1.307161107384e+02
RINT8048 nd2613 nd2614 5.600570520531e+02
RINT8049 nd2614 nd2615 7.600774277863e+02
RINT8050 nd2615 nd2616 5.600570520531e+02
RINT8051 nd2616 nd2617 5.600570520531e+02
RINT8052 nd2617 nd2618 5.600570520531e+02
RINT8053 nd2618 nd2619 5.600570520531e+02
RINT8054 nd2619 nd2620 5.600570520531e+02
RINT8055 nd2620 nd2621 5.600570520531e+02
RINT8056 nd2621 nd2622 3.600366763198e+03
RINT8057 nd2622 nd2623 3.576364318110e+03
RINT8058 nd2623 nd2624 2.800285260265e+02
RINT8059 nd2624 nd2625 4.800489017598e+01
RINT8060 nd2625 nd2626 4.800489017598e+01
RINT8061 nd2626 nd2627 4.800489017598e+01
RINT8062 nd2628 nd2629 1.473427763669e+02
RINT8063 nd2629 nd2630 1.539485148149e+02
RINT8064 nd2630 nd2631 3.466763243260e+01
RINT8065 nd2631 nd2632 1.485344990161e+02
RINT8066 nd2632 nd2633 2.015825343789e+02
RINT8067 nd2633 nd2634 1.485344990161e+02
RINT8068 nd2634 nd2635 1.485344990161e+02
RINT8069 nd2635 nd2636 1.485344990161e+02
RINT8070 nd2636 nd2637 1.485344990161e+02
RINT8071 nd2637 nd2638 1.485344990161e+02
RINT8072 nd2638 nd2639 1.485344990161e+02
RINT8073 nd2639 nd2640 9.548646365318e+02
RINT8074 nd2640 nd2641 9.484988722882e+02
RINT8075 nd2641 nd2642 7.426724950803e+01
RINT8076 nd2642 nd2643 1.273152848709e+01
RINT8077 nd2643 nd2644 1.273152848709e+01
RINT8078 nd2644 nd2645 1.273152848709e+01
RINT8079 nd2646 nd2647 1.473427763669e+02
RINT8080 nd2647 nd2648 1.539485148149e+02
RINT8081 nd2648 nd2649 3.466763243260e+01
RINT8082 nd2649 nd2650 1.485344990161e+02
RINT8083 nd2650 nd2651 2.015825343789e+02
RINT8084 nd2651 nd2652 1.485344990161e+02
RINT8085 nd2652 nd2653 1.485344990161e+02
RINT8086 nd2653 nd2654 1.485344990161e+02
RINT8087 nd2654 nd2655 1.485344990161e+02
RINT8088 nd2655 nd2656 1.485344990161e+02
RINT8089 nd2656 nd2657 1.485344990161e+02
RINT8090 nd2657 nd2658 9.548646365318e+02
RINT8091 nd2658 nd2659 9.484988722882e+02
RINT8092 nd2659 nd2660 7.426724950803e+01
RINT8093 nd2660 nd2661 1.273152848709e+01
RINT8094 nd2661 nd2662 1.273152848709e+01
RINT8095 nd2662 nd2663 1.273152848709e+01
RINT8096 nd2664 nd2665 2.402441725655e+03
RINT8097 nd2665 nd2666 2.510149087139e+03
RINT8098 nd2666 nd2667 5.652599247780e+02
RINT8099 nd2667 nd2668 2.421872907069e+03
RINT8100 nd2668 nd2669 3.286827516737e+03
RINT8101 nd2669 nd2670 2.421872907069e+03
RINT8102 nd2670 nd2671 2.421872907069e+03
RINT8103 nd2671 nd2672 2.421872907069e+03
RINT8104 nd2672 nd2673 2.421872907069e+03
RINT8105 nd2673 nd2674 2.421872907069e+03
RINT8106 nd2674 nd2675 2.421872907069e+03
RINT8107 nd2675 nd2676 1.556918297402e+04
RINT8108 nd2676 nd2677 1.546538842086e+04
RINT8109 nd2677 nd2678 1.210936453535e+03
RINT8110 nd2678 nd2679 2.075891063202e+02
RINT8111 nd2679 nd2680 2.075891063202e+02
RINT8112 nd2680 nd2681 2.075891063202e+02
RINT8113 nd2682 nd2683 1.300917539661e+02
RINT8114 nd2683 nd2684 1.359240867219e+02
RINT8115 nd2684 nd2685 1.225018928626e+01
RINT8116 nd2685 nd2686 1.878240669084e+00
RINT8117 nd2686 nd2687 3.819334482112e+00
RINT8118 nd2687 nd2688 4.634835007103e+00
RINT8119 nd2688 nd2689 4.634835007103e+00
RINT8120 nd2689 nd2690 4.634835007103e+00
RINT8121 nd2690 nd2691 4.634835007103e+00
RINT8122 nd2691 nd2692 4.634835007103e+00
RINT8123 nd2692 nd2693 4.634835007103e+00
RINT8124 nd2693 nd2694 1.414697587132e+01
RINT8125 nd2694 nd2695 7.178107776196e+01
RINT8126 nd2695 nd2696 6.557197433740e+01
RINT8127 nd2696 nd2697 1.124090988641e+01
RINT8128 nd2697 nd2698 1.124090988641e+01
RINT8129 nd2698 nd2699 1.124090988641e+01
RINT8130 nd2700 nd2701 1.300917539661e+02
RINT8131 nd2701 nd2702 1.359240867219e+02
RINT8132 nd2702 nd2703 1.225018928626e+01
RINT8133 nd2703 nd2704 1.878240669084e+00
RINT8134 nd2704 nd2705 3.819334482112e+00
RINT8135 nd2705 nd2706 4.634835007103e+00
RINT8136 nd2706 nd2707 4.634835007103e+00
RINT8137 nd2707 nd2708 4.634835007103e+00
RINT8138 nd2708 nd2709 4.634835007103e+00
RINT8139 nd2709 nd2710 4.634835007103e+00
RINT8140 nd2710 nd2711 4.634835007103e+00
RINT8141 nd2711 nd2712 1.414697587132e+01
RINT8142 nd2712 nd2713 7.178107776196e+01
RINT8143 nd2713 nd2714 6.557197433740e+01
RINT8144 nd2714 nd2715 1.124090988641e+01
RINT8145 nd2715 nd2716 1.124090988641e+01
RINT8146 nd2716 nd2717 1.124090988641e+01
RINT8147 nd2718 nd2719 2.402449448537e+03
RINT8148 nd2719 nd2720 2.510157156257e+03
RINT8149 nd2720 nd2721 5.652617418608e+02
RINT8150 nd2721 nd2722 2.421880692414e+03
RINT8151 nd2722 nd2723 3.286838082562e+03
RINT8152 nd2723 nd2724 2.421880692414e+03
RINT8153 nd2724 nd2725 2.421880692414e+03
RINT8154 nd2725 nd2726 2.421880692414e+03
RINT8155 nd2726 nd2727 2.421880692414e+03
RINT8156 nd2727 nd2728 2.421880692414e+03
RINT8157 nd2728 nd2729 2.421880692414e+03
RINT8158 nd2729 nd2730 1.556923302266e+04
RINT8159 nd2730 nd2731 1.546543813585e+04
RINT8160 nd2731 nd2732 1.210940346207e+03
RINT8161 nd2732 nd2733 2.075897736355e+02
RINT8162 nd2733 nd2734 2.075897736355e+02
RINT8163 nd2734 nd2735 2.075897736355e+02
RINT8164 nd2736 nd2737 1.473427763669e+02
RINT8165 nd2737 nd2738 1.539485148149e+02
RINT8166 nd2738 nd2739 3.466763243260e+01
RINT8167 nd2739 nd2740 1.485344990161e+02
RINT8168 nd2740 nd2741 2.015825343789e+02
RINT8169 nd2741 nd2742 1.485344990161e+02
RINT8170 nd2742 nd2743 1.485344990161e+02
RINT8171 nd2743 nd2744 1.485344990161e+02
RINT8172 nd2744 nd2745 1.485344990161e+02
RINT8173 nd2745 nd2746 1.485344990161e+02
RINT8174 nd2746 nd2747 1.485344990161e+02
RINT8175 nd2747 nd2748 9.548646365318e+02
RINT8176 nd2748 nd2749 9.484988722882e+02
RINT8177 nd2749 nd2750 7.426724950803e+01
RINT8178 nd2750 nd2751 1.273152848709e+01
RINT8179 nd2751 nd2752 1.273152848709e+01
RINT8180 nd2752 nd2753 1.273152848709e+01
RINT8181 nd2754 nd2755 1.473427763669e+02
RINT8182 nd2755 nd2756 1.539485148149e+02
RINT8183 nd2756 nd2757 3.466763243260e+01
RINT8184 nd2757 nd2758 1.485344990161e+02
RINT8185 nd2758 nd2759 2.015825343789e+02
RINT8186 nd2759 nd2760 1.485344990161e+02
RINT8187 nd2760 nd2761 1.485344990161e+02
RINT8188 nd2761 nd2762 1.485344990161e+02
RINT8189 nd2762 nd2763 1.485344990161e+02
RINT8190 nd2763 nd2764 1.485344990161e+02
RINT8191 nd2764 nd2765 1.485344990161e+02
RINT8192 nd2765 nd2766 9.548646365318e+02
RINT8193 nd2766 nd2767 9.484988722882e+02
RINT8194 nd2767 nd2768 7.426724950803e+01
RINT8195 nd2768 nd2769 1.273152848709e+01
RINT8196 nd2769 nd2770 1.273152848709e+01
RINT8197 nd2770 nd2771 1.273152848709e+01
RINT8198 nd2772 nd2773 5.555635998372e+02
RINT8199 nd2773 nd2774 5.804708801413e+02
RINT8200 nd2774 nd2775 1.307161107384e+02
RINT8201 nd2775 nd2776 5.600570520531e+02
RINT8202 nd2776 nd2777 7.600774277863e+02
RINT8203 nd2777 nd2778 5.600570520531e+02
RINT8204 nd2778 nd2779 5.600570520531e+02
RINT8205 nd2779 nd2780 5.600570520531e+02
RINT8206 nd2780 nd2781 5.600570520531e+02
RINT8207 nd2781 nd2782 5.600570520531e+02
RINT8208 nd2782 nd2783 5.600570520531e+02
RINT8209 nd2783 nd2784 3.600366763198e+03
RINT8210 nd2784 nd2785 3.576364318110e+03
RINT8211 nd2785 nd2786 2.800285260265e+02
RINT8212 nd2786 nd2787 4.800489017598e+01
RINT8213 nd2787 nd2788 4.800489017598e+01
RINT8214 nd2788 nd2789 4.800489017598e+01
RINT8215 nd2790 nd2791 2.187107128560e+04
RINT8216 nd2791 nd2792 2.285160511327e+04
RINT8217 nd2792 nd2793 2.035776476255e+05
RINT8218 nd2793 nd2794 1.411069864251e+06
RINT8219 nd2794 nd2795 1.915023387198e+06
RINT8220 nd2795 nd2796 1.411069864251e+06
RINT8221 nd2796 nd2797 1.411069864251e+06
RINT8222 nd2797 nd2798 1.411069864251e+06
RINT8223 nd2798 nd2799 1.411069864251e+06
RINT8224 nd2799 nd2800 1.411069864251e+06
RINT8225 nd2800 nd2801 1.411069864251e+06
RINT8226 nd2801 nd2802 9.071163413042e+06
RINT8227 nd2802 nd2803 8.375707551376e+06
RINT8228 nd2803 nd2804 1.102398331446e+04
RINT8229 nd2804 nd2805 1.889825711051e+03
RINT8230 nd2805 nd2806 1.889825711051e+03
RINT8231 nd2806 nd2807 1.889825711051e+03
RINT8232 nd2808 nd2809 5.341900564494e+04
RINT8233 nd2809 nd2810 5.581391083231e+04
RINT8234 nd2810 nd2811 4.972282960301e+05
RINT8235 nd2811 nd2812 3.446468079205e+06
RINT8236 nd2812 nd2813 4.677349536064e+06
RINT8237 nd2813 nd2814 3.446468079205e+06
RINT8238 nd2814 nd2815 3.446468079205e+06
RINT8239 nd2815 nd2816 3.446468079205e+06
RINT8240 nd2816 nd2817 3.446468079205e+06
RINT8241 nd2817 nd2818 3.446468079205e+06
RINT8242 nd2818 nd2819 3.446468079205e+06
RINT8243 nd2819 nd2820 2.215586622346e+07
RINT8244 nd2820 nd2821 2.045724981299e+07
RINT8245 nd2821 nd2822 2.692553186879e+04
RINT8246 nd2822 nd2823 4.615805463221e+03
RINT8247 nd2823 nd2824 4.615805463221e+03
RINT8248 nd2824 nd2825 4.615805463221e+03
RINT8249 nd2826 nd2827 1.356896796876e+03
RINT8250 nd2827 nd2828 1.417729811986e+03
RINT8251 nd2828 nd2829 1.263010185334e+04
RINT8252 nd2829 nd2830 8.754377661563e+04
RINT8253 nd2830 nd2831 1.188094111212e+05
RINT8254 nd2831 nd2832 8.754377661563e+04
RINT8255 nd2832 nd2833 8.754377661563e+04
RINT8256 nd2833 nd2834 8.754377661563e+04
RINT8257 nd2834 nd2835 8.754377661563e+04
RINT8258 nd2835 nd2836 8.754377661563e+04
RINT8259 nd2836 nd2837 8.754377661563e+04
RINT8260 nd2837 nd2838 5.627814211005e+05
RINT8261 nd2838 nd2839 5.196348454828e+05
RINT8262 nd2839 nd2840 6.839357548096e+02
RINT8263 nd2840 nd2841 1.172461293959e+02
RINT8264 nd2841 nd2842 1.172461293959e+02
RINT8265 nd2842 nd2843 1.172461293959e+02
RINT8266 nd2844 nd2845 3.598668835642e+02
RINT8267 nd2845 nd2846 3.760005995667e+02
RINT8268 nd2846 nd2847 3.349669188933e+03
RINT8269 nd2847 nd2848 2.321776139396e+04
RINT8270 nd2848 nd2849 3.150981903467e+04
RINT8271 nd2849 nd2850 2.321776139396e+04
RINT8272 nd2850 nd2851 2.321776139396e+04
RINT8273 nd2851 nd2852 2.321776139396e+04
RINT8274 nd2852 nd2853 2.321776139396e+04
RINT8275 nd2853 nd2854 2.321776139396e+04
RINT8276 nd2854 nd2855 2.321776139396e+04
RINT8277 nd2855 nd2856 1.492570375326e+05
RINT8278 nd2856 nd2857 1.378139979885e+05
RINT8279 nd2857 nd2858 1.813887608903e+02
RINT8280 nd2858 nd2859 3.109521615263e+01
RINT8281 nd2859 nd2860 3.109521615263e+01
RINT8282 nd2860 nd2861 3.109521615263e+01
RINT8283 nd2862 nd2863 3.598668835642e+02
RINT8284 nd2863 nd2864 3.760005995667e+02
RINT8285 nd2864 nd2865 3.349669188933e+03
RINT8286 nd2865 nd2866 2.321776139396e+04
RINT8287 nd2866 nd2867 3.150981903467e+04
RINT8288 nd2867 nd2868 2.321776139396e+04
RINT8289 nd2868 nd2869 2.321776139396e+04
RINT8290 nd2869 nd2870 2.321776139396e+04
RINT8291 nd2870 nd2871 2.321776139396e+04
RINT8292 nd2871 nd2872 2.321776139396e+04
RINT8293 nd2872 nd2873 2.321776139396e+04
RINT8294 nd2873 nd2874 1.492570375326e+05
RINT8295 nd2874 nd2875 1.378139979885e+05
RINT8296 nd2875 nd2876 1.813887608903e+02
RINT8297 nd2876 nd2877 3.109521615263e+01
RINT8298 nd2877 nd2878 3.109521615263e+01
RINT8299 nd2878 nd2879 3.109521615263e+01
RINT8300 nd2880 nd2881 5.867672905818e+03
RINT8301 nd2881 nd2882 6.130735089591e+03
RINT8302 nd2882 nd2883 5.461675981043e+04
RINT8303 nd2883 nd2884 3.785683976136e+05
RINT8304 nd2884 nd2885 5.137713967613e+05
RINT8305 nd2885 nd2886 3.785683976136e+05
RINT8306 nd2886 nd2887 3.785683976136e+05
RINT8307 nd2887 nd2888 3.785683976136e+05
RINT8308 nd2888 nd2889 3.785683976136e+05
RINT8309 nd2889 nd2890 3.785683976136e+05
RINT8310 nd2890 nd2891 3.785683976136e+05
RINT8311 nd2891 nd2892 2.433653984659e+06
RINT8312 nd2892 nd2893 2.247073845835e+06
RINT8313 nd2893 nd2894 2.957565606356e+03
RINT8314 nd2894 nd2895 5.070112468039e+02
RINT8315 nd2895 nd2896 5.070112468039e+02
RINT8316 nd2896 nd2897 5.070112468039e+02
RINT8317 nd2898 nd2899 3.177333509760e+02
RINT8318 nd2899 nd2900 3.319781172584e+02
RINT8319 nd2900 nd2901 2.957486961622e+03
RINT8320 nd2901 nd2902 2.049940538235e+04
RINT8321 nd2902 nd2903 2.782062159033e+04
RINT8322 nd2903 nd2904 2.049940538235e+04
RINT8323 nd2904 nd2905 2.049940538235e+04
RINT8324 nd2905 nd2906 2.049940538235e+04
RINT8325 nd2906 nd2907 2.049940538235e+04
RINT8326 nd2907 nd2908 2.049940538235e+04
RINT8327 nd2908 nd2909 2.049940538235e+04
RINT8328 nd2909 nd2910 1.317818917437e+05
RINT8329 nd2910 nd2911 1.216786133766e+05
RINT8330 nd2911 nd2912 1.601516045496e+02
RINT8331 nd2912 nd2913 2.745456077993e+01
RINT8332 nd2913 nd2914 2.745456077993e+01
RINT8333 nd2914 nd2915 2.745456077993e+01
RINT8334 nd2916 nd2917 3.177333509760e+02
RINT8335 nd2917 nd2918 3.319781172584e+02
RINT8336 nd2918 nd2919 2.957486961622e+03
RINT8337 nd2919 nd2920 2.049940538235e+04
RINT8338 nd2920 nd2921 2.782062159033e+04
RINT8339 nd2921 nd2922 2.049940538235e+04
RINT8340 nd2922 nd2923 2.049940538235e+04
RINT8341 nd2923 nd2924 2.049940538235e+04
RINT8342 nd2924 nd2925 2.049940538235e+04
RINT8343 nd2925 nd2926 2.049940538235e+04
RINT8344 nd2926 nd2927 2.049940538235e+04
RINT8345 nd2927 nd2928 1.317818917437e+05
RINT8346 nd2928 nd2929 1.216786133766e+05
RINT8347 nd2929 nd2930 1.601516045496e+02
RINT8348 nd2930 nd2931 2.745456077993e+01
RINT8349 nd2931 nd2932 2.745456077993e+01
RINT8350 nd2932 nd2933 2.745456077993e+01
RINT8351 nd2934 nd2935 5.867691768021e+03
RINT8352 nd2935 nd2936 6.130754797432e+03
RINT8353 nd2936 nd2937 5.461693538130e+04
RINT8354 nd2937 nd2938 3.785696145584e+05
RINT8355 nd2938 nd2939 5.137730483292e+05
RINT8356 nd2939 nd2940 3.785696145584e+05
RINT8357 nd2940 nd2941 3.785696145584e+05
RINT8358 nd2941 nd2942 3.785696145584e+05
RINT8359 nd2942 nd2943 3.785696145584e+05
RINT8360 nd2943 nd2944 3.785696145584e+05
RINT8361 nd2944 nd2945 3.785696145584e+05
RINT8362 nd2945 nd2946 2.433661807875e+06
RINT8363 nd2946 nd2947 2.247081069271e+06
RINT8364 nd2947 nd2948 2.957575113737e+03
RINT8365 nd2948 nd2949 5.070128766407e+02
RINT8366 nd2949 nd2950 5.070128766407e+02
RINT8367 nd2950 nd2951 5.070128766407e+02
RINT8368 nd2952 nd2953 3.598668835642e+02
RINT8369 nd2953 nd2954 3.760005995667e+02
RINT8370 nd2954 nd2955 3.349669188933e+03
RINT8371 nd2955 nd2956 2.321776139396e+04
RINT8372 nd2956 nd2957 3.150981903467e+04
RINT8373 nd2957 nd2958 2.321776139396e+04
RINT8374 nd2958 nd2959 2.321776139396e+04
RINT8375 nd2959 nd2960 2.321776139396e+04
RINT8376 nd2960 nd2961 2.321776139396e+04
RINT8377 nd2961 nd2962 2.321776139396e+04
RINT8378 nd2962 nd2963 2.321776139396e+04
RINT8379 nd2963 nd2964 1.492570375326e+05
RINT8380 nd2964 nd2965 1.378139979885e+05
RINT8381 nd2965 nd2966 1.813887608903e+02
RINT8382 nd2966 nd2967 3.109521615263e+01
RINT8383 nd2967 nd2968 3.109521615263e+01
RINT8384 nd2968 nd2969 3.109521615263e+01
RINT8385 nd2970 nd2971 3.598668835642e+02
RINT8386 nd2971 nd2972 3.760005995667e+02
RINT8387 nd2972 nd2973 3.349669188933e+03
RINT8388 nd2973 nd2974 2.321776139396e+04
RINT8389 nd2974 nd2975 3.150981903467e+04
RINT8390 nd2975 nd2976 2.321776139396e+04
RINT8391 nd2976 nd2977 2.321776139396e+04
RINT8392 nd2977 nd2978 2.321776139396e+04
RINT8393 nd2978 nd2979 2.321776139396e+04
RINT8394 nd2979 nd2980 2.321776139396e+04
RINT8395 nd2980 nd2981 2.321776139396e+04
RINT8396 nd2981 nd2982 1.492570375326e+05
RINT8397 nd2982 nd2983 1.378139979885e+05
RINT8398 nd2983 nd2984 1.813887608903e+02
RINT8399 nd2984 nd2985 3.109521615263e+01
RINT8400 nd2985 nd2986 3.109521615263e+01
RINT8401 nd2986 nd2987 3.109521615263e+01
RINT8402 nd2988 nd2989 1.356896796876e+03
RINT8403 nd2989 nd2990 1.417729811986e+03
RINT8404 nd2990 nd2991 1.263010185334e+04
RINT8405 nd2991 nd2992 8.754377661563e+04
RINT8406 nd2992 nd2993 1.188094111212e+05
RINT8407 nd2993 nd2994 8.754377661563e+04
RINT8408 nd2994 nd2995 8.754377661563e+04
RINT8409 nd2995 nd2996 8.754377661563e+04
RINT8410 nd2996 nd2997 8.754377661563e+04
RINT8411 nd2997 nd2998 8.754377661563e+04
RINT8412 nd2998 nd2999 8.754377661563e+04
RINT8413 nd2999 nd3000 5.627814211005e+05
RINT8414 nd3000 nd3001 5.196348454828e+05
RINT8415 nd3001 nd3002 6.839357548096e+02
RINT8416 nd3002 nd3003 1.172461293959e+02
RINT8417 nd3003 nd3004 1.172461293959e+02
RINT8418 nd3004 nd3005 1.172461293959e+02
RINT8419 nd3006 nd3007 5.341744236012e+04
RINT8420 nd3007 nd3008 5.581227746159e+04
RINT8421 nd3008 nd3009 4.972137448523e+05
RINT8422 nd3009 nd3010 3.446367219760e+06
RINT8423 nd3010 nd3011 4.677212655389e+06
RINT8424 nd3011 nd3012 3.446367219760e+06
RINT8425 nd3012 nd3013 3.446367219760e+06
RINT8426 nd3013 nd3014 3.446367219760e+06
RINT8427 nd3014 nd3015 3.446367219760e+06
RINT8428 nd3015 nd3016 3.446367219760e+06
RINT8429 nd3016 nd3017 3.446367219760e+06
RINT8430 nd3017 nd3018 2.215521784132e+07
RINT8431 nd3018 nd3019 2.045665114015e+07
RINT8432 nd3019 nd3020 2.692474390438e+04
RINT8433 nd3020 nd3021 4.615670383607e+03
RINT8434 nd3021 nd3022 4.615670383607e+03
RINT8435 nd3022 nd3023 4.615670383607e+03
RAMB0 nd0 0 2.461787115772e+08
RAMB17 nd17 0 5.307406971306e+05
RAMB18 nd18 0 6.253189877054e+06
RAMB35 nd35 0 1.348135075865e+04
RAMB36 nd36 0 1.658428237807e+06
RAMB53 nd53 0 3.575431598754e+03
RAMB54 nd54 0 1.658428237807e+06
RAMB71 nd71 0 3.575431598754e+03
RAMB72 nd72 0 2.704087159633e+07
RAMB89 nd89 0 5.829784310711e+04
RAMB90 nd90 0 1.464257995165e+06
RAMB107 nd107 0 3.156816909092e+03
RAMB108 nd108 0 1.464257995165e+06
RAMB125 nd125 0 3.156816909092e+03
RAMB126 nd126 0 2.704095852183e+07
RAMB143 nd143 0 5.829803051118e+04
RAMB144 nd144 0 1.658428237807e+06
RAMB161 nd161 0 3.575431598754e+03
RAMB162 nd162 0 1.658428237807e+06
RAMB179 nd179 0 3.575431598754e+03
RAMB180 nd180 0 6.253189877054e+06
RAMB197 nd197 0 1.348135075865e+04
RAMB198 nd198 0 2.461715072621e+08
RAMB215 nd215 0 5.307251652265e+05
RAMB216 nd216 0 1.007946598484e+08
RAMB233 nd233 0 2.173048186482e+05
RAMB234 nd234 0 2.560286603511e+06
RAMB251 nd251 0 5.519762280699e+03
RAMB252 nd252 0 6.790216948636e+05
RAMB269 nd269 0 1.463913581749e+03
RAMB270 nd270 0 6.790216948636e+05
RAMB287 nd287 0 1.463913581749e+03
RAMB288 nd288 0 1.107153045189e+07
RAMB305 nd305 0 2.386928737321e+04
RAMB306 nd306 0 5.995212351154e+05
RAMB323 nd323 0 1.292517286563e+03
RAMB324 nd324 0 5.995212351154e+05
RAMB341 nd341 0 1.292517286563e+03
RAMB342 nd342 0 1.107156604240e+07
RAMB359 nd359 0 2.386936410334e+04
RAMB360 nd360 0 6.790216948636e+05
RAMB377 nd377 0 1.463913581749e+03
RAMB378 nd378 0 6.790216948636e+05
RAMB395 nd395 0 1.463913581749e+03
RAMB396 nd396 0 2.560286603511e+06
RAMB413 nd413 0 5.519762280699e+03
RAMB414 nd414 0 1.007917101352e+08
RAMB431 nd431 0 2.172984593137e+05
RAMB432 nd432 0 3.885945078342e+05
RAMB449 nd449 0 8.377770282596e+02
RAMB450 nd450 0 9.870693712803e+03
RAMB467 nd467 0 2.128038424562e+01
RAMB468 nd468 0 2.617837843856e+03
RAMB485 nd485 0 5.643837893308e+00
RAMB486 nd486 0 2.617837843856e+03
RAMB503 nd503 0 5.643837893308e+00
RAMB504 nd504 0 4.268416153069e+04
RAMB521 nd521 0 9.202345701665e+01
RAMB522 nd522 0 2.311339076833e+03
RAMB539 nd539 0 4.983052367712e+00
RAMB540 nd540 0 2.311339076833e+03
RAMB557 nd557 0 4.983052367712e+00
RAMB558 nd558 0 4.268429874306e+04
RAMB575 nd575 0 9.202375283496e+01
RAMB576 nd576 0 2.617837843856e+03
RAMB593 nd593 0 5.643837893308e+00
RAMB594 nd594 0 2.617837843856e+03
RAMB611 nd611 0 5.643837893308e+00
RAMB612 nd612 0 9.870693712803e+03
RAMB629 nd629 0 2.128038424562e+01
RAMB630 nd630 0 3.885831357788e+05
RAMB647 nd647 0 8.377525110659e+02
RAMB648 nd648 0 1.007946598484e+08
RAMB665 nd665 0 2.173048186482e+05
RAMB666 nd666 0 2.560286603511e+06
RAMB683 nd683 0 5.519762280699e+03
RAMB684 nd684 0 6.790216948636e+05
RAMB701 nd701 0 1.463913581749e+03
RAMB702 nd702 0 6.790216948636e+05
RAMB719 nd719 0 1.463913581749e+03
RAMB720 nd720 0 1.107153045189e+07
RAMB737 nd737 0 2.386928737321e+04
RAMB738 nd738 0 5.995212351154e+05
RAMB755 nd755 0 1.292517286563e+03
RAMB756 nd756 0 5.995212351154e+05
RAMB773 nd773 0 1.292517286563e+03
RAMB774 nd774 0 1.107156604240e+07
RAMB791 nd791 0 2.386936410334e+04
RAMB792 nd792 0 6.790216948636e+05
RAMB809 nd809 0 1.463913581749e+03
RAMB810 nd810 0 6.790216948636e+05
RAMB827 nd827 0 1.463913581749e+03
RAMB828 nd828 0 2.560286603511e+06
RAMB845 nd845 0 5.519762280699e+03
RAMB846 nd846 0 1.007917101352e+08
RAMB863 nd863 0 2.172984593137e+05
RAMB864 nd864 0 8.593414430723e+06
RAMB881 nd881 0 1.852667785616e+04
RAMB882 nd882 0 2.182814238520e+05
RAMB899 nd899 0 4.705963642850e+02
RAMB900 nd900 0 5.789110559846e+04
RAMB917 nd917 0 1.248083475632e+02
RAMB918 nd918 0 5.789110559846e+04
RAMB935 nd935 0 1.248083475632e+02
RAMB936 nd936 0 9.439214526843e+05
RAMB953 nd953 0 2.035015148274e+03
RAMB954 nd954 0 5.111316382171e+04
RAMB971 nd971 0 1.101956759907e+02
RAMB972 nd972 0 5.111316382171e+04
RAMB989 nd989 0 1.101956759907e+02
RAMB990 nd990 0 9.439244870112e+05
RAMB1007 nd1007 0 2.035021690027e+03
RAMB1008 nd1008 0 5.789110559846e+04
RAMB1025 nd1025 0 1.248083475632e+02
RAMB1026 nd1026 0 5.789110559846e+04
RAMB1043 nd1043 0 1.248083475632e+02
RAMB1044 nd1044 0 2.182814238520e+05
RAMB1061 nd1061 0 4.705963642850e+02
RAMB1062 nd1062 0 8.593162948052e+06
RAMB1079 nd1079 0 1.852613568069e+04
RAMB1080 nd1080 0 4.590811144313e+05
RAMB1097 nd1097 0 9.897402151897e+02
RAMB1098 nd1098 0 1.166112484567e+04
RAMB1115 nd1115 0 2.514040296179e+01
RAMB1116 nd1116 0 3.092683737451e+03
RAMB1133 nd1133 0 6.667565644076e+00
RAMB1134 nd1134 0 3.092683737451e+03
RAMB1151 nd1151 0 6.667565644076e+00
RAMB1152 nd1152 0 5.042658105106e+04
RAMB1169 nd1169 0 1.087154613673e+02
RAMB1170 nd1170 0 2.730589593789e+03
RAMB1187 nd1187 0 5.886921169189e+00
RAMB1188 nd1188 0 2.730589593789e+03
RAMB1205 nd1205 0 5.886921169189e+00
RAMB1206 nd1206 0 5.042674315219e+04
RAMB1223 nd1223 0 1.087158108437e+02
RAMB1224 nd1224 0 3.092683737451e+03
RAMB1241 nd1241 0 6.667565644076e+00
RAMB1242 nd1242 0 3.092683737451e+03
RAMB1259 nd1259 0 6.667565644076e+00
RAMB1260 nd1260 0 1.166112484567e+04
RAMB1277 nd1277 0 2.514040296179e+01
RAMB1278 nd1278 0 4.590676796148e+05
RAMB1295 nd1295 0 9.897112508570e+02
RAMB1296 nd1296 0 4.590811144313e+05
RAMB1313 nd1313 0 9.897402151897e+02
RAMB1314 nd1314 0 1.166112484567e+04
RAMB1331 nd1331 0 2.514040296179e+01
RAMB1332 nd1332 0 3.092683737451e+03
RAMB1349 nd1349 0 6.667565644076e+00
RAMB1350 nd1350 0 3.092683737451e+03
RAMB1367 nd1367 0 6.667565644076e+00
RAMB1368 nd1368 0 5.042658105106e+04
RAMB1385 nd1385 0 1.087154613673e+02
RAMB1386 nd1386 0 2.730589593789e+03
RAMB1403 nd1403 0 5.886921169189e+00
RAMB1404 nd1404 0 2.730589593789e+03
RAMB1421 nd1421 0 5.886921169189e+00
RAMB1422 nd1422 0 5.042674315219e+04
RAMB1439 nd1439 0 1.087158108437e+02
RAMB1440 nd1440 0 3.092683737451e+03
RAMB1457 nd1457 0 6.667565644076e+00
RAMB1458 nd1458 0 3.092683737451e+03
RAMB1475 nd1475 0 6.667565644076e+00
RAMB1476 nd1476 0 1.166112484567e+04
RAMB1493 nd1493 0 2.514040296179e+01
RAMB1494 nd1494 0 4.590676796148e+05
RAMB1511 nd1511 0 9.897112508570e+02
RAMB1512 nd1512 0 4.590811144313e+05
RAMB1529 nd1529 0 9.897402151897e+02
RAMB1530 nd1530 0 1.166112484567e+04
RAMB1547 nd1547 0 2.514040296179e+01
RAMB1548 nd1548 0 3.092683737451e+03
RAMB1565 nd1565 0 6.667565644076e+00
RAMB1566 nd1566 0 3.092683737451e+03
RAMB1583 nd1583 0 6.667565644076e+00
RAMB1584 nd1584 0 5.042658105106e+04
RAMB1601 nd1601 0 1.087154613673e+02
RAMB1602 nd1602 0 2.730589593789e+03
RAMB1619 nd1619 0 5.886921169189e+00
RAMB1620 nd1620 0 2.730589593789e+03
RAMB1637 nd1637 0 5.886921169189e+00
RAMB1638 nd1638 0 5.042674315219e+04
RAMB1655 nd1655 0 1.087158108437e+02
RAMB1656 nd1656 0 3.092683737451e+03
RAMB1673 nd1673 0 6.667565644076e+00
RAMB1674 nd1674 0 3.092683737451e+03
RAMB1691 nd1691 0 6.667565644076e+00
RAMB1692 nd1692 0 1.166112484567e+04
RAMB1709 nd1709 0 2.514040296179e+01
RAMB1710 nd1710 0 4.590676796148e+05
RAMB1727 nd1727 0 9.897112508570e+02
RAMB1728 nd1728 0 4.590811144313e+05
RAMB1745 nd1745 0 9.897402151897e+02
RAMB1746 nd1746 0 1.166112484567e+04
RAMB1763 nd1763 0 2.514040296179e+01
RAMB1764 nd1764 0 3.092683737451e+03
RAMB1781 nd1781 0 6.667565644076e+00
RAMB1782 nd1782 0 3.092683737451e+03
RAMB1799 nd1799 0 6.667565644076e+00
RAMB1800 nd1800 0 5.042658105106e+04
RAMB1817 nd1817 0 1.087154613673e+02
RAMB1818 nd1818 0 2.730589593789e+03
RAMB1835 nd1835 0 5.886921169189e+00
RAMB1836 nd1836 0 2.730589593789e+03
RAMB1853 nd1853 0 5.886921169189e+00
RAMB1854 nd1854 0 5.042674315219e+04
RAMB1871 nd1871 0 1.087158108437e+02
RAMB1872 nd1872 0 3.092683737451e+03
RAMB1889 nd1889 0 6.667565644076e+00
RAMB1890 nd1890 0 3.092683737451e+03
RAMB1907 nd1907 0 6.667565644076e+00
RAMB1908 nd1908 0 1.166112484567e+04
RAMB1925 nd1925 0 2.514040296179e+01
RAMB1926 nd1926 0 4.590676796148e+05
RAMB1943 nd1943 0 9.897112508570e+02
RAMB1944 nd1944 0 8.593414430723e+06
RAMB1961 nd1961 0 1.852667785616e+04
RAMB1962 nd1962 0 2.182814238520e+05
RAMB1979 nd1979 0 4.705963642850e+02
RAMB1980 nd1980 0 5.789110559846e+04
RAMB1997 nd1997 0 1.248083475632e+02
RAMB1998 nd1998 0 5.789110559846e+04
RAMB2015 nd2015 0 1.248083475632e+02
RAMB2016 nd2016 0 9.439214526843e+05
RAMB2033 nd2033 0 2.035015148274e+03
RAMB2034 nd2034 0 5.111316382171e+04
RAMB2051 nd2051 0 1.101956759907e+02
RAMB2052 nd2052 0 5.111316382171e+04
RAMB2069 nd2069 0 1.101956759907e+02
RAMB2070 nd2070 0 9.439244870112e+05
RAMB2087 nd2087 0 2.035021690027e+03
RAMB2088 nd2088 0 5.789110559846e+04
RAMB2105 nd2105 0 1.248083475632e+02
RAMB2106 nd2106 0 5.789110559846e+04
RAMB2123 nd2123 0 1.248083475632e+02
RAMB2124 nd2124 0 2.182814238520e+05
RAMB2141 nd2141 0 4.705963642850e+02
RAMB2142 nd2142 0 8.593162948052e+06
RAMB2159 nd2159 0 1.852613568069e+04
RAMB2160 nd2160 0 1.007946598484e+08
RAMB2177 nd2177 0 2.173048186482e+05
RAMB2178 nd2178 0 2.560286603511e+06
RAMB2195 nd2195 0 5.519762280699e+03
RAMB2196 nd2196 0 6.790216948636e+05
RAMB2213 nd2213 0 1.463913581749e+03
RAMB2214 nd2214 0 6.790216948636e+05
RAMB2231 nd2231 0 1.463913581749e+03
RAMB2232 nd2232 0 1.107153045189e+07
RAMB2249 nd2249 0 2.386928737321e+04
RAMB2250 nd2250 0 5.995212351154e+05
RAMB2267 nd2267 0 1.292517286563e+03
RAMB2268 nd2268 0 5.995212351154e+05
RAMB2285 nd2285 0 1.292517286563e+03
RAMB2286 nd2286 0 1.107156604239e+07
RAMB2303 nd2303 0 2.386936410334e+04
RAMB2304 nd2304 0 6.790216948636e+05
RAMB2321 nd2321 0 1.463913581749e+03
RAMB2322 nd2322 0 6.790216948636e+05
RAMB2339 nd2339 0 1.463913581749e+03
RAMB2340 nd2340 0 2.560286603511e+06
RAMB2357 nd2357 0 5.519762280699e+03
RAMB2358 nd2358 0 1.007917101352e+08
RAMB2375 nd2375 0 2.172984593137e+05
RAMB2376 nd2376 0 3.885945078342e+05
RAMB2393 nd2393 0 8.377770282596e+02
RAMB2394 nd2394 0 9.870693712803e+03
RAMB2411 nd2411 0 2.128038424562e+01
RAMB2412 nd2412 0 2.617837843856e+03
RAMB2429 nd2429 0 5.643837893308e+00
RAMB2430 nd2430 0 2.617837843856e+03
RAMB2447 nd2447 0 5.643837893308e+00
RAMB2448 nd2448 0 4.268416153069e+04
RAMB2465 nd2465 0 9.202345701665e+01
RAMB2466 nd2466 0 2.311339076833e+03
RAMB2483 nd2483 0 4.983052367712e+00
RAMB2484 nd2484 0 2.311339076833e+03
RAMB2501 nd2501 0 4.983052367712e+00
RAMB2502 nd2502 0 4.268429874306e+04
RAMB2519 nd2519 0 9.202375283496e+01
RAMB2520 nd2520 0 2.617837843856e+03
RAMB2537 nd2537 0 5.643837893308e+00
RAMB2538 nd2538 0 2.617837843856e+03
RAMB2555 nd2555 0 5.643837893308e+00
RAMB2556 nd2556 0 9.870693712803e+03
RAMB2573 nd2573 0 2.128038424562e+01
RAMB2574 nd2574 0 3.885831357788e+05
RAMB2591 nd2591 0 8.377525110659e+02
RAMB2592 nd2592 0 1.007946598484e+08
RAMB2609 nd2609 0 2.173048186482e+05
RAMB2610 nd2610 0 2.560286603511e+06
RAMB2627 nd2627 0 5.519762280699e+03
RAMB2628 nd2628 0 6.790216948636e+05
RAMB2645 nd2645 0 1.463913581749e+03
RAMB2646 nd2646 0 6.790216948636e+05
RAMB2663 nd2663 0 1.463913581749e+03
RAMB2664 nd2664 0 1.107153045189e+07
RAMB2681 nd2681 0 2.386928737321e+04
RAMB2682 nd2682 0 5.995212351154e+05
RAMB2699 nd2699 0 1.292517286563e+03
RAMB2700 nd2700 0 5.995212351154e+05
RAMB2717 nd2717 0 1.292517286563e+03
RAMB2718 nd2718 0 1.107156604239e+07
RAMB2735 nd2735 0 2.386936410334e+04
RAMB2736 nd2736 0 6.790216948636e+05
RAMB2753 nd2753 0 1.463913581749e+03
RAMB2754 nd2754 0 6.790216948636e+05
RAMB2771 nd2771 0 1.463913581749e+03
RAMB2772 nd2772 0 2.560286603511e+06
RAMB2789 nd2789 0 5.519762280699e+03
RAMB2790 nd2790 0 1.007917101352e+08
RAMB2807 nd2807 0 2.172984593137e+05
RAMB2808 nd2808 0 2.461787115771e+08
RAMB2825 nd2825 0 5.307406971304e+05
RAMB2826 nd2826 0 6.253189877051e+06
RAMB2843 nd2843 0 1.348135075864e+04
RAMB2844 nd2844 0 1.658428237807e+06
RAMB2861 nd2861 0 3.575431598752e+03
RAMB2862 nd2862 0 1.658428237807e+06
RAMB2879 nd2879 0 3.575431598752e+03
RAMB2880 nd2880 0 2.704087159631e+07
RAMB2897 nd2897 0 5.829784310708e+04
RAMB2898 nd2898 0 1.464257995164e+06
RAMB2915 nd2915 0 3.156816909091e+03
RAMB2916 nd2916 0 1.464257995164e+06
RAMB2933 nd2933 0 3.156816909091e+03
RAMB2934 nd2934 0 2.704095852181e+07
RAMB2951 nd2951 0 5.829803051115e+04
RAMB2952 nd2952 0 1.658428237807e+06
RAMB2969 nd2969 0 3.575431598752e+03
RAMB2970 nd2970 0 1.658428237807e+06
RAMB2987 nd2987 0 3.575431598752e+03
RAMB2988 nd2988 0 6.253189877051e+06
RAMB3005 nd3005 0 1.348135075864e+04
RAMB3006 nd3006 0 2.461715072620e+08
RAMB3023 nd3023 0 5.307251652262e+05
IPWR310 0 nd310 DC 1.920250892502e-03
IPWR311 0 nd311 DC 9.601254462508e-04
IPWR312 0 nd312 DC 9.601254462508e-04
IPWR313 0 nd313 DC 9.601254462508e-04
IPWR314 0 nd314 DC 9.601254462508e-04
IPWR315 0 nd315 DC 9.601254462508e-04
IPWR316 0 nd316 DC 9.601254462508e-04
IPWR317 0 nd317 DC 9.601254462508e-04
IPWR318 0 nd318 DC 9.601254462508e-04
IPWR328 0 nd328 DC 1.920250892502e-03
IPWR329 0 nd329 DC 9.601254462508e-04
IPWR330 0 nd330 DC 9.601254462508e-04
IPWR331 0 nd331 DC 9.601254462508e-04
IPWR332 0 nd332 DC 9.601254462508e-04
IPWR333 0 nd333 DC 9.601254462508e-04
IPWR334 0 nd334 DC 9.601254462508e-04
IPWR335 0 nd335 DC 9.601254462508e-04
IPWR336 0 nd336 DC 9.601254462508e-04
IPWR454 0 nd454 DC 1.166312339314e-01
IPWR455 0 nd455 DC 5.831561696568e-02
IPWR456 0 nd456 DC 5.831561696568e-02
IPWR457 0 nd457 DC 5.831561696568e-02
IPWR458 0 nd458 DC 5.831561696568e-02
IPWR459 0 nd459 DC 5.831561696568e-02
IPWR460 0 nd460 DC 5.831561696568e-02
IPWR461 0 nd461 DC 5.831561696568e-02
IPWR462 0 nd462 DC 5.831561696568e-02
IPWR472 0 nd472 DC 4.397641321418e-01
IPWR473 0 nd473 DC 2.198820660709e-01
IPWR474 0 nd474 DC 2.198820660709e-01
IPWR475 0 nd475 DC 2.198820660709e-01
IPWR476 0 nd476 DC 2.198820660709e-01
IPWR477 0 nd477 DC 2.198820660709e-01
IPWR478 0 nd478 DC 2.198820660709e-01
IPWR479 0 nd479 DC 2.198820660709e-01
IPWR480 0 nd480 DC 2.198820660709e-01
IPWR490 0 nd490 DC 4.397641321418e-01
IPWR491 0 nd491 DC 2.198820660709e-01
IPWR492 0 nd492 DC 2.198820660709e-01
IPWR493 0 nd493 DC 2.198820660709e-01
IPWR494 0 nd494 DC 2.198820660709e-01
IPWR495 0 nd495 DC 2.198820660709e-01
IPWR496 0 nd496 DC 2.198820660709e-01
IPWR497 0 nd497 DC 2.198820660709e-01
IPWR498 0 nd498 DC 2.198820660709e-01
IPWR526 0 nd526 DC 4.980797491075e-01
IPWR527 0 nd527 DC 2.490398745537e-01
IPWR528 0 nd528 DC 2.490398745537e-01
IPWR529 0 nd529 DC 2.490398745537e-01
IPWR530 0 nd530 DC 2.490398745537e-01
IPWR531 0 nd531 DC 2.490398745537e-01
IPWR532 0 nd532 DC 2.490398745537e-01
IPWR533 0 nd533 DC 2.490398745537e-01
IPWR534 0 nd534 DC 2.490398745537e-01
IPWR544 0 nd544 DC 4.980797491075e-01
IPWR545 0 nd545 DC 2.490398745537e-01
IPWR546 0 nd546 DC 2.490398745537e-01
IPWR547 0 nd547 DC 2.490398745537e-01
IPWR548 0 nd548 DC 2.490398745537e-01
IPWR549 0 nd549 DC 2.490398745537e-01
IPWR550 0 nd550 DC 2.490398745537e-01
IPWR551 0 nd551 DC 2.490398745537e-01
IPWR552 0 nd552 DC 2.490398745537e-01
IPWR580 0 nd580 DC 4.397641321418e-01
IPWR581 0 nd581 DC 2.198820660709e-01
IPWR582 0 nd582 DC 2.198820660709e-01
IPWR583 0 nd583 DC 2.198820660709e-01
IPWR584 0 nd584 DC 2.198820660709e-01
IPWR585 0 nd585 DC 2.198820660709e-01
IPWR586 0 nd586 DC 2.198820660709e-01
IPWR587 0 nd587 DC 2.198820660709e-01
IPWR588 0 nd588 DC 2.198820660709e-01
IPWR598 0 nd598 DC 4.397641321418e-01
IPWR599 0 nd599 DC 2.198820660709e-01
IPWR600 0 nd600 DC 2.198820660709e-01
IPWR601 0 nd601 DC 2.198820660709e-01
IPWR602 0 nd602 DC 2.198820660709e-01
IPWR603 0 nd603 DC 2.198820660709e-01
IPWR604 0 nd604 DC 2.198820660709e-01
IPWR605 0 nd605 DC 2.198820660709e-01
IPWR606 0 nd606 DC 2.198820660709e-01
IPWR616 0 nd616 DC 1.166312339314e-01
IPWR617 0 nd617 DC 5.831561696568e-02
IPWR618 0 nd618 DC 5.831561696568e-02
IPWR619 0 nd619 DC 5.831561696568e-02
IPWR620 0 nd620 DC 5.831561696568e-02
IPWR621 0 nd621 DC 5.831561696568e-02
IPWR622 0 nd622 DC 5.831561696568e-02
IPWR623 0 nd623 DC 5.831561696568e-02
IPWR624 0 nd624 DC 5.831561696568e-02
IPWR670 0 nd670 DC 4.496493411980e-04
IPWR671 0 nd671 DC 2.248246705990e-04
IPWR672 0 nd672 DC 2.248246705990e-04
IPWR673 0 nd673 DC 2.248246705990e-04
IPWR674 0 nd674 DC 2.248246705990e-04
IPWR675 0 nd675 DC 2.248246705990e-04
IPWR676 0 nd676 DC 2.248246705990e-04
IPWR677 0 nd677 DC 2.248246705990e-04
IPWR678 0 nd678 DC 2.248246705990e-04
IPWR688 0 nd688 DC 1.695426221903e-03
IPWR689 0 nd689 DC 8.477131109513e-04
IPWR690 0 nd690 DC 8.477131109513e-04
IPWR691 0 nd691 DC 8.477131109513e-04
IPWR692 0 nd692 DC 8.477131109513e-04
IPWR693 0 nd693 DC 8.477131109513e-04
IPWR694 0 nd694 DC 8.477131109513e-04
IPWR695 0 nd695 DC 8.477131109513e-04
IPWR696 0 nd696 DC 8.477131109513e-04
IPWR706 0 nd706 DC 1.695426221903e-03
IPWR707 0 nd707 DC 8.477131109513e-04
IPWR708 0 nd708 DC 8.477131109513e-04
IPWR709 0 nd709 DC 8.477131109513e-04
IPWR710 0 nd710 DC 8.477131109513e-04
IPWR711 0 nd711 DC 8.477131109513e-04
IPWR712 0 nd712 DC 8.477131109513e-04
IPWR713 0 nd713 DC 8.477131109513e-04
IPWR714 0 nd714 DC 8.477131109513e-04
IPWR796 0 nd796 DC 1.695426221903e-03
IPWR797 0 nd797 DC 8.477131109513e-04
IPWR798 0 nd798 DC 8.477131109513e-04
IPWR799 0 nd799 DC 8.477131109513e-04
IPWR800 0 nd800 DC 8.477131109513e-04
IPWR801 0 nd801 DC 8.477131109513e-04
IPWR802 0 nd802 DC 8.477131109513e-04
IPWR803 0 nd803 DC 8.477131109513e-04
IPWR804 0 nd804 DC 8.477131109513e-04
IPWR814 0 nd814 DC 1.695426221903e-03
IPWR815 0 nd815 DC 8.477131109513e-04
IPWR816 0 nd816 DC 8.477131109513e-04
IPWR817 0 nd817 DC 8.477131109513e-04
IPWR818 0 nd818 DC 8.477131109513e-04
IPWR819 0 nd819 DC 8.477131109513e-04
IPWR820 0 nd820 DC 8.477131109513e-04
IPWR821 0 nd821 DC 8.477131109513e-04
IPWR822 0 nd822 DC 8.477131109513e-04
IPWR832 0 nd832 DC 4.496493411980e-04
IPWR833 0 nd833 DC 2.248246705990e-04
IPWR834 0 nd834 DC 2.248246705990e-04
IPWR835 0 nd835 DC 2.248246705990e-04
IPWR836 0 nd836 DC 2.248246705990e-04
IPWR837 0 nd837 DC 2.248246705990e-04
IPWR838 0 nd838 DC 2.248246705990e-04
IPWR839 0 nd839 DC 2.248246705990e-04
IPWR840 0 nd840 DC 2.248246705990e-04
IPWR1128 0 nd1128 DC 1.056689627392e+01
IPWR1146 0 nd1146 DC 1.056689627392e+01
IPWR1164 0 nd1164 DC 6.480722583006e-01
IPWR1182 0 nd1182 DC 1.196813623550e+01
IPWR1200 0 nd1200 DC 1.196813623550e+01
IPWR1218 0 nd1218 DC 6.480701750162e-01
IPWR1236 0 nd1236 DC 1.056689627392e+01
IPWR1254 0 nd1254 DC 1.056689627392e+01
IPWR1344 0 nd1344 DC 1.056689627392e+01
IPWR1362 0 nd1362 DC 1.056689627392e+01
IPWR1380 0 nd1380 DC 6.480722583006e-01
IPWR1398 0 nd1398 DC 1.196813623550e+01
IPWR1416 0 nd1416 DC 1.196813623550e+01
IPWR1434 0 nd1434 DC 6.480701750163e-01
IPWR1452 0 nd1452 DC 1.056689627392e+01
IPWR1470 0 nd1470 DC 1.056689627392e+01
IPWR1560 0 nd1560 DC 1.056689627392e+01
IPWR1578 0 nd1578 DC 1.056689627392e+01
IPWR1596 0 nd1596 DC 6.480722583006e-01
IPWR1614 0 nd1614 DC 1.196813623550e+01
IPWR1632 0 nd1632 DC 1.196813623550e+01
IPWR1650 0 nd1650 DC 6.480701750162e-01
IPWR1668 0 nd1668 DC 1.056689627392e+01
IPWR1686 0 nd1686 DC 1.056689627392e+01
IPWR1776 0 nd1776 DC 1.056689627392e+01
IPWR1794 0 nd1794 DC 1.056689627392e+01
IPWR1812 0 nd1812 DC 6.480722583006e-01
IPWR1830 0 nd1830 DC 1.196813623550e+01
IPWR1848 0 nd1848 DC 1.196813623550e+01
IPWR1866 0 nd1866 DC 6.480701750163e-01
IPWR1884 0 nd1884 DC 1.056689627392e+01
IPWR1902 0 nd1902 DC 1.056689627392e+01
IPWR2182 0 nd2182 DC 4.496493411981e-04
IPWR2183 0 nd2183 DC 2.248246705990e-04
IPWR2184 0 nd2184 DC 2.248246705990e-04
IPWR2185 0 nd2185 DC 2.248246705990e-04
IPWR2186 0 nd2186 DC 2.248246705990e-04
IPWR2187 0 nd2187 DC 2.248246705990e-04
IPWR2188 0 nd2188 DC 2.248246705990e-04
IPWR2189 0 nd2189 DC 2.248246705990e-04
IPWR2190 0 nd2190 DC 2.248246705990e-04
IPWR2200 0 nd2200 DC 1.695426221903e-03
IPWR2201 0 nd2201 DC 8.477131109513e-04
IPWR2202 0 nd2202 DC 8.477131109513e-04
IPWR2203 0 nd2203 DC 8.477131109513e-04
IPWR2204 0 nd2204 DC 8.477131109513e-04
IPWR2205 0 nd2205 DC 8.477131109513e-04
IPWR2206 0 nd2206 DC 8.477131109513e-04
IPWR2207 0 nd2207 DC 8.477131109513e-04
IPWR2208 0 nd2208 DC 8.477131109513e-04
IPWR2218 0 nd2218 DC 1.695426221903e-03
IPWR2219 0 nd2219 DC 8.477131109513e-04
IPWR2220 0 nd2220 DC 8.477131109513e-04
IPWR2221 0 nd2221 DC 8.477131109513e-04
IPWR2222 0 nd2222 DC 8.477131109513e-04
IPWR2223 0 nd2223 DC 8.477131109513e-04
IPWR2224 0 nd2224 DC 8.477131109513e-04
IPWR2225 0 nd2225 DC 8.477131109513e-04
IPWR2226 0 nd2226 DC 8.477131109513e-04
IPWR2308 0 nd2308 DC 1.695426221903e-03
IPWR2309 0 nd2309 DC 8.477131109513e-04
IPWR2310 0 nd2310 DC 8.477131109513e-04
IPWR2311 0 nd2311 DC 8.477131109513e-04
IPWR2312 0 nd2312 DC 8.477131109513e-04
IPWR2313 0 nd2313 DC 8.477131109513e-04
IPWR2314 0 nd2314 DC 8.477131109513e-04
IPWR2315 0 nd2315 DC 8.477131109513e-04
IPWR2316 0 nd2316 DC 8.477131109513e-04
IPWR2326 0 nd2326 DC 1.695426221903e-03
IPWR2327 0 nd2327 DC 8.477131109513e-04
IPWR2328 0 nd2328 DC 8.477131109513e-04
IPWR2329 0 nd2329 DC 8.477131109513e-04
IPWR2330 0 nd2330 DC 8.477131109513e-04
IPWR2331 0 nd2331 DC 8.477131109513e-04
IPWR2332 0 nd2332 DC 8.477131109513e-04
IPWR2333 0 nd2333 DC 8.477131109513e-04
IPWR2334 0 nd2334 DC 8.477131109513e-04
IPWR2344 0 nd2344 DC 4.496493411981e-04
IPWR2345 0 nd2345 DC 2.248246705990e-04
IPWR2346 0 nd2346 DC 2.248246705990e-04
IPWR2347 0 nd2347 DC 2.248246705990e-04
IPWR2348 0 nd2348 DC 2.248246705990e-04
IPWR2349 0 nd2349 DC 2.248246705990e-04
IPWR2350 0 nd2350 DC 2.248246705990e-04
IPWR2351 0 nd2351 DC 2.248246705990e-04
IPWR2352 0 nd2352 DC 2.248246705990e-04
IPWR2398 0 nd2398 DC 1.166312339314e-01
IPWR2399 0 nd2399 DC 5.831561696568e-02
IPWR2400 0 nd2400 DC 5.831561696568e-02
IPWR2401 0 nd2401 DC 5.831561696568e-02
IPWR2402 0 nd2402 DC 5.831561696568e-02
IPWR2403 0 nd2403 DC 5.831561696568e-02
IPWR2404 0 nd2404 DC 5.831561696568e-02
IPWR2405 0 nd2405 DC 5.831561696568e-02
IPWR2406 0 nd2406 DC 5.831561696568e-02
IPWR2416 0 nd2416 DC 4.397641321418e-01
IPWR2417 0 nd2417 DC 2.198820660709e-01
IPWR2418 0 nd2418 DC 2.198820660709e-01
IPWR2419 0 nd2419 DC 2.198820660709e-01
IPWR2420 0 nd2420 DC 2.198820660709e-01
IPWR2421 0 nd2421 DC 2.198820660709e-01
IPWR2422 0 nd2422 DC 2.198820660709e-01
IPWR2423 0 nd2423 DC 2.198820660709e-01
IPWR2424 0 nd2424 DC 2.198820660709e-01
IPWR2434 0 nd2434 DC 4.397641321418e-01
IPWR2435 0 nd2435 DC 2.198820660709e-01
IPWR2436 0 nd2436 DC 2.198820660709e-01
IPWR2437 0 nd2437 DC 2.198820660709e-01
IPWR2438 0 nd2438 DC 2.198820660709e-01
IPWR2439 0 nd2439 DC 2.198820660709e-01
IPWR2440 0 nd2440 DC 2.198820660709e-01
IPWR2441 0 nd2441 DC 2.198820660709e-01
IPWR2442 0 nd2442 DC 2.198820660709e-01
IPWR2470 0 nd2470 DC 4.980797491075e-01
IPWR2471 0 nd2471 DC 2.490398745537e-01
IPWR2472 0 nd2472 DC 2.490398745537e-01
IPWR2473 0 nd2473 DC 2.490398745537e-01
IPWR2474 0 nd2474 DC 2.490398745537e-01
IPWR2475 0 nd2475 DC 2.490398745537e-01
IPWR2476 0 nd2476 DC 2.490398745537e-01
IPWR2477 0 nd2477 DC 2.490398745537e-01
IPWR2478 0 nd2478 DC 2.490398745537e-01
IPWR2488 0 nd2488 DC 4.980797491075e-01
IPWR2489 0 nd2489 DC 2.490398745537e-01
IPWR2490 0 nd2490 DC 2.490398745537e-01
IPWR2491 0 nd2491 DC 2.490398745537e-01
IPWR2492 0 nd2492 DC 2.490398745537e-01
IPWR2493 0 nd2493 DC 2.490398745537e-01
IPWR2494 0 nd2494 DC 2.490398745537e-01
IPWR2495 0 nd2495 DC 2.490398745537e-01
IPWR2496 0 nd2496 DC 2.490398745537e-01
IPWR2524 0 nd2524 DC 4.397641321418e-01
IPWR2525 0 nd2525 DC 2.198820660709e-01
IPWR2526 0 nd2526 DC 2.198820660709e-01
IPWR2527 0 nd2527 DC 2.198820660709e-01
IPWR2528 0 nd2528 DC 2.198820660709e-01
IPWR2529 0 nd2529 DC 2.198820660709e-01
IPWR2530 0 nd2530 DC 2.198820660709e-01
IPWR2531 0 nd2531 DC 2.198820660709e-01
IPWR2532 0 nd2532 DC 2.198820660709e-01
IPWR2542 0 nd2542 DC 4.397641321418e-01
IPWR2543 0 nd2543 DC 2.198820660709e-01
IPWR2544 0 nd2544 DC 2.198820660709e-01
IPWR2545 0 nd2545 DC 2.198820660709e-01
IPWR2546 0 nd2546 DC 2.198820660709e-01
IPWR2547 0 nd2547 DC 2.198820660709e-01
IPWR2548 0 nd2548 DC 2.198820660709e-01
IPWR2549 0 nd2549 DC 2.198820660709e-01
IPWR2550 0 nd2550 DC 2.198820660709e-01
IPWR2560 0 nd2560 DC 1.166312339314e-01
IPWR2561 0 nd2561 DC 5.831561696568e-02
IPWR2562 0 nd2562 DC 5.831561696568e-02
IPWR2563 0 nd2563 DC 5.831561696568e-02
IPWR2564 0 nd2564 DC 5.831561696568e-02
IPWR2565 0 nd2565 DC 5.831561696568e-02
IPWR2566 0 nd2566 DC 5.831561696568e-02
IPWR2567 0 nd2567 DC 5.831561696568e-02
IPWR2568 0 nd2568 DC 5.831561696568e-02
IPWR2686 0 nd2686 DC 1.920250892502e-03
IPWR2687 0 nd2687 DC 9.601254462508e-04
IPWR2688 0 nd2688 DC 9.601254462508e-04
IPWR2689 0 nd2689 DC 9.601254462508e-04
IPWR2690 0 nd2690 DC 9.601254462508e-04
IPWR2691 0 nd2691 DC 9.601254462508e-04
IPWR2692 0 nd2692 DC 9.601254462508e-04
IPWR2693 0 nd2693 DC 9.601254462508e-04
IPWR2694 0 nd2694 DC 9.601254462508e-04
IPWR2704 0 nd2704 DC 1.920250892502e-03
IPWR2705 0 nd2705 DC 9.601254462508e-04
IPWR2706 0 nd2706 DC 9.601254462508e-04
IPWR2707 0 nd2707 DC 9.601254462508e-04
IPWR2708 0 nd2708 DC 9.601254462508e-04
IPWR2709 0 nd2709 DC 9.601254462508e-04
IPWR2710 0 nd2710 DC 9.601254462508e-04
IPWR2711 0 nd2711 DC 9.601254462508e-04
IPWR2712 0 nd2712 DC 9.601254462508e-04
.end
