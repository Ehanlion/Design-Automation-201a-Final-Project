.title ThermalResistorNetwork
RRint0 nd0 nd57 0.014901343778453438
RRint1 nd1 nd57 0.015563706259042282
RRint2 nd1 nd58 0.00244022756882676
RRint3 nd1 nd59 0.023210978960137203
RRint4 nd1 nd60 0.02321097896013721
RRint5 nd1 nd61 0.023210978960137206
RRint6 nd1 nd62 0.023210978960137213
RRint7 nd1 nd63 0.023210978960137206
RRint8 nd1 nd64 0.023210978960137213
RRint9 nd2 nd3 0.0048210249014515125
RRint10 nd2 nd59 0.003606693652292224
RRint11 nd3 nd4 0.003873934886595345
RRint12 nd4 nd5 0.003873934886595345
RRint13 nd5 nd6 0.003873934886595345
RRint14 nd6 nd7 0.003873934886595345
RRint15 nd7 nd8 0.003873934886595345
RRint16 nd8 nd9 0.003873934886595345
RRint17 nd9 nd10 0.022108645568064196
RRint18 nd10 nd65 0.13529363832940733
RRint19 nd11 nd12 0.004821024901451514
RRint20 nd11 nd60 0.0036066935204217827
RRint21 nd12 nd13 0.0038739348865953465
RRint22 nd13 nd14 0.0038739348865953465
RRint23 nd14 nd15 0.0038739348865953465
RRint24 nd15 nd16 0.0038739348865953465
RRint25 nd16 nd17 0.0038739348865953465
RRint26 nd17 nd18 0.0038739348865953465
RRint27 nd18 nd19 0.022108645568064203
RRint28 nd19 nd65 0.13529363832940736
RRint29 nd20 nd21 0.004821024901451512
RRint30 nd20 nd61 0.003606693487564423
RRint31 nd21 nd22 0.003873934886595345
RRint32 nd22 nd23 0.003873934886595345
RRint33 nd23 nd24 0.003873934886595345
RRint34 nd24 nd25 0.003873934886595345
RRint35 nd25 nd26 0.003873934886595345
RRint36 nd26 nd27 0.003873934886595345
RRint37 nd27 nd28 0.022108645568064193
RRint38 nd28 nd65 0.1352936383294073
RRint39 nd29 nd58 0.004230261525806908
RRint40 nd29 nd65 0.01625800346627016
RRint41 nd30 nd31 0.004821024901451514
RRint42 nd30 nd62 0.003606693480829202
RRint43 nd31 nd32 0.0038739348865953465
RRint44 nd32 nd33 0.0038739348865953465
RRint45 nd33 nd34 0.0038739348865953465
RRint46 nd34 nd35 0.0038739348865953465
RRint47 nd35 nd36 0.0038739348865953465
RRint48 nd36 nd37 0.0038739348865953465
RRint49 nd37 nd38 0.022108645568064203
RRint50 nd38 nd65 0.13529363832940736
RRint51 nd39 nd40 0.004821024901451512
RRint52 nd39 nd63 0.003606693576859544
RRint53 nd40 nd41 0.003873934886595345
RRint54 nd41 nd42 0.003873934886595345
RRint55 nd42 nd43 0.003873934886595345
RRint56 nd43 nd44 0.003873934886595345
RRint57 nd44 nd45 0.003873934886595345
RRint58 nd45 nd46 0.003873934886595345
RRint59 nd46 nd47 0.022108645568064193
RRint60 nd47 nd65 0.1352936383294073
RRint61 nd48 nd49 0.004821024901451514
RRint62 nd48 nd64 0.003606693444989105
RRint63 nd49 nd50 0.0038739348865953465
RRint64 nd50 nd51 0.0038739348865953465
RRint65 nd51 nd52 0.0038739348865953465
RRint66 nd52 nd53 0.0038739348865953465
RRint67 nd53 nd54 0.0038739348865953465
RRint68 nd54 nd55 0.0038739348865953465
RRint69 nd55 nd56 0.022108645568064203
RRint70 nd56 nd65 0.13529363832940736
RRconv0 nd0 0 68.72852233676977
RRconv65 nd65 0 0.09818360333824253
IIpwr0 0 nd0 33.33333333333332
IIpwr2 0 nd2 1.0
IIpwr3 0 nd3 0.5
IIpwr4 0 nd4 0.5
IIpwr5 0 nd5 0.5
IIpwr6 0 nd6 0.5
IIpwr7 0 nd7 0.5
IIpwr8 0 nd8 0.5
IIpwr9 0 nd9 0.5
IIpwr10 0 nd10 0.5
IIpwr11 0 nd11 1.0
IIpwr12 0 nd12 0.5
IIpwr13 0 nd13 0.5
IIpwr14 0 nd14 0.5
IIpwr15 0 nd15 0.5
IIpwr16 0 nd16 0.5
IIpwr17 0 nd17 0.5
IIpwr18 0 nd18 0.5
IIpwr19 0 nd19 0.5
IIpwr20 0 nd20 1.0
IIpwr21 0 nd21 0.5
IIpwr22 0 nd22 0.5
IIpwr23 0 nd23 0.5
IIpwr24 0 nd24 0.5
IIpwr25 0 nd25 0.5
IIpwr26 0 nd26 0.5
IIpwr27 0 nd27 0.5
IIpwr28 0 nd28 0.5
IIpwr29 0 nd29 270.0
IIpwr30 0 nd30 1.0
IIpwr31 0 nd31 0.5
IIpwr32 0 nd32 0.5
IIpwr33 0 nd33 0.5
IIpwr34 0 nd34 0.5
IIpwr35 0 nd35 0.5
IIpwr36 0 nd36 0.5
IIpwr37 0 nd37 0.5
IIpwr38 0 nd38 0.5
IIpwr39 0 nd39 1.0
IIpwr40 0 nd40 0.5
IIpwr41 0 nd41 0.5
IIpwr42 0 nd42 0.5
IIpwr43 0 nd43 0.5
IIpwr44 0 nd44 0.5
IIpwr45 0 nd45 0.5
IIpwr46 0 nd46 0.5
IIpwr47 0 nd47 0.5
IIpwr48 0 nd48 1.0
IIpwr49 0 nd49 0.5
IIpwr50 0 nd50 0.5
IIpwr51 0 nd51 0.5
IIpwr52 0 nd52 0.5
IIpwr53 0 nd53 0.5
IIpwr54 0 nd54 0.5
IIpwr55 0 nd55 0.5
IIpwr56 0 nd56 0.5
