* VoxelThermalNetwork
.option klu
RINT0 nd0 nd651 5.509580147687e+00
RINT1 nd1 nd652 4.757549543375e+00
RINT2 nd2 nd653 4.757549543375e+00
RINT3 nd3 nd654 2.760265117425e+02
RINT4 nd4 nd655 9.791845679505e+00
RINT5 nd5 nd656 9.861102689905e+00
RINT6 nd6 nd657 9.861102689905e+00
RINT7 nd7 nd658 3.917049124046e+02
RINT8 nd8 nd659 6.528415206743e+01
RINT9 nd9 nd660 1.119156892585e+02
RINT10 nd10 nd661 1.119156892584e+02
RINT11 nd11 nd662 1.119156892585e+02
RINT12 nd12 nd663 1.119156892584e+02
RINT13 nd13 nd664 1.119156892585e+02
RINT14 nd14 nd665 1.119156892585e+02
RINT15 nd15 nd666 1.119156892584e+02
RINT16 nd16 nd667 2.487015316854e+01
RINT17 nd17 nd668 2.487015316854e+01
RINT18 nd18 nd669 5.155895645706e+02
RINT19 nd19 nd670 3.708407078194e+01
RINT20 nd20 nd671 8.225803160496e+02
RINT21 nd21 nd672 3.427417983540e+00
RINT22 nd22 nd673 3.427417983540e+00
RINT23 nd23 nd674 3.427417983540e+00
RINT24 nd24 nd675 3.427417983540e+00
RINT25 nd25 nd676 3.427417983540e+00
RINT26 nd26 nd677 3.427417983540e+00
RINT27 nd27 nd678 3.427417983540e+00
RINT28 nd28 nd679 3.427417983540e+00
RINT29 nd29 nd680 3.427417983540e+00
RINT30 nd30 nd681 3.427417983540e+00
RINT31 nd31 nd682 5.509580147687e+00
RINT32 nd32 nd683 4.757549543375e+00
RINT33 nd33 nd684 4.757549543375e+00
RINT34 nd34 nd685 2.760265117425e+02
RINT35 nd35 nd686 9.791845679505e+00
RINT36 nd36 nd687 9.861102689905e+00
RINT37 nd37 nd688 9.861102689905e+00
RINT38 nd38 nd689 3.917049124046e+02
RINT39 nd39 nd690 6.528415206743e+01
RINT40 nd40 nd691 1.119156892585e+02
RINT41 nd41 nd692 1.119156892584e+02
RINT42 nd42 nd693 1.119156892585e+02
RINT43 nd43 nd694 1.119156892584e+02
RINT44 nd44 nd695 1.119156892585e+02
RINT45 nd45 nd696 1.119156892585e+02
RINT46 nd46 nd697 1.119156892584e+02
RINT47 nd47 nd698 2.487015316854e+01
RINT48 nd48 nd699 2.487015316854e+01
RINT49 nd49 nd700 5.155895645706e+02
RINT50 nd50 nd701 3.708407078194e+01
RINT51 nd51 nd702 8.225803160496e+02
RINT52 nd52 nd703 3.427417983540e+00
RINT53 nd53 nd704 3.427417983540e+00
RINT54 nd54 nd705 3.427417983540e+00
RINT55 nd55 nd706 3.427417983540e+00
RINT56 nd56 nd707 3.427417983540e+00
RINT57 nd57 nd708 3.427417983540e+00
RINT58 nd58 nd709 3.427417983540e+00
RINT59 nd59 nd710 3.427417983540e+00
RINT60 nd60 nd711 3.427417983540e+00
RINT61 nd61 nd712 3.427417983540e+00
RINT62 nd62 nd713 5.509580147687e+00
RINT63 nd63 nd714 4.757549543375e+00
RINT64 nd64 nd715 4.757549543375e+00
RINT65 nd65 nd716 2.760265117425e+02
RINT66 nd66 nd717 9.791845679505e+00
RINT67 nd67 nd718 9.861102689905e+00
RINT68 nd68 nd719 9.861102689905e+00
RINT69 nd69 nd720 3.917049124046e+02
RINT70 nd70 nd721 6.528415206743e+01
RINT71 nd71 nd722 1.119156892585e+02
RINT72 nd72 nd723 1.119156892584e+02
RINT73 nd73 nd724 1.119156892585e+02
RINT74 nd74 nd725 1.119156892584e+02
RINT75 nd75 nd726 1.119156892585e+02
RINT76 nd76 nd727 1.119156892585e+02
RINT77 nd77 nd728 1.119156892584e+02
RINT78 nd78 nd729 2.487015316854e+01
RINT79 nd79 nd730 2.487015316854e+01
RINT80 nd80 nd731 5.155895645706e+02
RINT81 nd81 nd732 3.708407078194e+01
RINT82 nd82 nd733 8.225803160496e+02
RINT83 nd83 nd734 3.427417983540e+00
RINT84 nd84 nd735 3.427417983540e+00
RINT85 nd85 nd736 3.427417983540e+00
RINT86 nd86 nd737 3.427417983540e+00
RINT87 nd87 nd738 3.427417983540e+00
RINT88 nd88 nd739 3.427417983540e+00
RINT89 nd89 nd740 3.427417983540e+00
RINT90 nd90 nd741 3.427417983540e+00
RINT91 nd91 nd742 3.427417983540e+00
RINT92 nd92 nd743 3.427417983540e+00
RINT93 nd93 nd744 4.050184192900e+01
RINT94 nd94 nd745 3.497353961828e+01
RINT95 nd95 nd746 3.497353961828e+01
RINT96 nd96 nd747 2.029116892238e+03
RINT97 nd97 nd748 7.198148956432e+01
RINT98 nd98 nd749 7.249060939061e+01
RINT99 nd99 nd750 7.249060939061e+01
RINT100 nd100 nd751 3.365329761905e+04
RINT101 nd101 nd752 5.608882936508e+03
RINT102 nd102 nd753 9.615227891157e+03
RINT103 nd103 nd754 9.615227891156e+03
RINT104 nd104 nd755 9.615227891157e+03
RINT105 nd105 nd756 9.615227891156e+03
RINT106 nd106 nd757 9.615227891157e+03
RINT107 nd107 nd758 9.615227891157e+03
RINT108 nd108 nd759 9.615227891156e+03
RINT109 nd109 nd760 2.136717309146e+03
RINT110 nd110 nd761 2.136717309146e+03
RINT111 nd111 nd762 3.790184820752e+03
RINT112 nd112 nd763 2.726111849965e+02
RINT113 nd113 nd764 6.046925000000e+03
RINT114 nd114 nd765 2.519552083333e+01
RINT115 nd115 nd766 2.519552083333e+01
RINT116 nd116 nd767 2.519552083333e+01
RINT117 nd117 nd768 2.519552083333e+01
RINT118 nd118 nd769 2.519552083333e+01
RINT119 nd119 nd770 2.519552083333e+01
RINT120 nd120 nd771 2.519552083333e+01
RINT121 nd121 nd772 2.519552083333e+01
RINT122 nd122 nd773 2.519552083333e+01
RINT123 nd123 nd774 2.519552083333e+01
RINT124 nd124 nd775 4.230074822339e+00
RINT125 nd125 nd776 3.652690404715e+00
RINT126 nd126 nd777 3.652690404715e+00
RINT127 nd127 nd778 2.119240969950e+02
RINT128 nd128 nd779 7.517857760993e+00
RINT129 nd129 nd780 7.571031020681e+00
RINT130 nd130 nd781 7.571031020681e+00
RINT131 nd131 nd782 3.514802294586e+03
RINT132 nd132 nd783 5.858003824309e+02
RINT133 nd133 nd784 1.004229227024e+03
RINT134 nd134 nd785 1.004229227024e+03
RINT135 nd135 nd786 1.004229227024e+03
RINT136 nd136 nd787 1.004229227024e+03
RINT137 nd137 nd788 1.004229227024e+03
RINT138 nd138 nd789 1.004229227024e+03
RINT139 nd139 nd790 1.004229227024e+03
RINT140 nd140 nd791 2.231620504499e+02
RINT141 nd141 nd792 2.231620504499e+02
RINT142 nd142 nd793 3.958527469042e+02
RINT143 nd143 nd794 2.847193251021e+01
RINT144 nd144 nd795 6.315501709752e+02
RINT145 nd145 nd796 2.631459045730e+00
RINT146 nd146 nd797 2.631459045730e+00
RINT147 nd147 nd798 2.631459045730e+00
RINT148 nd148 nd799 2.631459045730e+00
RINT149 nd149 nd800 2.631459045730e+00
RINT150 nd150 nd801 2.631459045730e+00
RINT151 nd151 nd802 2.631459045730e+00
RINT152 nd152 nd803 2.631459045730e+00
RINT153 nd153 nd804 2.631459045730e+00
RINT154 nd154 nd805 2.631459045730e+00
RINT155 nd155 nd806 4.230074822339e+00
RINT156 nd156 nd807 3.652690404715e+00
RINT157 nd157 nd808 3.652690404715e+00
RINT158 nd158 nd809 2.119240969950e+02
RINT159 nd159 nd810 7.517857760993e+00
RINT160 nd160 nd811 7.571031020681e+00
RINT161 nd161 nd812 7.571031020681e+00
RINT162 nd162 nd813 3.514802294586e+03
RINT163 nd163 nd814 5.858003824309e+02
RINT164 nd164 nd815 1.004229227024e+03
RINT165 nd165 nd816 1.004229227024e+03
RINT166 nd166 nd817 1.004229227024e+03
RINT167 nd167 nd818 1.004229227024e+03
RINT168 nd168 nd819 1.004229227024e+03
RINT169 nd169 nd820 1.004229227024e+03
RINT170 nd170 nd821 1.004229227024e+03
RINT171 nd171 nd822 2.231620504499e+02
RINT172 nd172 nd823 2.231620504499e+02
RINT173 nd173 nd824 3.958527469042e+02
RINT174 nd174 nd825 2.847193251021e+01
RINT175 nd175 nd826 6.315501709752e+02
RINT176 nd176 nd827 2.631459045730e+00
RINT177 nd177 nd828 2.631459045730e+00
RINT178 nd178 nd829 2.631459045730e+00
RINT179 nd179 nd830 2.631459045730e+00
RINT180 nd180 nd831 2.631459045730e+00
RINT181 nd181 nd832 2.631459045730e+00
RINT182 nd182 nd833 2.631459045730e+00
RINT183 nd183 nd834 2.631459045730e+00
RINT184 nd184 nd835 2.631459045730e+00
RINT185 nd185 nd836 2.631459045730e+00
RINT186 nd186 nd837 4.230074822339e+00
RINT187 nd187 nd838 3.652690404715e+00
RINT188 nd188 nd839 3.652690404715e+00
RINT189 nd189 nd840 2.119240969950e+02
RINT190 nd190 nd841 7.517857760993e+00
RINT191 nd191 nd842 7.571031020681e+00
RINT192 nd192 nd843 7.571031020681e+00
RINT193 nd193 nd844 3.514802294586e+03
RINT194 nd194 nd845 5.858003824309e+02
RINT195 nd195 nd846 1.004229227024e+03
RINT196 nd196 nd847 1.004229227024e+03
RINT197 nd197 nd848 1.004229227024e+03
RINT198 nd198 nd849 1.004229227024e+03
RINT199 nd199 nd850 1.004229227024e+03
RINT200 nd200 nd851 1.004229227024e+03
RINT201 nd201 nd852 1.004229227024e+03
RINT202 nd202 nd853 2.231620504499e+02
RINT203 nd203 nd854 2.231620504499e+02
RINT204 nd204 nd855 3.958527469042e+02
RINT205 nd205 nd856 2.847193251021e+01
RINT206 nd206 nd857 6.315501709752e+02
RINT207 nd207 nd858 2.631459045730e+00
RINT208 nd208 nd859 2.631459045730e+00
RINT209 nd209 nd860 2.631459045730e+00
RINT210 nd210 nd861 2.631459045730e+00
RINT211 nd211 nd862 2.631459045730e+00
RINT212 nd212 nd863 2.631459045730e+00
RINT213 nd213 nd864 2.631459045730e+00
RINT214 nd214 nd865 2.631459045730e+00
RINT215 nd215 nd866 2.631459045730e+00
RINT216 nd216 nd867 2.631459045730e+00
RINT217 nd217 nd868 4.230074822339e+00
RINT218 nd218 nd869 3.652690404715e+00
RINT219 nd219 nd870 3.652690404715e+00
RINT220 nd220 nd871 2.119240969950e+02
RINT221 nd221 nd872 7.517857760993e+00
RINT222 nd222 nd873 7.571031020681e+00
RINT223 nd223 nd874 7.571031020681e+00
RINT224 nd224 nd875 3.514802294586e+03
RINT225 nd225 nd876 5.858003824309e+02
RINT226 nd226 nd877 1.004229227024e+03
RINT227 nd227 nd878 1.004229227024e+03
RINT228 nd228 nd879 1.004229227024e+03
RINT229 nd229 nd880 1.004229227024e+03
RINT230 nd230 nd881 1.004229227024e+03
RINT231 nd231 nd882 1.004229227024e+03
RINT232 nd232 nd883 1.004229227024e+03
RINT233 nd233 nd884 2.231620504499e+02
RINT234 nd234 nd885 2.231620504499e+02
RINT235 nd235 nd886 3.958527469042e+02
RINT236 nd236 nd887 2.847193251021e+01
RINT237 nd237 nd888 6.315501709752e+02
RINT238 nd238 nd889 2.631459045730e+00
RINT239 nd239 nd890 2.631459045730e+00
RINT240 nd240 nd891 2.631459045730e+00
RINT241 nd241 nd892 2.631459045730e+00
RINT242 nd242 nd893 2.631459045730e+00
RINT243 nd243 nd894 2.631459045730e+00
RINT244 nd244 nd895 2.631459045730e+00
RINT245 nd245 nd896 2.631459045730e+00
RINT246 nd246 nd897 2.631459045730e+00
RINT247 nd247 nd898 2.631459045730e+00
RINT248 nd248 nd899 4.230074822339e+00
RINT249 nd249 nd900 3.652690404715e+00
RINT250 nd250 nd901 3.652690404715e+00
RINT251 nd251 nd902 2.119240969950e+02
RINT252 nd252 nd903 7.517857760993e+00
RINT253 nd253 nd904 7.571031020681e+00
RINT254 nd254 nd905 7.571031020681e+00
RINT255 nd255 nd906 3.514802294586e+03
RINT256 nd256 nd907 5.858003824309e+02
RINT257 nd257 nd908 1.004229227024e+03
RINT258 nd258 nd909 1.004229227024e+03
RINT259 nd259 nd910 1.004229227024e+03
RINT260 nd260 nd911 1.004229227024e+03
RINT261 nd261 nd912 1.004229227024e+03
RINT262 nd262 nd913 1.004229227024e+03
RINT263 nd263 nd914 1.004229227024e+03
RINT264 nd264 nd915 2.231620504499e+02
RINT265 nd265 nd916 2.231620504499e+02
RINT266 nd266 nd917 3.958527469042e+02
RINT267 nd267 nd918 2.847193251021e+01
RINT268 nd268 nd919 6.315501709752e+02
RINT269 nd269 nd920 2.631459045730e+00
RINT270 nd270 nd921 2.631459045730e+00
RINT271 nd271 nd922 2.631459045730e+00
RINT272 nd272 nd923 2.631459045730e+00
RINT273 nd273 nd924 2.631459045730e+00
RINT274 nd274 nd925 2.631459045730e+00
RINT275 nd275 nd926 2.631459045730e+00
RINT276 nd276 nd927 2.631459045730e+00
RINT277 nd277 nd928 2.631459045730e+00
RINT278 nd278 nd929 2.631459045730e+00
RINT279 nd279 nd930 4.230074822339e+00
RINT280 nd280 nd931 3.652690404715e+00
RINT281 nd281 nd932 3.652690404715e+00
RINT282 nd282 nd933 2.119240969950e+02
RINT283 nd283 nd934 7.517857760993e+00
RINT284 nd284 nd935 7.571031020681e+00
RINT285 nd285 nd936 7.571031020681e+00
RINT286 nd286 nd937 3.514802294586e+03
RINT287 nd287 nd938 5.858003824309e+02
RINT288 nd288 nd939 1.004229227024e+03
RINT289 nd289 nd940 1.004229227024e+03
RINT290 nd290 nd941 1.004229227024e+03
RINT291 nd291 nd942 1.004229227024e+03
RINT292 nd292 nd943 1.004229227024e+03
RINT293 nd293 nd944 1.004229227024e+03
RINT294 nd294 nd945 1.004229227024e+03
RINT295 nd295 nd946 2.231620504499e+02
RINT296 nd296 nd947 2.231620504499e+02
RINT297 nd297 nd948 3.958527469042e+02
RINT298 nd298 nd949 2.847193251021e+01
RINT299 nd299 nd950 6.315501709752e+02
RINT300 nd300 nd951 2.631459045730e+00
RINT301 nd301 nd952 2.631459045730e+00
RINT302 nd302 nd953 2.631459045730e+00
RINT303 nd303 nd954 2.631459045730e+00
RINT304 nd304 nd955 2.631459045730e+00
RINT305 nd305 nd956 2.631459045730e+00
RINT306 nd306 nd957 2.631459045730e+00
RINT307 nd307 nd958 2.631459045730e+00
RINT308 nd308 nd959 2.631459045730e+00
RINT309 nd309 nd960 2.631459045730e+00
RINT310 nd310 nd961 4.050184192900e+01
RINT311 nd311 nd962 3.497353961828e+01
RINT312 nd312 nd963 3.497353961828e+01
RINT313 nd313 nd964 2.029116892238e+03
RINT314 nd314 nd965 7.198148956432e+01
RINT315 nd315 nd966 7.249060939061e+01
RINT316 nd316 nd967 7.249060939061e+01
RINT317 nd317 nd968 3.365329761905e+04
RINT318 nd318 nd969 5.608882936508e+03
RINT319 nd319 nd970 9.615227891156e+03
RINT320 nd320 nd971 9.615227891156e+03
RINT321 nd321 nd972 9.615227891156e+03
RINT322 nd322 nd973 9.615227891156e+03
RINT323 nd323 nd974 9.615227891156e+03
RINT324 nd324 nd975 9.615227891156e+03
RINT325 nd325 nd976 9.615227891156e+03
RINT326 nd326 nd977 2.136717309146e+03
RINT327 nd327 nd978 2.136717309146e+03
RINT328 nd328 nd979 3.790184820752e+03
RINT329 nd329 nd980 2.726111849965e+02
RINT330 nd330 nd981 6.046925000000e+03
RINT331 nd331 nd982 2.519552083333e+01
RINT332 nd332 nd983 2.519552083333e+01
RINT333 nd333 nd984 2.519552083333e+01
RINT334 nd334 nd985 2.519552083333e+01
RINT335 nd335 nd986 2.519552083333e+01
RINT336 nd336 nd987 2.519552083333e+01
RINT337 nd337 nd988 2.519552083333e+01
RINT338 nd338 nd989 2.519552083333e+01
RINT339 nd339 nd990 2.519552083333e+01
RINT340 nd340 nd991 2.519552083333e+01
RINT341 nd341 nd992 4.230074822339e+00
RINT342 nd342 nd993 3.652690404715e+00
RINT343 nd343 nd994 3.652690404715e+00
RINT344 nd344 nd995 2.119240969950e+02
RINT345 nd345 nd996 7.517857760993e+00
RINT346 nd346 nd997 7.571031020681e+00
RINT347 nd347 nd998 7.571031020681e+00
RINT348 nd348 nd999 3.514802294586e+03
RINT349 nd349 nd1000 5.858003824309e+02
RINT350 nd350 nd1001 1.004229227024e+03
RINT351 nd351 nd1002 1.004229227024e+03
RINT352 nd352 nd1003 1.004229227024e+03
RINT353 nd353 nd1004 1.004229227024e+03
RINT354 nd354 nd1005 1.004229227024e+03
RINT355 nd355 nd1006 1.004229227024e+03
RINT356 nd356 nd1007 1.004229227024e+03
RINT357 nd357 nd1008 2.231620504499e+02
RINT358 nd358 nd1009 2.231620504499e+02
RINT359 nd359 nd1010 3.958527469042e+02
RINT360 nd360 nd1011 2.847193251021e+01
RINT361 nd361 nd1012 6.315501709752e+02
RINT362 nd362 nd1013 2.631459045730e+00
RINT363 nd363 nd1014 2.631459045730e+00
RINT364 nd364 nd1015 2.631459045730e+00
RINT365 nd365 nd1016 2.631459045730e+00
RINT366 nd366 nd1017 2.631459045730e+00
RINT367 nd367 nd1018 2.631459045730e+00
RINT368 nd368 nd1019 2.631459045730e+00
RINT369 nd369 nd1020 2.631459045730e+00
RINT370 nd370 nd1021 2.631459045730e+00
RINT371 nd371 nd1022 2.631459045730e+00
RINT372 nd372 nd1023 4.230074822339e+00
RINT373 nd373 nd1024 3.652690404715e+00
RINT374 nd374 nd1025 3.652690404715e+00
RINT375 nd375 nd1026 2.119240969950e+02
RINT376 nd376 nd1027 7.517857760993e+00
RINT377 nd377 nd1028 7.571031020681e+00
RINT378 nd378 nd1029 7.571031020681e+00
RINT379 nd379 nd1030 3.514802294586e+03
RINT380 nd380 nd1031 5.858003824309e+02
RINT381 nd381 nd1032 1.004229227024e+03
RINT382 nd382 nd1033 1.004229227024e+03
RINT383 nd383 nd1034 1.004229227024e+03
RINT384 nd384 nd1035 1.004229227024e+03
RINT385 nd385 nd1036 1.004229227024e+03
RINT386 nd386 nd1037 1.004229227024e+03
RINT387 nd387 nd1038 1.004229227024e+03
RINT388 nd388 nd1039 2.231620504499e+02
RINT389 nd389 nd1040 2.231620504499e+02
RINT390 nd390 nd1041 3.958527469042e+02
RINT391 nd391 nd1042 2.847193251021e+01
RINT392 nd392 nd1043 6.315501709752e+02
RINT393 nd393 nd1044 2.631459045730e+00
RINT394 nd394 nd1045 2.631459045730e+00
RINT395 nd395 nd1046 2.631459045730e+00
RINT396 nd396 nd1047 2.631459045730e+00
RINT397 nd397 nd1048 2.631459045730e+00
RINT398 nd398 nd1049 2.631459045730e+00
RINT399 nd399 nd1050 2.631459045730e+00
RINT400 nd400 nd1051 2.631459045730e+00
RINT401 nd401 nd1052 2.631459045730e+00
RINT402 nd402 nd1053 2.631459045730e+00
RINT403 nd403 nd1054 4.230074822339e+00
RINT404 nd404 nd1055 3.652690404715e+00
RINT405 nd405 nd1056 3.652690404715e+00
RINT406 nd406 nd1057 2.119240969950e+02
RINT407 nd407 nd1058 7.517857760993e+00
RINT408 nd408 nd1059 7.571031020681e+00
RINT409 nd409 nd1060 7.571031020681e+00
RINT410 nd410 nd1061 3.514802294586e+03
RINT411 nd411 nd1062 5.858003824309e+02
RINT412 nd412 nd1063 1.004229227024e+03
RINT413 nd413 nd1064 1.004229227024e+03
RINT414 nd414 nd1065 1.004229227024e+03
RINT415 nd415 nd1066 1.004229227024e+03
RINT416 nd416 nd1067 1.004229227024e+03
RINT417 nd417 nd1068 1.004229227024e+03
RINT418 nd418 nd1069 1.004229227024e+03
RINT419 nd419 nd1070 2.231620504499e+02
RINT420 nd420 nd1071 2.231620504499e+02
RINT421 nd421 nd1072 3.958527469042e+02
RINT422 nd422 nd1073 2.847193251021e+01
RINT423 nd423 nd1074 6.315501709752e+02
RINT424 nd424 nd1075 2.631459045730e+00
RINT425 nd425 nd1076 2.631459045730e+00
RINT426 nd426 nd1077 2.631459045730e+00
RINT427 nd427 nd1078 2.631459045730e+00
RINT428 nd428 nd1079 2.631459045730e+00
RINT429 nd429 nd1080 2.631459045730e+00
RINT430 nd430 nd1081 2.631459045730e+00
RINT431 nd431 nd1082 2.631459045730e+00
RINT432 nd432 nd1083 2.631459045730e+00
RINT433 nd433 nd1084 2.631459045730e+00
RINT434 nd434 nd1085 4.230074822339e+00
RINT435 nd435 nd1086 3.652690404715e+00
RINT436 nd436 nd1087 3.652690404715e+00
RINT437 nd437 nd1088 2.119240969950e+02
RINT438 nd438 nd1089 7.517857760993e+00
RINT439 nd439 nd1090 7.571031020681e+00
RINT440 nd440 nd1091 7.571031020681e+00
RINT441 nd441 nd1092 3.514802294586e+03
RINT442 nd442 nd1093 5.858003824309e+02
RINT443 nd443 nd1094 1.004229227024e+03
RINT444 nd444 nd1095 1.004229227024e+03
RINT445 nd445 nd1096 1.004229227024e+03
RINT446 nd446 nd1097 1.004229227024e+03
RINT447 nd447 nd1098 1.004229227024e+03
RINT448 nd448 nd1099 1.004229227024e+03
RINT449 nd449 nd1100 1.004229227024e+03
RINT450 nd450 nd1101 2.231620504499e+02
RINT451 nd451 nd1102 2.231620504499e+02
RINT452 nd452 nd1103 3.958527469042e+02
RINT453 nd453 nd1104 2.847193251021e+01
RINT454 nd454 nd1105 6.315501709752e+02
RINT455 nd455 nd1106 2.631459045730e+00
RINT456 nd456 nd1107 2.631459045730e+00
RINT457 nd457 nd1108 2.631459045730e+00
RINT458 nd458 nd1109 2.631459045730e+00
RINT459 nd459 nd1110 2.631459045730e+00
RINT460 nd460 nd1111 2.631459045730e+00
RINT461 nd461 nd1112 2.631459045730e+00
RINT462 nd462 nd1113 2.631459045730e+00
RINT463 nd463 nd1114 2.631459045730e+00
RINT464 nd464 nd1115 2.631459045730e+00
RINT465 nd465 nd1116 4.230074822339e+00
RINT466 nd466 nd1117 3.652690404715e+00
RINT467 nd467 nd1118 3.652690404715e+00
RINT468 nd468 nd1119 2.119240969950e+02
RINT469 nd469 nd1120 7.517857760993e+00
RINT470 nd470 nd1121 7.571031020681e+00
RINT471 nd471 nd1122 7.571031020681e+00
RINT472 nd472 nd1123 3.514802294586e+03
RINT473 nd473 nd1124 5.858003824309e+02
RINT474 nd474 nd1125 1.004229227024e+03
RINT475 nd475 nd1126 1.004229227024e+03
RINT476 nd476 nd1127 1.004229227024e+03
RINT477 nd477 nd1128 1.004229227024e+03
RINT478 nd478 nd1129 1.004229227024e+03
RINT479 nd479 nd1130 1.004229227024e+03
RINT480 nd480 nd1131 1.004229227024e+03
RINT481 nd481 nd1132 2.231620504499e+02
RINT482 nd482 nd1133 2.231620504499e+02
RINT483 nd483 nd1134 3.958527469042e+02
RINT484 nd484 nd1135 2.847193251021e+01
RINT485 nd485 nd1136 6.315501709752e+02
RINT486 nd486 nd1137 2.631459045730e+00
RINT487 nd487 nd1138 2.631459045730e+00
RINT488 nd488 nd1139 2.631459045730e+00
RINT489 nd489 nd1140 2.631459045730e+00
RINT490 nd490 nd1141 2.631459045730e+00
RINT491 nd491 nd1142 2.631459045730e+00
RINT492 nd492 nd1143 2.631459045730e+00
RINT493 nd493 nd1144 2.631459045730e+00
RINT494 nd494 nd1145 2.631459045730e+00
RINT495 nd495 nd1146 2.631459045730e+00
RINT496 nd496 nd1147 4.230074822339e+00
RINT497 nd497 nd1148 3.652690404715e+00
RINT498 nd498 nd1149 3.652690404715e+00
RINT499 nd499 nd1150 2.119240969950e+02
RINT500 nd500 nd1151 7.517857760993e+00
RINT501 nd501 nd1152 7.571031020681e+00
RINT502 nd502 nd1153 7.571031020681e+00
RINT503 nd503 nd1154 3.514802294586e+03
RINT504 nd504 nd1155 5.858003824309e+02
RINT505 nd505 nd1156 1.004229227024e+03
RINT506 nd506 nd1157 1.004229227024e+03
RINT507 nd507 nd1158 1.004229227024e+03
RINT508 nd508 nd1159 1.004229227024e+03
RINT509 nd509 nd1160 1.004229227024e+03
RINT510 nd510 nd1161 1.004229227024e+03
RINT511 nd511 nd1162 1.004229227024e+03
RINT512 nd512 nd1163 2.231620504499e+02
RINT513 nd513 nd1164 2.231620504499e+02
RINT514 nd514 nd1165 3.958527469042e+02
RINT515 nd515 nd1166 2.847193251021e+01
RINT516 nd516 nd1167 6.315501709752e+02
RINT517 nd517 nd1168 2.631459045730e+00
RINT518 nd518 nd1169 2.631459045730e+00
RINT519 nd519 nd1170 2.631459045730e+00
RINT520 nd520 nd1171 2.631459045730e+00
RINT521 nd521 nd1172 2.631459045730e+00
RINT522 nd522 nd1173 2.631459045730e+00
RINT523 nd523 nd1174 2.631459045730e+00
RINT524 nd524 nd1175 2.631459045730e+00
RINT525 nd525 nd1176 2.631459045730e+00
RINT526 nd526 nd1177 2.631459045730e+00
RINT527 nd527 nd1178 4.050184192900e+01
RINT528 nd528 nd1179 3.497353961828e+01
RINT529 nd529 nd1180 3.497353961828e+01
RINT530 nd530 nd1181 2.029116892238e+03
RINT531 nd531 nd1182 7.198148956432e+01
RINT532 nd532 nd1183 7.249060939061e+01
RINT533 nd533 nd1184 7.249060939061e+01
RINT534 nd534 nd1185 3.365329761905e+04
RINT535 nd535 nd1186 5.608882936508e+03
RINT536 nd536 nd1187 9.615227891156e+03
RINT537 nd537 nd1188 9.615227891156e+03
RINT538 nd538 nd1189 9.615227891156e+03
RINT539 nd539 nd1190 9.615227891156e+03
RINT540 nd540 nd1191 9.615227891156e+03
RINT541 nd541 nd1192 9.615227891156e+03
RINT542 nd542 nd1193 9.615227891156e+03
RINT543 nd543 nd1194 2.136717309146e+03
RINT544 nd544 nd1195 2.136717309146e+03
RINT545 nd545 nd1196 3.790184820752e+03
RINT546 nd546 nd1197 2.726111849965e+02
RINT547 nd547 nd1198 6.046925000000e+03
RINT548 nd548 nd1199 2.519552083333e+01
RINT549 nd549 nd1200 2.519552083333e+01
RINT550 nd550 nd1201 2.519552083333e+01
RINT551 nd551 nd1202 2.519552083333e+01
RINT552 nd552 nd1203 2.519552083333e+01
RINT553 nd553 nd1204 2.519552083333e+01
RINT554 nd554 nd1205 2.519552083333e+01
RINT555 nd555 nd1206 2.519552083333e+01
RINT556 nd556 nd1207 2.519552083333e+01
RINT557 nd557 nd1208 2.519552083333e+01
RINT558 nd558 nd1209 5.509580147687e+00
RINT559 nd559 nd1210 4.757549543375e+00
RINT560 nd560 nd1211 4.757549543375e+00
RINT561 nd561 nd1212 2.760265117425e+02
RINT562 nd562 nd1213 9.791845679505e+00
RINT563 nd563 nd1214 9.861102689905e+00
RINT564 nd564 nd1215 9.861102689905e+00
RINT565 nd565 nd1216 3.917049124046e+02
RINT566 nd566 nd1217 6.528415206743e+01
RINT567 nd567 nd1218 1.119156892585e+02
RINT568 nd568 nd1219 1.119156892584e+02
RINT569 nd569 nd1220 1.119156892585e+02
RINT570 nd570 nd1221 1.119156892584e+02
RINT571 nd571 nd1222 1.119156892585e+02
RINT572 nd572 nd1223 1.119156892585e+02
RINT573 nd573 nd1224 1.119156892584e+02
RINT574 nd574 nd1225 2.487015316854e+01
RINT575 nd575 nd1226 2.487015316854e+01
RINT576 nd576 nd1227 5.155895645706e+02
RINT577 nd577 nd1228 3.708407078194e+01
RINT578 nd578 nd1229 8.225803160496e+02
RINT579 nd579 nd1230 3.427417983540e+00
RINT580 nd580 nd1231 3.427417983540e+00
RINT581 nd581 nd1232 3.427417983540e+00
RINT582 nd582 nd1233 3.427417983540e+00
RINT583 nd583 nd1234 3.427417983540e+00
RINT584 nd584 nd1235 3.427417983540e+00
RINT585 nd585 nd1236 3.427417983540e+00
RINT586 nd586 nd1237 3.427417983540e+00
RINT587 nd587 nd1238 3.427417983540e+00
RINT588 nd588 nd1239 3.427417983540e+00
RINT589 nd589 nd1240 5.509580147687e+00
RINT590 nd590 nd1241 4.757549543375e+00
RINT591 nd591 nd1242 4.757549543375e+00
RINT592 nd592 nd1243 2.760265117425e+02
RINT593 nd593 nd1244 9.791845679505e+00
RINT594 nd594 nd1245 9.861102689905e+00
RINT595 nd595 nd1246 9.861102689905e+00
RINT596 nd596 nd1247 3.917049124046e+02
RINT597 nd597 nd1248 6.528415206743e+01
RINT598 nd598 nd1249 1.119156892585e+02
RINT599 nd599 nd1250 1.119156892584e+02
RINT600 nd600 nd1251 1.119156892585e+02
RINT601 nd601 nd1252 1.119156892584e+02
RINT602 nd602 nd1253 1.119156892585e+02
RINT603 nd603 nd1254 1.119156892585e+02
RINT604 nd604 nd1255 1.119156892584e+02
RINT605 nd605 nd1256 2.487015316854e+01
RINT606 nd606 nd1257 2.487015316854e+01
RINT607 nd607 nd1258 5.155895645706e+02
RINT608 nd608 nd1259 3.708407078194e+01
RINT609 nd609 nd1260 8.225803160496e+02
RINT610 nd610 nd1261 3.427417983540e+00
RINT611 nd611 nd1262 3.427417983540e+00
RINT612 nd612 nd1263 3.427417983540e+00
RINT613 nd613 nd1264 3.427417983540e+00
RINT614 nd614 nd1265 3.427417983540e+00
RINT615 nd615 nd1266 3.427417983540e+00
RINT616 nd616 nd1267 3.427417983540e+00
RINT617 nd617 nd1268 3.427417983540e+00
RINT618 nd618 nd1269 3.427417983540e+00
RINT619 nd619 nd1270 3.427417983540e+00
RINT620 nd620 nd1271 5.509580147687e+00
RINT621 nd621 nd1272 4.757549543375e+00
RINT622 nd622 nd1273 4.757549543375e+00
RINT623 nd623 nd1274 2.760265117425e+02
RINT624 nd624 nd1275 9.791845679505e+00
RINT625 nd625 nd1276 9.861102689905e+00
RINT626 nd626 nd1277 9.861102689905e+00
RINT627 nd627 nd1278 3.917049124046e+02
RINT628 nd628 nd1279 6.528415206743e+01
RINT629 nd629 nd1280 1.119156892585e+02
RINT630 nd630 nd1281 1.119156892584e+02
RINT631 nd631 nd1282 1.119156892585e+02
RINT632 nd632 nd1283 1.119156892584e+02
RINT633 nd633 nd1284 1.119156892585e+02
RINT634 nd634 nd1285 1.119156892585e+02
RINT635 nd635 nd1286 1.119156892584e+02
RINT636 nd636 nd1287 2.487015316854e+01
RINT637 nd637 nd1288 2.487015316854e+01
RINT638 nd638 nd1289 5.155895645706e+02
RINT639 nd639 nd1290 3.708407078194e+01
RINT640 nd640 nd1291 8.225803160496e+02
RINT641 nd641 nd1292 3.427417983540e+00
RINT642 nd642 nd1293 3.427417983540e+00
RINT643 nd643 nd1294 3.427417983540e+00
RINT644 nd644 nd1295 3.427417983540e+00
RINT645 nd645 nd1296 3.427417983540e+00
RINT646 nd646 nd1297 3.427417983540e+00
RINT647 nd647 nd1298 3.427417983540e+00
RINT648 nd648 nd1299 3.427417983540e+00
RINT649 nd649 nd1300 3.427417983540e+00
RINT650 nd650 nd1301 3.427417983540e+00
RINT651 nd651 nd1302 9.521626084020e+00
RINT652 nd652 nd1303 8.221970933165e+00
RINT653 nd653 nd1304 8.221970933165e+00
RINT654 nd654 nd1305 4.770274982191e+02
RINT655 nd655 nd1306 1.692221380459e+01
RINT656 nd656 nd1307 1.704190338874e+01
RINT657 nd657 nd1308 1.704190338874e+01
RINT658 nd658 nd1309 6.769422734972e+02
RINT659 nd659 nd1310 1.128237122495e+02
RINT660 nd660 nd1311 1.934120781421e+02
RINT661 nd661 nd1312 1.934120781421e+02
RINT662 nd662 nd1313 1.934120781421e+02
RINT663 nd663 nd1314 1.934120781421e+02
RINT664 nd664 nd1315 1.934120781421e+02
RINT665 nd665 nd1316 1.934120781421e+02
RINT666 nd666 nd1317 1.934120781421e+02
RINT667 nd667 nd1318 4.298046180935e+01
RINT668 nd668 nd1319 4.298046180935e+01
RINT669 nd669 nd1320 8.910390474536e+02
RINT670 nd670 nd1321 6.408848699791e+01
RINT671 nd671 nd1322 1.421578774344e+03
RINT672 nd672 nd1323 5.923244893101e+00
RINT673 nd673 nd1324 5.923244893101e+00
RINT674 nd674 nd1325 5.923244893101e+00
RINT675 nd675 nd1326 5.923244893101e+00
RINT676 nd676 nd1327 5.923244893101e+00
RINT677 nd677 nd1328 5.923244893101e+00
RINT678 nd678 nd1329 5.923244893101e+00
RINT679 nd679 nd1330 5.923244893101e+00
RINT680 nd680 nd1331 5.923244893101e+00
RINT681 nd681 nd1332 5.923244893101e+00
RINT682 nd682 nd1333 9.521626084020e+00
RINT683 nd683 nd1334 8.221970933165e+00
RINT684 nd684 nd1335 8.221970933165e+00
RINT685 nd685 nd1336 4.770274982191e+02
RINT686 nd686 nd1337 1.692221380459e+01
RINT687 nd687 nd1338 1.704190338874e+01
RINT688 nd688 nd1339 1.704190338874e+01
RINT689 nd689 nd1340 6.769422734972e+02
RINT690 nd690 nd1341 1.128237122495e+02
RINT691 nd691 nd1342 1.934120781421e+02
RINT692 nd692 nd1343 1.934120781421e+02
RINT693 nd693 nd1344 1.934120781421e+02
RINT694 nd694 nd1345 1.934120781421e+02
RINT695 nd695 nd1346 1.934120781421e+02
RINT696 nd696 nd1347 1.934120781421e+02
RINT697 nd697 nd1348 1.934120781421e+02
RINT698 nd698 nd1349 4.298046180935e+01
RINT699 nd699 nd1350 4.298046180935e+01
RINT700 nd700 nd1351 8.910390474536e+02
RINT701 nd701 nd1352 6.408848699791e+01
RINT702 nd702 nd1353 1.421578774344e+03
RINT703 nd703 nd1354 5.923244893101e+00
RINT704 nd704 nd1355 5.923244893101e+00
RINT705 nd705 nd1356 5.923244893101e+00
RINT706 nd706 nd1357 5.923244893101e+00
RINT707 nd707 nd1358 5.923244893101e+00
RINT708 nd708 nd1359 5.923244893101e+00
RINT709 nd709 nd1360 5.923244893101e+00
RINT710 nd710 nd1361 5.923244893101e+00
RINT711 nd711 nd1362 5.923244893101e+00
RINT712 nd712 nd1363 5.923244893101e+00
RINT713 nd713 nd1364 9.521626084020e+00
RINT714 nd714 nd1365 8.221970933165e+00
RINT715 nd715 nd1366 8.221970933165e+00
RINT716 nd716 nd1367 4.770274982191e+02
RINT717 nd717 nd1368 1.692221380459e+01
RINT718 nd718 nd1369 1.704190338874e+01
RINT719 nd719 nd1370 1.704190338874e+01
RINT720 nd720 nd1371 6.769422734972e+02
RINT721 nd721 nd1372 1.128237122495e+02
RINT722 nd722 nd1373 1.934120781421e+02
RINT723 nd723 nd1374 1.934120781421e+02
RINT724 nd724 nd1375 1.934120781421e+02
RINT725 nd725 nd1376 1.934120781421e+02
RINT726 nd726 nd1377 1.934120781421e+02
RINT727 nd727 nd1378 1.934120781421e+02
RINT728 nd728 nd1379 1.934120781421e+02
RINT729 nd729 nd1380 4.298046180935e+01
RINT730 nd730 nd1381 4.298046180935e+01
RINT731 nd731 nd1382 8.910390474536e+02
RINT732 nd732 nd1383 6.408848699791e+01
RINT733 nd733 nd1384 1.421578774344e+03
RINT734 nd734 nd1385 5.923244893101e+00
RINT735 nd735 nd1386 5.923244893101e+00
RINT736 nd736 nd1387 5.923244893101e+00
RINT737 nd737 nd1388 5.923244893101e+00
RINT738 nd738 nd1389 5.923244893101e+00
RINT739 nd739 nd1390 5.923244893101e+00
RINT740 nd740 nd1391 5.923244893101e+00
RINT741 nd741 nd1392 5.923244893101e+00
RINT742 nd742 nd1393 5.923244893101e+00
RINT743 nd743 nd1394 5.923244893101e+00
RINT744 nd744 nd1395 6.999506028131e+01
RINT745 nd745 nd1396 6.044107865818e+01
RINT746 nd746 nd1397 6.044107865818e+01
RINT747 nd747 nd1398 3.506708643992e+03
RINT748 nd748 nd1399 1.243980140465e+02
RINT749 nd749 nd1400 1.252778721279e+02
RINT750 nd750 nd1401 1.252778721279e+02
RINT751 nd751 nd1402 3.265707031250e+05
RINT752 nd752 nd1403 5.442845052083e+04
RINT753 nd753 nd1404 9.330591517857e+04
RINT754 nd754 nd1405 9.330591517857e+04
RINT755 nd755 nd1406 9.330591517857e+04
RINT756 nd756 nd1407 9.330591517857e+04
RINT757 nd757 nd1408 9.330591517857e+04
RINT758 nd758 nd1409 9.330591517857e+04
RINT759 nd759 nd1410 9.330591517857e+04
RINT760 nd760 nd1411 2.073464781746e+04
RINT761 nd761 nd1412 2.073464781746e+04
RINT762 nd762 nd1413 6.550176544339e+03
RINT763 nd763 nd1414 4.711251493362e+02
RINT764 nd764 nd1415 1.045026250000e+04
RINT765 nd765 nd1416 4.354276041667e+01
RINT766 nd766 nd1417 4.354276041667e+01
RINT767 nd767 nd1418 4.354276041667e+01
RINT768 nd768 nd1419 4.354276041667e+01
RINT769 nd769 nd1420 4.354276041667e+01
RINT770 nd770 nd1421 4.354276041667e+01
RINT771 nd771 nd1422 4.354276041667e+01
RINT772 nd772 nd1423 4.354276041667e+01
RINT773 nd773 nd1424 4.354276041667e+01
RINT774 nd774 nd1425 4.354276041667e+01
RINT775 nd775 nd1426 7.310392023728e+00
RINT776 nd776 nd1427 6.312559451374e+00
RINT777 nd777 nd1428 6.312559451374e+00
RINT778 nd778 nd1429 3.662460579010e+02
RINT779 nd779 nd1430 1.299232040087e+01
RINT780 nd780 nd1431 1.308421413557e+01
RINT781 nd781 nd1432 1.308421413557e+01
RINT782 nd782 nd1433 3.883351253541e+03
RINT783 nd783 nd1434 6.126511232794e+02
RINT784 nd784 nd1435 1.068078026015e+03
RINT785 nd785 nd1436 1.068078026015e+03
RINT786 nd786 nd1437 1.068078026015e+03
RINT787 nd787 nd1438 1.068078026015e+03
RINT788 nd788 nd1439 1.068078026015e+03
RINT789 nd789 nd1440 1.068078026015e+03
RINT790 nd790 nd1441 1.068078026015e+03
RINT791 nd791 nd1442 2.333909041065e+02
RINT792 nd792 nd1443 2.341781857809e+02
RINT793 nd793 nd1444 6.841105382479e+02
RINT794 nd794 nd1445 4.920503704179e+01
RINT795 nd795 nd1446 1.091441529143e+03
RINT796 nd796 nd1447 4.547673038094e+00
RINT797 nd797 nd1448 4.547673038094e+00
RINT798 nd798 nd1449 4.547673038094e+00
RINT799 nd799 nd1450 4.547673038094e+00
RINT800 nd800 nd1451 4.547673038094e+00
RINT801 nd801 nd1452 4.547673038094e+00
RINT802 nd802 nd1453 4.547673038094e+00
RINT803 nd803 nd1454 4.547673038094e+00
RINT804 nd804 nd1455 4.547673038094e+00
RINT805 nd805 nd1456 4.547673038094e+00
RINT806 nd806 nd1457 7.310392023728e+00
RINT807 nd807 nd1458 6.312559451374e+00
RINT808 nd808 nd1459 6.312559451374e+00
RINT809 nd809 nd1460 3.662460579010e+02
RINT810 nd810 nd1461 1.299232040087e+01
RINT811 nd811 nd1462 1.308421413557e+01
RINT812 nd812 nd1463 1.308421413557e+01
RINT813 nd813 nd1464 3.883351253541e+03
RINT814 nd814 nd1465 6.126511232794e+02
RINT815 nd815 nd1466 1.068078026015e+03
RINT816 nd816 nd1467 1.068078026015e+03
RINT817 nd817 nd1468 1.068078026015e+03
RINT818 nd818 nd1469 1.068078026015e+03
RINT819 nd819 nd1470 1.068078026015e+03
RINT820 nd820 nd1471 1.068078026015e+03
RINT821 nd821 nd1472 1.068078026015e+03
RINT822 nd822 nd1473 2.333909041065e+02
RINT823 nd823 nd1474 2.341781857809e+02
RINT824 nd824 nd1475 6.841105382479e+02
RINT825 nd825 nd1476 4.920503704179e+01
RINT826 nd826 nd1477 1.091441529143e+03
RINT827 nd827 nd1478 4.547673038094e+00
RINT828 nd828 nd1479 4.547673038094e+00
RINT829 nd829 nd1480 4.547673038094e+00
RINT830 nd830 nd1481 4.547673038094e+00
RINT831 nd831 nd1482 4.547673038094e+00
RINT832 nd832 nd1483 4.547673038094e+00
RINT833 nd833 nd1484 4.547673038094e+00
RINT834 nd834 nd1485 4.547673038094e+00
RINT835 nd835 nd1486 4.547673038094e+00
RINT836 nd836 nd1487 4.547673038094e+00
RINT837 nd837 nd1488 7.310392023728e+00
RINT838 nd838 nd1489 6.312559451374e+00
RINT839 nd839 nd1490 6.312559451374e+00
RINT840 nd840 nd1491 3.662460579010e+02
RINT841 nd841 nd1492 1.299232040087e+01
RINT842 nd842 nd1493 1.308421413557e+01
RINT843 nd843 nd1494 1.308421413557e+01
RINT844 nd844 nd1495 3.883351253541e+03
RINT845 nd845 nd1496 6.126511232794e+02
RINT846 nd846 nd1497 1.068078026015e+03
RINT847 nd847 nd1498 1.068078026015e+03
RINT848 nd848 nd1499 1.068078026015e+03
RINT849 nd849 nd1500 1.068078026015e+03
RINT850 nd850 nd1501 1.068078026015e+03
RINT851 nd851 nd1502 1.068078026015e+03
RINT852 nd852 nd1503 1.068078026015e+03
RINT853 nd853 nd1504 2.333909041065e+02
RINT854 nd854 nd1505 2.341781857809e+02
RINT855 nd855 nd1506 6.841105382479e+02
RINT856 nd856 nd1507 4.920503704179e+01
RINT857 nd857 nd1508 1.091441529143e+03
RINT858 nd858 nd1509 4.547673038094e+00
RINT859 nd859 nd1510 4.547673038094e+00
RINT860 nd860 nd1511 4.547673038094e+00
RINT861 nd861 nd1512 4.547673038094e+00
RINT862 nd862 nd1513 4.547673038094e+00
RINT863 nd863 nd1514 4.547673038094e+00
RINT864 nd864 nd1515 4.547673038094e+00
RINT865 nd865 nd1516 4.547673038094e+00
RINT866 nd866 nd1517 4.547673038094e+00
RINT867 nd867 nd1518 4.547673038094e+00
RINT868 nd868 nd1519 7.310392023728e+00
RINT869 nd869 nd1520 6.312559451374e+00
RINT870 nd870 nd1521 6.312559451374e+00
RINT871 nd871 nd1522 3.662460579010e+02
RINT872 nd872 nd1523 1.299232040087e+01
RINT873 nd873 nd1524 1.308421413557e+01
RINT874 nd874 nd1525 1.308421413557e+01
RINT875 nd875 nd1526 3.883351253541e+03
RINT876 nd876 nd1527 6.126511232794e+02
RINT877 nd877 nd1528 1.068078026015e+03
RINT878 nd878 nd1529 1.068078026015e+03
RINT879 nd879 nd1530 1.068078026015e+03
RINT880 nd880 nd1531 1.068078026015e+03
RINT881 nd881 nd1532 1.068078026015e+03
RINT882 nd882 nd1533 1.068078026015e+03
RINT883 nd883 nd1534 1.068078026015e+03
RINT884 nd884 nd1535 2.333909041065e+02
RINT885 nd885 nd1536 2.341781857809e+02
RINT886 nd886 nd1537 6.841105382479e+02
RINT887 nd887 nd1538 4.920503704179e+01
RINT888 nd888 nd1539 1.091441529143e+03
RINT889 nd889 nd1540 4.547673038094e+00
RINT890 nd890 nd1541 4.547673038094e+00
RINT891 nd891 nd1542 4.547673038094e+00
RINT892 nd892 nd1543 4.547673038094e+00
RINT893 nd893 nd1544 4.547673038094e+00
RINT894 nd894 nd1545 4.547673038094e+00
RINT895 nd895 nd1546 4.547673038094e+00
RINT896 nd896 nd1547 4.547673038094e+00
RINT897 nd897 nd1548 4.547673038094e+00
RINT898 nd898 nd1549 4.547673038094e+00
RINT899 nd899 nd1550 7.310392023728e+00
RINT900 nd900 nd1551 6.312559451374e+00
RINT901 nd901 nd1552 6.312559451374e+00
RINT902 nd902 nd1553 3.662460579010e+02
RINT903 nd903 nd1554 1.299232040087e+01
RINT904 nd904 nd1555 1.308421413557e+01
RINT905 nd905 nd1556 1.308421413557e+01
RINT906 nd906 nd1557 3.883351253541e+03
RINT907 nd907 nd1558 6.126511232794e+02
RINT908 nd908 nd1559 1.068078026015e+03
RINT909 nd909 nd1560 1.068078026015e+03
RINT910 nd910 nd1561 1.068078026015e+03
RINT911 nd911 nd1562 1.068078026015e+03
RINT912 nd912 nd1563 1.068078026015e+03
RINT913 nd913 nd1564 1.068078026015e+03
RINT914 nd914 nd1565 1.068078026015e+03
RINT915 nd915 nd1566 2.333909041065e+02
RINT916 nd916 nd1567 2.341781857809e+02
RINT917 nd917 nd1568 6.841105382479e+02
RINT918 nd918 nd1569 4.920503704179e+01
RINT919 nd919 nd1570 1.091441529143e+03
RINT920 nd920 nd1571 4.547673038094e+00
RINT921 nd921 nd1572 4.547673038094e+00
RINT922 nd922 nd1573 4.547673038094e+00
RINT923 nd923 nd1574 4.547673038094e+00
RINT924 nd924 nd1575 4.547673038094e+00
RINT925 nd925 nd1576 4.547673038094e+00
RINT926 nd926 nd1577 4.547673038094e+00
RINT927 nd927 nd1578 4.547673038094e+00
RINT928 nd928 nd1579 4.547673038094e+00
RINT929 nd929 nd1580 4.547673038094e+00
RINT930 nd930 nd1581 7.310392023728e+00
RINT931 nd931 nd1582 6.312559451374e+00
RINT932 nd932 nd1583 6.312559451374e+00
RINT933 nd933 nd1584 3.662460579010e+02
RINT934 nd934 nd1585 1.299232040087e+01
RINT935 nd935 nd1586 1.308421413557e+01
RINT936 nd936 nd1587 1.308421413557e+01
RINT937 nd937 nd1588 3.883351253541e+03
RINT938 nd938 nd1589 6.126511232794e+02
RINT939 nd939 nd1590 1.068078026015e+03
RINT940 nd940 nd1591 1.068078026015e+03
RINT941 nd941 nd1592 1.068078026015e+03
RINT942 nd942 nd1593 1.068078026015e+03
RINT943 nd943 nd1594 1.068078026015e+03
RINT944 nd944 nd1595 1.068078026015e+03
RINT945 nd945 nd1596 1.068078026015e+03
RINT946 nd946 nd1597 2.333909041065e+02
RINT947 nd947 nd1598 2.341781857809e+02
RINT948 nd948 nd1599 6.841105382479e+02
RINT949 nd949 nd1600 4.920503704179e+01
RINT950 nd950 nd1601 1.091441529143e+03
RINT951 nd951 nd1602 4.547673038094e+00
RINT952 nd952 nd1603 4.547673038094e+00
RINT953 nd953 nd1604 4.547673038094e+00
RINT954 nd954 nd1605 4.547673038094e+00
RINT955 nd955 nd1606 4.547673038094e+00
RINT956 nd956 nd1607 4.547673038094e+00
RINT957 nd957 nd1608 4.547673038094e+00
RINT958 nd958 nd1609 4.547673038094e+00
RINT959 nd959 nd1610 4.547673038094e+00
RINT960 nd960 nd1611 4.547673038094e+00
RINT961 nd961 nd1612 6.999506028131e+01
RINT962 nd962 nd1613 6.044107865818e+01
RINT963 nd963 nd1614 6.044107865818e+01
RINT964 nd964 nd1615 3.506708643992e+03
RINT965 nd965 nd1616 1.243980140465e+02
RINT966 nd966 nd1617 1.252778721279e+02
RINT967 nd967 nd1618 1.252778721279e+02
RINT968 nd968 nd1619 3.265707031250e+05
RINT969 nd969 nd1620 5.442845052083e+04
RINT970 nd970 nd1621 9.330591517857e+04
RINT971 nd971 nd1622 9.330591517857e+04
RINT972 nd972 nd1623 9.330591517857e+04
RINT973 nd973 nd1624 9.330591517857e+04
RINT974 nd974 nd1625 9.330591517857e+04
RINT975 nd975 nd1626 9.330591517857e+04
RINT976 nd976 nd1627 9.330591517857e+04
RINT977 nd977 nd1628 2.073464781746e+04
RINT978 nd978 nd1629 2.073464781746e+04
RINT979 nd979 nd1630 6.550176544339e+03
RINT980 nd980 nd1631 4.711251493362e+02
RINT981 nd981 nd1632 1.045026250000e+04
RINT982 nd982 nd1633 4.354276041667e+01
RINT983 nd983 nd1634 4.354276041667e+01
RINT984 nd984 nd1635 4.354276041667e+01
RINT985 nd985 nd1636 4.354276041667e+01
RINT986 nd986 nd1637 4.354276041667e+01
RINT987 nd987 nd1638 4.354276041667e+01
RINT988 nd988 nd1639 4.354276041667e+01
RINT989 nd989 nd1640 4.354276041667e+01
RINT990 nd990 nd1641 4.354276041667e+01
RINT991 nd991 nd1642 4.354276041667e+01
RINT992 nd992 nd1643 7.310392023728e+00
RINT993 nd993 nd1644 6.312559451374e+00
RINT994 nd994 nd1645 6.312559451374e+00
RINT995 nd995 nd1646 3.662460579010e+02
RINT996 nd996 nd1647 1.299232040087e+01
RINT997 nd997 nd1648 1.308421413557e+01
RINT998 nd998 nd1649 1.308421413557e+01
RINT999 nd999 nd1650 3.883351253541e+03
RINT1000 nd1000 nd1651 6.126511232794e+02
RINT1001 nd1001 nd1652 1.068078026015e+03
RINT1002 nd1002 nd1653 1.068078026015e+03
RINT1003 nd1003 nd1654 1.068078026015e+03
RINT1004 nd1004 nd1655 1.068078026015e+03
RINT1005 nd1005 nd1656 1.068078026015e+03
RINT1006 nd1006 nd1657 1.068078026015e+03
RINT1007 nd1007 nd1658 1.068078026015e+03
RINT1008 nd1008 nd1659 2.333909041065e+02
RINT1009 nd1009 nd1660 2.341781857809e+02
RINT1010 nd1010 nd1661 6.841105382479e+02
RINT1011 nd1011 nd1662 4.920503704179e+01
RINT1012 nd1012 nd1663 1.091441529143e+03
RINT1013 nd1013 nd1664 4.547673038094e+00
RINT1014 nd1014 nd1665 4.547673038094e+00
RINT1015 nd1015 nd1666 4.547673038094e+00
RINT1016 nd1016 nd1667 4.547673038094e+00
RINT1017 nd1017 nd1668 4.547673038094e+00
RINT1018 nd1018 nd1669 4.547673038094e+00
RINT1019 nd1019 nd1670 4.547673038094e+00
RINT1020 nd1020 nd1671 4.547673038094e+00
RINT1021 nd1021 nd1672 4.547673038094e+00
RINT1022 nd1022 nd1673 4.547673038094e+00
RINT1023 nd1023 nd1674 7.310392023728e+00
RINT1024 nd1024 nd1675 6.312559451374e+00
RINT1025 nd1025 nd1676 6.312559451374e+00
RINT1026 nd1026 nd1677 3.662460579010e+02
RINT1027 nd1027 nd1678 1.299232040087e+01
RINT1028 nd1028 nd1679 1.308421413557e+01
RINT1029 nd1029 nd1680 1.308421413557e+01
RINT1030 nd1030 nd1681 3.883351253541e+03
RINT1031 nd1031 nd1682 6.126511232794e+02
RINT1032 nd1032 nd1683 1.068078026015e+03
RINT1033 nd1033 nd1684 1.068078026015e+03
RINT1034 nd1034 nd1685 1.068078026015e+03
RINT1035 nd1035 nd1686 1.068078026015e+03
RINT1036 nd1036 nd1687 1.068078026015e+03
RINT1037 nd1037 nd1688 1.068078026015e+03
RINT1038 nd1038 nd1689 1.068078026015e+03
RINT1039 nd1039 nd1690 2.333909041065e+02
RINT1040 nd1040 nd1691 2.341781857809e+02
RINT1041 nd1041 nd1692 6.841105382479e+02
RINT1042 nd1042 nd1693 4.920503704179e+01
RINT1043 nd1043 nd1694 1.091441529143e+03
RINT1044 nd1044 nd1695 4.547673038094e+00
RINT1045 nd1045 nd1696 4.547673038094e+00
RINT1046 nd1046 nd1697 4.547673038094e+00
RINT1047 nd1047 nd1698 4.547673038094e+00
RINT1048 nd1048 nd1699 4.547673038094e+00
RINT1049 nd1049 nd1700 4.547673038094e+00
RINT1050 nd1050 nd1701 4.547673038094e+00
RINT1051 nd1051 nd1702 4.547673038094e+00
RINT1052 nd1052 nd1703 4.547673038094e+00
RINT1053 nd1053 nd1704 4.547673038094e+00
RINT1054 nd1054 nd1705 7.310392023728e+00
RINT1055 nd1055 nd1706 6.312559451374e+00
RINT1056 nd1056 nd1707 6.312559451374e+00
RINT1057 nd1057 nd1708 3.662460579010e+02
RINT1058 nd1058 nd1709 1.299232040087e+01
RINT1059 nd1059 nd1710 1.308421413557e+01
RINT1060 nd1060 nd1711 1.308421413557e+01
RINT1061 nd1061 nd1712 3.883351253541e+03
RINT1062 nd1062 nd1713 6.126511232794e+02
RINT1063 nd1063 nd1714 1.068078026015e+03
RINT1064 nd1064 nd1715 1.068078026015e+03
RINT1065 nd1065 nd1716 1.068078026015e+03
RINT1066 nd1066 nd1717 1.068078026015e+03
RINT1067 nd1067 nd1718 1.068078026015e+03
RINT1068 nd1068 nd1719 1.068078026015e+03
RINT1069 nd1069 nd1720 1.068078026015e+03
RINT1070 nd1070 nd1721 2.333909041065e+02
RINT1071 nd1071 nd1722 2.341781857809e+02
RINT1072 nd1072 nd1723 6.841105382479e+02
RINT1073 nd1073 nd1724 4.920503704179e+01
RINT1074 nd1074 nd1725 1.091441529143e+03
RINT1075 nd1075 nd1726 4.547673038094e+00
RINT1076 nd1076 nd1727 4.547673038094e+00
RINT1077 nd1077 nd1728 4.547673038094e+00
RINT1078 nd1078 nd1729 4.547673038094e+00
RINT1079 nd1079 nd1730 4.547673038094e+00
RINT1080 nd1080 nd1731 4.547673038094e+00
RINT1081 nd1081 nd1732 4.547673038094e+00
RINT1082 nd1082 nd1733 4.547673038094e+00
RINT1083 nd1083 nd1734 4.547673038094e+00
RINT1084 nd1084 nd1735 4.547673038094e+00
RINT1085 nd1085 nd1736 7.310392023728e+00
RINT1086 nd1086 nd1737 6.312559451374e+00
RINT1087 nd1087 nd1738 6.312559451374e+00
RINT1088 nd1088 nd1739 3.662460579010e+02
RINT1089 nd1089 nd1740 1.299232040087e+01
RINT1090 nd1090 nd1741 1.308421413557e+01
RINT1091 nd1091 nd1742 1.308421413557e+01
RINT1092 nd1092 nd1743 3.883351253541e+03
RINT1093 nd1093 nd1744 6.126511232794e+02
RINT1094 nd1094 nd1745 1.068078026015e+03
RINT1095 nd1095 nd1746 1.068078026015e+03
RINT1096 nd1096 nd1747 1.068078026015e+03
RINT1097 nd1097 nd1748 1.068078026015e+03
RINT1098 nd1098 nd1749 1.068078026015e+03
RINT1099 nd1099 nd1750 1.068078026015e+03
RINT1100 nd1100 nd1751 1.068078026015e+03
RINT1101 nd1101 nd1752 2.333909041065e+02
RINT1102 nd1102 nd1753 2.341781857809e+02
RINT1103 nd1103 nd1754 6.841105382479e+02
RINT1104 nd1104 nd1755 4.920503704179e+01
RINT1105 nd1105 nd1756 1.091441529143e+03
RINT1106 nd1106 nd1757 4.547673038094e+00
RINT1107 nd1107 nd1758 4.547673038094e+00
RINT1108 nd1108 nd1759 4.547673038094e+00
RINT1109 nd1109 nd1760 4.547673038094e+00
RINT1110 nd1110 nd1761 4.547673038094e+00
RINT1111 nd1111 nd1762 4.547673038094e+00
RINT1112 nd1112 nd1763 4.547673038094e+00
RINT1113 nd1113 nd1764 4.547673038094e+00
RINT1114 nd1114 nd1765 4.547673038094e+00
RINT1115 nd1115 nd1766 4.547673038094e+00
RINT1116 nd1116 nd1767 7.310392023728e+00
RINT1117 nd1117 nd1768 6.312559451374e+00
RINT1118 nd1118 nd1769 6.312559451374e+00
RINT1119 nd1119 nd1770 3.662460579010e+02
RINT1120 nd1120 nd1771 1.299232040087e+01
RINT1121 nd1121 nd1772 1.308421413557e+01
RINT1122 nd1122 nd1773 1.308421413557e+01
RINT1123 nd1123 nd1774 3.883351253541e+03
RINT1124 nd1124 nd1775 6.126511232794e+02
RINT1125 nd1125 nd1776 1.068078026015e+03
RINT1126 nd1126 nd1777 1.068078026015e+03
RINT1127 nd1127 nd1778 1.068078026015e+03
RINT1128 nd1128 nd1779 1.068078026015e+03
RINT1129 nd1129 nd1780 1.068078026015e+03
RINT1130 nd1130 nd1781 1.068078026015e+03
RINT1131 nd1131 nd1782 1.068078026015e+03
RINT1132 nd1132 nd1783 2.333909041065e+02
RINT1133 nd1133 nd1784 2.341781857809e+02
RINT1134 nd1134 nd1785 6.841105382479e+02
RINT1135 nd1135 nd1786 4.920503704179e+01
RINT1136 nd1136 nd1787 1.091441529143e+03
RINT1137 nd1137 nd1788 4.547673038094e+00
RINT1138 nd1138 nd1789 4.547673038094e+00
RINT1139 nd1139 nd1790 4.547673038094e+00
RINT1140 nd1140 nd1791 4.547673038094e+00
RINT1141 nd1141 nd1792 4.547673038094e+00
RINT1142 nd1142 nd1793 4.547673038094e+00
RINT1143 nd1143 nd1794 4.547673038094e+00
RINT1144 nd1144 nd1795 4.547673038094e+00
RINT1145 nd1145 nd1796 4.547673038094e+00
RINT1146 nd1146 nd1797 4.547673038094e+00
RINT1147 nd1147 nd1798 7.310392023728e+00
RINT1148 nd1148 nd1799 6.312559451374e+00
RINT1149 nd1149 nd1800 6.312559451374e+00
RINT1150 nd1150 nd1801 3.662460579010e+02
RINT1151 nd1151 nd1802 1.299232040087e+01
RINT1152 nd1152 nd1803 1.308421413557e+01
RINT1153 nd1153 nd1804 1.308421413557e+01
RINT1154 nd1154 nd1805 3.883351253541e+03
RINT1155 nd1155 nd1806 6.126511232794e+02
RINT1156 nd1156 nd1807 1.068078026015e+03
RINT1157 nd1157 nd1808 1.068078026015e+03
RINT1158 nd1158 nd1809 1.068078026015e+03
RINT1159 nd1159 nd1810 1.068078026015e+03
RINT1160 nd1160 nd1811 1.068078026015e+03
RINT1161 nd1161 nd1812 1.068078026015e+03
RINT1162 nd1162 nd1813 1.068078026015e+03
RINT1163 nd1163 nd1814 2.333909041065e+02
RINT1164 nd1164 nd1815 2.341781857809e+02
RINT1165 nd1165 nd1816 6.841105382479e+02
RINT1166 nd1166 nd1817 4.920503704179e+01
RINT1167 nd1167 nd1818 1.091441529143e+03
RINT1168 nd1168 nd1819 4.547673038094e+00
RINT1169 nd1169 nd1820 4.547673038094e+00
RINT1170 nd1170 nd1821 4.547673038094e+00
RINT1171 nd1171 nd1822 4.547673038094e+00
RINT1172 nd1172 nd1823 4.547673038094e+00
RINT1173 nd1173 nd1824 4.547673038094e+00
RINT1174 nd1174 nd1825 4.547673038094e+00
RINT1175 nd1175 nd1826 4.547673038094e+00
RINT1176 nd1176 nd1827 4.547673038094e+00
RINT1177 nd1177 nd1828 4.547673038094e+00
RINT1178 nd1178 nd1829 6.999506028131e+01
RINT1179 nd1179 nd1830 6.044107865818e+01
RINT1180 nd1180 nd1831 6.044107865818e+01
RINT1181 nd1181 nd1832 3.506708643992e+03
RINT1182 nd1182 nd1833 1.243980140465e+02
RINT1183 nd1183 nd1834 1.252778721279e+02
RINT1184 nd1184 nd1835 1.252778721279e+02
RINT1185 nd1185 nd1836 3.265707031250e+05
RINT1186 nd1186 nd1837 5.442845052083e+04
RINT1187 nd1187 nd1838 9.330591517857e+04
RINT1188 nd1188 nd1839 9.330591517857e+04
RINT1189 nd1189 nd1840 9.330591517857e+04
RINT1190 nd1190 nd1841 9.330591517857e+04
RINT1191 nd1191 nd1842 9.330591517857e+04
RINT1192 nd1192 nd1843 9.330591517857e+04
RINT1193 nd1193 nd1844 9.330591517857e+04
RINT1194 nd1194 nd1845 2.073464781746e+04
RINT1195 nd1195 nd1846 2.073464781746e+04
RINT1196 nd1196 nd1847 6.550176544339e+03
RINT1197 nd1197 nd1848 4.711251493362e+02
RINT1198 nd1198 nd1849 1.045026250000e+04
RINT1199 nd1199 nd1850 4.354276041667e+01
RINT1200 nd1200 nd1851 4.354276041667e+01
RINT1201 nd1201 nd1852 4.354276041667e+01
RINT1202 nd1202 nd1853 4.354276041667e+01
RINT1203 nd1203 nd1854 4.354276041667e+01
RINT1204 nd1204 nd1855 4.354276041667e+01
RINT1205 nd1205 nd1856 4.354276041667e+01
RINT1206 nd1206 nd1857 4.354276041667e+01
RINT1207 nd1207 nd1858 4.354276041667e+01
RINT1208 nd1208 nd1859 4.354276041667e+01
RINT1209 nd1209 nd1860 9.521626084020e+00
RINT1210 nd1210 nd1861 8.221970933165e+00
RINT1211 nd1211 nd1862 8.221970933165e+00
RINT1212 nd1212 nd1863 4.770274982191e+02
RINT1213 nd1213 nd1864 1.692221380459e+01
RINT1214 nd1214 nd1865 1.704190338874e+01
RINT1215 nd1215 nd1866 1.704190338874e+01
RINT1216 nd1216 nd1867 6.769422734972e+02
RINT1217 nd1217 nd1868 1.128237122495e+02
RINT1218 nd1218 nd1869 1.934120781421e+02
RINT1219 nd1219 nd1870 1.934120781421e+02
RINT1220 nd1220 nd1871 1.934120781421e+02
RINT1221 nd1221 nd1872 1.934120781421e+02
RINT1222 nd1222 nd1873 1.934120781421e+02
RINT1223 nd1223 nd1874 1.934120781421e+02
RINT1224 nd1224 nd1875 1.934120781421e+02
RINT1225 nd1225 nd1876 4.298046180935e+01
RINT1226 nd1226 nd1877 4.298046180935e+01
RINT1227 nd1227 nd1878 8.910390474536e+02
RINT1228 nd1228 nd1879 6.408848699791e+01
RINT1229 nd1229 nd1880 1.421578774344e+03
RINT1230 nd1230 nd1881 5.923244893101e+00
RINT1231 nd1231 nd1882 5.923244893101e+00
RINT1232 nd1232 nd1883 5.923244893101e+00
RINT1233 nd1233 nd1884 5.923244893101e+00
RINT1234 nd1234 nd1885 5.923244893101e+00
RINT1235 nd1235 nd1886 5.923244893101e+00
RINT1236 nd1236 nd1887 5.923244893101e+00
RINT1237 nd1237 nd1888 5.923244893101e+00
RINT1238 nd1238 nd1889 5.923244893101e+00
RINT1239 nd1239 nd1890 5.923244893101e+00
RINT1240 nd1240 nd1891 9.521626084020e+00
RINT1241 nd1241 nd1892 8.221970933165e+00
RINT1242 nd1242 nd1893 8.221970933165e+00
RINT1243 nd1243 nd1894 4.770274982191e+02
RINT1244 nd1244 nd1895 1.692221380459e+01
RINT1245 nd1245 nd1896 1.704190338874e+01
RINT1246 nd1246 nd1897 1.704190338874e+01
RINT1247 nd1247 nd1898 6.769422734972e+02
RINT1248 nd1248 nd1899 1.128237122495e+02
RINT1249 nd1249 nd1900 1.934120781421e+02
RINT1250 nd1250 nd1901 1.934120781421e+02
RINT1251 nd1251 nd1902 1.934120781421e+02
RINT1252 nd1252 nd1903 1.934120781421e+02
RINT1253 nd1253 nd1904 1.934120781421e+02
RINT1254 nd1254 nd1905 1.934120781421e+02
RINT1255 nd1255 nd1906 1.934120781421e+02
RINT1256 nd1256 nd1907 4.298046180935e+01
RINT1257 nd1257 nd1908 4.298046180935e+01
RINT1258 nd1258 nd1909 8.910390474536e+02
RINT1259 nd1259 nd1910 6.408848699791e+01
RINT1260 nd1260 nd1911 1.421578774344e+03
RINT1261 nd1261 nd1912 5.923244893101e+00
RINT1262 nd1262 nd1913 5.923244893101e+00
RINT1263 nd1263 nd1914 5.923244893101e+00
RINT1264 nd1264 nd1915 5.923244893101e+00
RINT1265 nd1265 nd1916 5.923244893101e+00
RINT1266 nd1266 nd1917 5.923244893101e+00
RINT1267 nd1267 nd1918 5.923244893101e+00
RINT1268 nd1268 nd1919 5.923244893101e+00
RINT1269 nd1269 nd1920 5.923244893101e+00
RINT1270 nd1270 nd1921 5.923244893101e+00
RINT1271 nd1271 nd1922 9.521626084020e+00
RINT1272 nd1272 nd1923 8.221970933165e+00
RINT1273 nd1273 nd1924 8.221970933165e+00
RINT1274 nd1274 nd1925 4.770274982191e+02
RINT1275 nd1275 nd1926 1.692221380459e+01
RINT1276 nd1276 nd1927 1.704190338874e+01
RINT1277 nd1277 nd1928 1.704190338874e+01
RINT1278 nd1278 nd1929 6.769422734972e+02
RINT1279 nd1279 nd1930 1.128237122495e+02
RINT1280 nd1280 nd1931 1.934120781421e+02
RINT1281 nd1281 nd1932 1.934120781421e+02
RINT1282 nd1282 nd1933 1.934120781421e+02
RINT1283 nd1283 nd1934 1.934120781421e+02
RINT1284 nd1284 nd1935 1.934120781421e+02
RINT1285 nd1285 nd1936 1.934120781421e+02
RINT1286 nd1286 nd1937 1.934120781421e+02
RINT1287 nd1287 nd1938 4.298046180935e+01
RINT1288 nd1288 nd1939 4.298046180935e+01
RINT1289 nd1289 nd1940 8.910390474536e+02
RINT1290 nd1290 nd1941 6.408848699791e+01
RINT1291 nd1291 nd1942 1.421578774344e+03
RINT1292 nd1292 nd1943 5.923244893101e+00
RINT1293 nd1293 nd1944 5.923244893101e+00
RINT1294 nd1294 nd1945 5.923244893101e+00
RINT1295 nd1295 nd1946 5.923244893101e+00
RINT1296 nd1296 nd1947 5.923244893101e+00
RINT1297 nd1297 nd1948 5.923244893101e+00
RINT1298 nd1298 nd1949 5.923244893101e+00
RINT1299 nd1299 nd1950 5.923244893101e+00
RINT1300 nd1300 nd1951 5.923244893101e+00
RINT1301 nd1301 nd1952 5.923244893101e+00
RINT1302 nd1302 nd1953 1.722097716126e+01
RINT1303 nd1303 nd1954 1.487039843942e+01
RINT1304 nd1304 nd1955 1.487039843942e+01
RINT1305 nd1305 nd1956 8.627601608838e+02
RINT1306 nd1306 nd1957 3.060580775545e+01
RINT1307 nd1307 nd1958 3.082228040171e+01
RINT1308 nd1308 nd1959 3.082228040171e+01
RINT1309 nd1309 nd1960 1.224329471512e+03
RINT1310 nd1310 nd1961 2.040549119187e+02
RINT1311 nd1311 nd1962 3.498084204321e+02
RINT1312 nd1312 nd1963 3.498084204321e+02
RINT1313 nd1313 nd1964 3.498084204321e+02
RINT1314 nd1314 nd1965 3.498084204321e+02
RINT1315 nd1315 nd1966 3.498084204321e+02
RINT1316 nd1316 nd1967 3.498084204321e+02
RINT1317 nd1317 nd1968 3.498084204321e+02
RINT1318 nd1318 nd1969 7.773520454047e+01
RINT1319 nd1319 nd1970 7.773520454047e+01
RINT1320 nd1320 nd1971 1.611548589557e+03
RINT1321 nd1321 nd1972 1.159115429604e+02
RINT1322 nd1322 nd1973 2.571091890176e+03
RINT1323 nd1323 nd1974 1.071288287573e+01
RINT1324 nd1324 nd1975 1.071288287573e+01
RINT1325 nd1325 nd1976 1.071288287573e+01
RINT1326 nd1326 nd1977 1.071288287573e+01
RINT1327 nd1327 nd1978 1.071288287573e+01
RINT1328 nd1328 nd1979 1.071288287573e+01
RINT1329 nd1329 nd1980 1.071288287573e+01
RINT1330 nd1330 nd1981 1.071288287573e+01
RINT1331 nd1331 nd1982 1.071288287573e+01
RINT1332 nd1332 nd1983 1.071288287573e+01
RINT1333 nd1333 nd1984 1.722097716126e+01
RINT1334 nd1334 nd1985 1.487039843942e+01
RINT1335 nd1335 nd1986 1.487039843942e+01
RINT1336 nd1336 nd1987 8.627601608838e+02
RINT1337 nd1337 nd1988 3.060580775545e+01
RINT1338 nd1338 nd1989 3.082228040171e+01
RINT1339 nd1339 nd1990 3.082228040171e+01
RINT1340 nd1340 nd1991 1.224329471512e+03
RINT1341 nd1341 nd1992 2.040549119187e+02
RINT1342 nd1342 nd1993 3.498084204321e+02
RINT1343 nd1343 nd1994 3.498084204321e+02
RINT1344 nd1344 nd1995 3.498084204321e+02
RINT1345 nd1345 nd1996 3.498084204321e+02
RINT1346 nd1346 nd1997 3.498084204321e+02
RINT1347 nd1347 nd1998 3.498084204321e+02
RINT1348 nd1348 nd1999 3.498084204321e+02
RINT1349 nd1349 nd2000 7.773520454047e+01
RINT1350 nd1350 nd2001 7.773520454047e+01
RINT1351 nd1351 nd2002 1.611548589557e+03
RINT1352 nd1352 nd2003 1.159115429604e+02
RINT1353 nd1353 nd2004 2.571091890176e+03
RINT1354 nd1354 nd2005 1.071288287573e+01
RINT1355 nd1355 nd2006 1.071288287573e+01
RINT1356 nd1356 nd2007 1.071288287573e+01
RINT1357 nd1357 nd2008 1.071288287573e+01
RINT1358 nd1358 nd2009 1.071288287573e+01
RINT1359 nd1359 nd2010 1.071288287573e+01
RINT1360 nd1360 nd2011 1.071288287573e+01
RINT1361 nd1361 nd2012 1.071288287573e+01
RINT1362 nd1362 nd2013 1.071288287573e+01
RINT1363 nd1363 nd2014 1.071288287573e+01
RINT1364 nd1364 nd2015 1.722097716126e+01
RINT1365 nd1365 nd2016 1.487039843942e+01
RINT1366 nd1366 nd2017 1.487039843942e+01
RINT1367 nd1367 nd2018 8.627601608838e+02
RINT1368 nd1368 nd2019 3.060580775545e+01
RINT1369 nd1369 nd2020 3.082228040171e+01
RINT1370 nd1370 nd2021 3.082228040171e+01
RINT1371 nd1371 nd2022 1.224329471512e+03
RINT1372 nd1372 nd2023 2.040549119187e+02
RINT1373 nd1373 nd2024 3.498084204321e+02
RINT1374 nd1374 nd2025 3.498084204321e+02
RINT1375 nd1375 nd2026 3.498084204321e+02
RINT1376 nd1376 nd2027 3.498084204321e+02
RINT1377 nd1377 nd2028 3.498084204321e+02
RINT1378 nd1378 nd2029 3.498084204321e+02
RINT1379 nd1379 nd2030 3.498084204321e+02
RINT1380 nd1380 nd2031 7.773520454047e+01
RINT1381 nd1381 nd2032 7.773520454047e+01
RINT1382 nd1382 nd2033 1.611548589557e+03
RINT1383 nd1383 nd2034 1.159115429604e+02
RINT1384 nd1384 nd2035 2.571091890176e+03
RINT1385 nd1385 nd2036 1.071288287573e+01
RINT1386 nd1386 nd2037 1.071288287573e+01
RINT1387 nd1387 nd2038 1.071288287573e+01
RINT1388 nd1388 nd2039 1.071288287573e+01
RINT1389 nd1389 nd2040 1.071288287573e+01
RINT1390 nd1390 nd2041 1.071288287573e+01
RINT1391 nd1391 nd2042 1.071288287573e+01
RINT1392 nd1392 nd2043 1.071288287573e+01
RINT1393 nd1393 nd2044 1.071288287573e+01
RINT1394 nd1394 nd2045 1.071288287573e+01
RINT1395 nd1395 nd2046 1.265942732753e+02
RINT1396 nd1396 nd2047 1.093147773279e+02
RINT1397 nd1397 nd2048 1.093147773279e+02
RINT1398 nd1398 nd2049 6.342293736017e+03
RINT1399 nd1399 nd2050 2.249883937783e+02
RINT1400 nd1400 nd2051 2.265797202797e+02
RINT1401 nd1401 nd2052 2.265797202797e+02
RINT1402 nd1402 nd2053 5.906414062500e+05
RINT1403 nd1403 nd2054 9.844023437500e+04
RINT1404 nd1404 nd2055 1.687546875000e+05
RINT1405 nd1405 nd2056 1.687546875000e+05
RINT1406 nd1406 nd2057 1.687546875000e+05
RINT1407 nd1407 nd2058 1.687546875000e+05
RINT1408 nd1408 nd2059 1.687546875000e+05
RINT1409 nd1409 nd2060 1.687546875000e+05
RINT1410 nd1410 nd2061 1.687546875000e+05
RINT1411 nd1411 nd2062 3.750104166667e+04
RINT1412 nd1412 nd2063 3.750104166667e+04
RINT1413 nd1413 nd2064 1.184676227326e+04
RINT1414 nd1414 nd2065 8.520850708924e+02
RINT1415 nd1415 nd2066 1.890052500000e+04
RINT1416 nd1416 nd2067 7.875218750000e+01
RINT1417 nd1417 nd2068 7.875218750000e+01
RINT1418 nd1418 nd2069 7.875218750000e+01
RINT1419 nd1419 nd2070 7.875218750000e+01
RINT1420 nd1420 nd2071 7.875218750000e+01
RINT1421 nd1421 nd2072 7.875218750000e+01
RINT1422 nd1422 nd2073 7.875218750000e+01
RINT1423 nd1423 nd2074 7.875218750000e+01
RINT1424 nd1424 nd2075 7.875218750000e+01
RINT1425 nd1425 nd2076 7.875218750000e+01
RINT1426 nd1426 nd2077 1.322170110122e+01
RINT1427 nd1427 nd2078 1.141700390059e+01
RINT1428 nd1428 nd2079 1.141700390059e+01
RINT1429 nd1429 nd2080 6.623989372047e+02
RINT1430 nd1430 nd2081 2.349813476405e+01
RINT1431 nd1431 nd2082 2.366433535758e+01
RINT1432 nd1432 nd2083 2.366433535758e+01
RINT1433 nd1433 nd2084 1.239106136042e+03
RINT1434 nd1434 nd2085 1.373695180523e+02
RINT1435 nd1435 nd2086 2.711285174478e+02
RINT1436 nd1436 nd2087 2.711285174478e+02
RINT1437 nd1437 nd2088 2.711285174478e+02
RINT1438 nd1438 nd2089 2.711285174478e+02
RINT1439 nd1439 nd2090 2.711285174478e+02
RINT1440 nd1440 nd2091 2.711285174478e+02
RINT1441 nd1441 nd2092 2.711285174478e+02
RINT1442 nd1442 nd2093 5.233124497231e+01
RINT1443 nd1443 nd2094 5.390580832121e+01
RINT1444 nd1444 nd2095 1.237294118776e+03
RINT1445 nd1445 nd2096 8.899307866519e+01
RINT1446 nd1446 nd2097 1.973999974412e+03
RINT1447 nd1447 nd2098 8.224999893383e+00
RINT1448 nd1448 nd2099 8.224999893383e+00
RINT1449 nd1449 nd2100 8.224999893383e+00
RINT1450 nd1450 nd2101 8.224999893383e+00
RINT1451 nd1451 nd2102 8.224999893383e+00
RINT1452 nd1452 nd2103 8.224999893383e+00
RINT1453 nd1453 nd2104 8.224999893383e+00
RINT1454 nd1454 nd2105 8.224999893383e+00
RINT1455 nd1455 nd2106 8.224999893383e+00
RINT1456 nd1456 nd2107 8.224999893383e+00
RINT1457 nd1457 nd2108 1.322170110122e+01
RINT1458 nd1458 nd2109 1.141700390059e+01
RINT1459 nd1459 nd2110 1.141700390059e+01
RINT1460 nd1460 nd2111 6.623989372047e+02
RINT1461 nd1461 nd2112 2.349813476405e+01
RINT1462 nd1462 nd2113 2.366433535758e+01
RINT1463 nd1463 nd2114 2.366433535758e+01
RINT1464 nd1464 nd2115 1.239106136042e+03
RINT1465 nd1465 nd2116 1.373695180523e+02
RINT1466 nd1466 nd2117 2.711285174478e+02
RINT1467 nd1467 nd2118 2.711285174478e+02
RINT1468 nd1468 nd2119 2.711285174478e+02
RINT1469 nd1469 nd2120 2.711285174478e+02
RINT1470 nd1470 nd2121 2.711285174478e+02
RINT1471 nd1471 nd2122 2.711285174478e+02
RINT1472 nd1472 nd2123 2.711285174478e+02
RINT1473 nd1473 nd2124 5.233124497231e+01
RINT1474 nd1474 nd2125 5.390580832121e+01
RINT1475 nd1475 nd2126 1.237294118776e+03
RINT1476 nd1476 nd2127 8.899307866519e+01
RINT1477 nd1477 nd2128 1.973999974412e+03
RINT1478 nd1478 nd2129 8.224999893383e+00
RINT1479 nd1479 nd2130 8.224999893383e+00
RINT1480 nd1480 nd2131 8.224999893383e+00
RINT1481 nd1481 nd2132 8.224999893383e+00
RINT1482 nd1482 nd2133 8.224999893383e+00
RINT1483 nd1483 nd2134 8.224999893383e+00
RINT1484 nd1484 nd2135 8.224999893383e+00
RINT1485 nd1485 nd2136 8.224999893383e+00
RINT1486 nd1486 nd2137 8.224999893383e+00
RINT1487 nd1487 nd2138 8.224999893383e+00
RINT1488 nd1488 nd2139 1.322170110122e+01
RINT1489 nd1489 nd2140 1.141700390059e+01
RINT1490 nd1490 nd2141 1.141700390059e+01
RINT1491 nd1491 nd2142 6.623989372047e+02
RINT1492 nd1492 nd2143 2.349813476405e+01
RINT1493 nd1493 nd2144 2.366433535758e+01
RINT1494 nd1494 nd2145 2.366433535758e+01
RINT1495 nd1495 nd2146 1.239106136042e+03
RINT1496 nd1496 nd2147 1.373695180523e+02
RINT1497 nd1497 nd2148 2.711285174478e+02
RINT1498 nd1498 nd2149 2.711285174478e+02
RINT1499 nd1499 nd2150 2.711285174478e+02
RINT1500 nd1500 nd2151 2.711285174478e+02
RINT1501 nd1501 nd2152 2.711285174478e+02
RINT1502 nd1502 nd2153 2.711285174478e+02
RINT1503 nd1503 nd2154 2.711285174478e+02
RINT1504 nd1504 nd2155 5.233124497231e+01
RINT1505 nd1505 nd2156 5.390580832121e+01
RINT1506 nd1506 nd2157 1.237294118776e+03
RINT1507 nd1507 nd2158 8.899307866519e+01
RINT1508 nd1508 nd2159 1.973999974412e+03
RINT1509 nd1509 nd2160 8.224999893383e+00
RINT1510 nd1510 nd2161 8.224999893383e+00
RINT1511 nd1511 nd2162 8.224999893383e+00
RINT1512 nd1512 nd2163 8.224999893383e+00
RINT1513 nd1513 nd2164 8.224999893383e+00
RINT1514 nd1514 nd2165 8.224999893383e+00
RINT1515 nd1515 nd2166 8.224999893383e+00
RINT1516 nd1516 nd2167 8.224999893383e+00
RINT1517 nd1517 nd2168 8.224999893383e+00
RINT1518 nd1518 nd2169 8.224999893383e+00
RINT1519 nd1519 nd2170 1.322170110122e+01
RINT1520 nd1520 nd2171 1.141700390059e+01
RINT1521 nd1521 nd2172 1.141700390059e+01
RINT1522 nd1522 nd2173 6.623989372047e+02
RINT1523 nd1523 nd2174 2.349813476405e+01
RINT1524 nd1524 nd2175 2.366433535758e+01
RINT1525 nd1525 nd2176 2.366433535758e+01
RINT1526 nd1526 nd2177 1.239106136042e+03
RINT1527 nd1527 nd2178 1.373695180523e+02
RINT1528 nd1528 nd2179 2.711285174478e+02
RINT1529 nd1529 nd2180 2.711285174478e+02
RINT1530 nd1530 nd2181 2.711285174478e+02
RINT1531 nd1531 nd2182 2.711285174478e+02
RINT1532 nd1532 nd2183 2.711285174478e+02
RINT1533 nd1533 nd2184 2.711285174478e+02
RINT1534 nd1534 nd2185 2.711285174478e+02
RINT1535 nd1535 nd2186 5.233124497231e+01
RINT1536 nd1536 nd2187 5.390580832121e+01
RINT1537 nd1537 nd2188 1.237294118776e+03
RINT1538 nd1538 nd2189 8.899307866519e+01
RINT1539 nd1539 nd2190 1.973999974412e+03
RINT1540 nd1540 nd2191 8.224999893383e+00
RINT1541 nd1541 nd2192 8.224999893383e+00
RINT1542 nd1542 nd2193 8.224999893383e+00
RINT1543 nd1543 nd2194 8.224999893383e+00
RINT1544 nd1544 nd2195 8.224999893383e+00
RINT1545 nd1545 nd2196 8.224999893383e+00
RINT1546 nd1546 nd2197 8.224999893383e+00
RINT1547 nd1547 nd2198 8.224999893383e+00
RINT1548 nd1548 nd2199 8.224999893383e+00
RINT1549 nd1549 nd2200 8.224999893383e+00
RINT1550 nd1550 nd2201 1.322170110122e+01
RINT1551 nd1551 nd2202 1.141700390059e+01
RINT1552 nd1552 nd2203 1.141700390059e+01
RINT1553 nd1553 nd2204 6.623989372047e+02
RINT1554 nd1554 nd2205 2.349813476405e+01
RINT1555 nd1555 nd2206 2.366433535758e+01
RINT1556 nd1556 nd2207 2.366433535758e+01
RINT1557 nd1557 nd2208 1.239106136042e+03
RINT1558 nd1558 nd2209 1.373695180523e+02
RINT1559 nd1559 nd2210 2.711285174478e+02
RINT1560 nd1560 nd2211 2.711285174478e+02
RINT1561 nd1561 nd2212 2.711285174478e+02
RINT1562 nd1562 nd2213 2.711285174478e+02
RINT1563 nd1563 nd2214 2.711285174478e+02
RINT1564 nd1564 nd2215 2.711285174478e+02
RINT1565 nd1565 nd2216 2.711285174478e+02
RINT1566 nd1566 nd2217 5.233124497231e+01
RINT1567 nd1567 nd2218 5.390580832121e+01
RINT1568 nd1568 nd2219 1.237294118776e+03
RINT1569 nd1569 nd2220 8.899307866519e+01
RINT1570 nd1570 nd2221 1.973999974412e+03
RINT1571 nd1571 nd2222 8.224999893383e+00
RINT1572 nd1572 nd2223 8.224999893383e+00
RINT1573 nd1573 nd2224 8.224999893383e+00
RINT1574 nd1574 nd2225 8.224999893383e+00
RINT1575 nd1575 nd2226 8.224999893383e+00
RINT1576 nd1576 nd2227 8.224999893383e+00
RINT1577 nd1577 nd2228 8.224999893383e+00
RINT1578 nd1578 nd2229 8.224999893383e+00
RINT1579 nd1579 nd2230 8.224999893383e+00
RINT1580 nd1580 nd2231 8.224999893383e+00
RINT1581 nd1581 nd2232 1.322170110122e+01
RINT1582 nd1582 nd2233 1.141700390059e+01
RINT1583 nd1583 nd2234 1.141700390059e+01
RINT1584 nd1584 nd2235 6.623989372047e+02
RINT1585 nd1585 nd2236 2.349813476405e+01
RINT1586 nd1586 nd2237 2.366433535758e+01
RINT1587 nd1587 nd2238 2.366433535758e+01
RINT1588 nd1588 nd2239 1.239106136042e+03
RINT1589 nd1589 nd2240 1.373695180523e+02
RINT1590 nd1590 nd2241 2.711285174478e+02
RINT1591 nd1591 nd2242 2.711285174478e+02
RINT1592 nd1592 nd2243 2.711285174478e+02
RINT1593 nd1593 nd2244 2.711285174478e+02
RINT1594 nd1594 nd2245 2.711285174478e+02
RINT1595 nd1595 nd2246 2.711285174478e+02
RINT1596 nd1596 nd2247 2.711285174478e+02
RINT1597 nd1597 nd2248 5.233124497231e+01
RINT1598 nd1598 nd2249 5.390580832121e+01
RINT1599 nd1599 nd2250 1.237294118776e+03
RINT1600 nd1600 nd2251 8.899307866519e+01
RINT1601 nd1601 nd2252 1.973999974412e+03
RINT1602 nd1602 nd2253 8.224999893383e+00
RINT1603 nd1603 nd2254 8.224999893383e+00
RINT1604 nd1604 nd2255 8.224999893383e+00
RINT1605 nd1605 nd2256 8.224999893383e+00
RINT1606 nd1606 nd2257 8.224999893383e+00
RINT1607 nd1607 nd2258 8.224999893383e+00
RINT1608 nd1608 nd2259 8.224999893383e+00
RINT1609 nd1609 nd2260 8.224999893383e+00
RINT1610 nd1610 nd2261 8.224999893383e+00
RINT1611 nd1611 nd2262 8.224999893383e+00
RINT1612 nd1612 nd2263 1.265942732753e+02
RINT1613 nd1613 nd2264 1.093147773279e+02
RINT1614 nd1614 nd2265 1.093147773279e+02
RINT1615 nd1615 nd2266 6.342293736017e+03
RINT1616 nd1616 nd2267 2.249883937783e+02
RINT1617 nd1617 nd2268 2.265797202797e+02
RINT1618 nd1618 nd2269 2.265797202797e+02
RINT1619 nd1619 nd2270 5.906414062500e+05
RINT1620 nd1620 nd2271 9.844023437500e+04
RINT1621 nd1621 nd2272 1.687546875000e+05
RINT1622 nd1622 nd2273 1.687546875000e+05
RINT1623 nd1623 nd2274 1.687546875000e+05
RINT1624 nd1624 nd2275 1.687546875000e+05
RINT1625 nd1625 nd2276 1.687546875000e+05
RINT1626 nd1626 nd2277 1.687546875000e+05
RINT1627 nd1627 nd2278 1.687546875000e+05
RINT1628 nd1628 nd2279 3.750104166667e+04
RINT1629 nd1629 nd2280 3.750104166667e+04
RINT1630 nd1630 nd2281 1.184676227326e+04
RINT1631 nd1631 nd2282 8.520850708924e+02
RINT1632 nd1632 nd2283 1.890052500000e+04
RINT1633 nd1633 nd2284 7.875218750000e+01
RINT1634 nd1634 nd2285 7.875218750000e+01
RINT1635 nd1635 nd2286 7.875218750000e+01
RINT1636 nd1636 nd2287 7.875218750000e+01
RINT1637 nd1637 nd2288 7.875218750000e+01
RINT1638 nd1638 nd2289 7.875218750000e+01
RINT1639 nd1639 nd2290 7.875218750000e+01
RINT1640 nd1640 nd2291 7.875218750000e+01
RINT1641 nd1641 nd2292 7.875218750000e+01
RINT1642 nd1642 nd2293 7.875218750000e+01
RINT1643 nd1643 nd2294 1.322170110122e+01
RINT1644 nd1644 nd2295 1.141700390059e+01
RINT1645 nd1645 nd2296 1.141700390059e+01
RINT1646 nd1646 nd2297 6.623989372047e+02
RINT1647 nd1647 nd2298 2.349813476405e+01
RINT1648 nd1648 nd2299 2.366433535758e+01
RINT1649 nd1649 nd2300 2.366433535758e+01
RINT1650 nd1650 nd2301 1.239106136042e+03
RINT1651 nd1651 nd2302 1.373695180523e+02
RINT1652 nd1652 nd2303 2.711285174478e+02
RINT1653 nd1653 nd2304 2.711285174478e+02
RINT1654 nd1654 nd2305 2.711285174478e+02
RINT1655 nd1655 nd2306 2.711285174478e+02
RINT1656 nd1656 nd2307 2.711285174478e+02
RINT1657 nd1657 nd2308 2.711285174478e+02
RINT1658 nd1658 nd2309 2.711285174478e+02
RINT1659 nd1659 nd2310 5.233124497231e+01
RINT1660 nd1660 nd2311 5.390580832121e+01
RINT1661 nd1661 nd2312 1.237294118776e+03
RINT1662 nd1662 nd2313 8.899307866519e+01
RINT1663 nd1663 nd2314 1.973999974412e+03
RINT1664 nd1664 nd2315 8.224999893383e+00
RINT1665 nd1665 nd2316 8.224999893383e+00
RINT1666 nd1666 nd2317 8.224999893383e+00
RINT1667 nd1667 nd2318 8.224999893383e+00
RINT1668 nd1668 nd2319 8.224999893383e+00
RINT1669 nd1669 nd2320 8.224999893383e+00
RINT1670 nd1670 nd2321 8.224999893383e+00
RINT1671 nd1671 nd2322 8.224999893383e+00
RINT1672 nd1672 nd2323 8.224999893383e+00
RINT1673 nd1673 nd2324 8.224999893383e+00
RINT1674 nd1674 nd2325 1.322170110122e+01
RINT1675 nd1675 nd2326 1.141700390059e+01
RINT1676 nd1676 nd2327 1.141700390059e+01
RINT1677 nd1677 nd2328 6.623989372047e+02
RINT1678 nd1678 nd2329 2.349813476405e+01
RINT1679 nd1679 nd2330 2.366433535758e+01
RINT1680 nd1680 nd2331 2.366433535758e+01
RINT1681 nd1681 nd2332 1.239106136042e+03
RINT1682 nd1682 nd2333 1.373695180523e+02
RINT1683 nd1683 nd2334 2.711285174478e+02
RINT1684 nd1684 nd2335 2.711285174478e+02
RINT1685 nd1685 nd2336 2.711285174478e+02
RINT1686 nd1686 nd2337 2.711285174478e+02
RINT1687 nd1687 nd2338 2.711285174478e+02
RINT1688 nd1688 nd2339 2.711285174478e+02
RINT1689 nd1689 nd2340 2.711285174478e+02
RINT1690 nd1690 nd2341 5.233124497231e+01
RINT1691 nd1691 nd2342 5.390580832121e+01
RINT1692 nd1692 nd2343 1.237294118776e+03
RINT1693 nd1693 nd2344 8.899307866519e+01
RINT1694 nd1694 nd2345 1.973999974412e+03
RINT1695 nd1695 nd2346 8.224999893383e+00
RINT1696 nd1696 nd2347 8.224999893383e+00
RINT1697 nd1697 nd2348 8.224999893383e+00
RINT1698 nd1698 nd2349 8.224999893383e+00
RINT1699 nd1699 nd2350 8.224999893383e+00
RINT1700 nd1700 nd2351 8.224999893383e+00
RINT1701 nd1701 nd2352 8.224999893383e+00
RINT1702 nd1702 nd2353 8.224999893383e+00
RINT1703 nd1703 nd2354 8.224999893383e+00
RINT1704 nd1704 nd2355 8.224999893383e+00
RINT1705 nd1705 nd2356 1.322170110122e+01
RINT1706 nd1706 nd2357 1.141700390059e+01
RINT1707 nd1707 nd2358 1.141700390059e+01
RINT1708 nd1708 nd2359 6.623989372047e+02
RINT1709 nd1709 nd2360 2.349813476405e+01
RINT1710 nd1710 nd2361 2.366433535758e+01
RINT1711 nd1711 nd2362 2.366433535758e+01
RINT1712 nd1712 nd2363 1.239106136042e+03
RINT1713 nd1713 nd2364 1.373695180523e+02
RINT1714 nd1714 nd2365 2.711285174478e+02
RINT1715 nd1715 nd2366 2.711285174478e+02
RINT1716 nd1716 nd2367 2.711285174478e+02
RINT1717 nd1717 nd2368 2.711285174478e+02
RINT1718 nd1718 nd2369 2.711285174478e+02
RINT1719 nd1719 nd2370 2.711285174478e+02
RINT1720 nd1720 nd2371 2.711285174478e+02
RINT1721 nd1721 nd2372 5.233124497231e+01
RINT1722 nd1722 nd2373 5.390580832121e+01
RINT1723 nd1723 nd2374 1.237294118776e+03
RINT1724 nd1724 nd2375 8.899307866519e+01
RINT1725 nd1725 nd2376 1.973999974412e+03
RINT1726 nd1726 nd2377 8.224999893383e+00
RINT1727 nd1727 nd2378 8.224999893383e+00
RINT1728 nd1728 nd2379 8.224999893383e+00
RINT1729 nd1729 nd2380 8.224999893383e+00
RINT1730 nd1730 nd2381 8.224999893383e+00
RINT1731 nd1731 nd2382 8.224999893383e+00
RINT1732 nd1732 nd2383 8.224999893383e+00
RINT1733 nd1733 nd2384 8.224999893383e+00
RINT1734 nd1734 nd2385 8.224999893383e+00
RINT1735 nd1735 nd2386 8.224999893383e+00
RINT1736 nd1736 nd2387 1.322170110122e+01
RINT1737 nd1737 nd2388 1.141700390059e+01
RINT1738 nd1738 nd2389 1.141700390059e+01
RINT1739 nd1739 nd2390 6.623989372047e+02
RINT1740 nd1740 nd2391 2.349813476405e+01
RINT1741 nd1741 nd2392 2.366433535758e+01
RINT1742 nd1742 nd2393 2.366433535758e+01
RINT1743 nd1743 nd2394 1.239106136042e+03
RINT1744 nd1744 nd2395 1.373695180523e+02
RINT1745 nd1745 nd2396 2.711285174478e+02
RINT1746 nd1746 nd2397 2.711285174478e+02
RINT1747 nd1747 nd2398 2.711285174478e+02
RINT1748 nd1748 nd2399 2.711285174478e+02
RINT1749 nd1749 nd2400 2.711285174478e+02
RINT1750 nd1750 nd2401 2.711285174478e+02
RINT1751 nd1751 nd2402 2.711285174478e+02
RINT1752 nd1752 nd2403 5.233124497231e+01
RINT1753 nd1753 nd2404 5.390580832121e+01
RINT1754 nd1754 nd2405 1.237294118776e+03
RINT1755 nd1755 nd2406 8.899307866519e+01
RINT1756 nd1756 nd2407 1.973999974412e+03
RINT1757 nd1757 nd2408 8.224999893383e+00
RINT1758 nd1758 nd2409 8.224999893383e+00
RINT1759 nd1759 nd2410 8.224999893383e+00
RINT1760 nd1760 nd2411 8.224999893383e+00
RINT1761 nd1761 nd2412 8.224999893383e+00
RINT1762 nd1762 nd2413 8.224999893383e+00
RINT1763 nd1763 nd2414 8.224999893383e+00
RINT1764 nd1764 nd2415 8.224999893383e+00
RINT1765 nd1765 nd2416 8.224999893383e+00
RINT1766 nd1766 nd2417 8.224999893383e+00
RINT1767 nd1767 nd2418 1.322170110122e+01
RINT1768 nd1768 nd2419 1.141700390059e+01
RINT1769 nd1769 nd2420 1.141700390059e+01
RINT1770 nd1770 nd2421 6.623989372047e+02
RINT1771 nd1771 nd2422 2.349813476405e+01
RINT1772 nd1772 nd2423 2.366433535758e+01
RINT1773 nd1773 nd2424 2.366433535758e+01
RINT1774 nd1774 nd2425 1.239106136042e+03
RINT1775 nd1775 nd2426 1.373695180523e+02
RINT1776 nd1776 nd2427 2.711285174478e+02
RINT1777 nd1777 nd2428 2.711285174478e+02
RINT1778 nd1778 nd2429 2.711285174478e+02
RINT1779 nd1779 nd2430 2.711285174478e+02
RINT1780 nd1780 nd2431 2.711285174478e+02
RINT1781 nd1781 nd2432 2.711285174478e+02
RINT1782 nd1782 nd2433 2.711285174478e+02
RINT1783 nd1783 nd2434 5.233124497231e+01
RINT1784 nd1784 nd2435 5.390580832121e+01
RINT1785 nd1785 nd2436 1.237294118776e+03
RINT1786 nd1786 nd2437 8.899307866519e+01
RINT1787 nd1787 nd2438 1.973999974412e+03
RINT1788 nd1788 nd2439 8.224999893383e+00
RINT1789 nd1789 nd2440 8.224999893383e+00
RINT1790 nd1790 nd2441 8.224999893383e+00
RINT1791 nd1791 nd2442 8.224999893383e+00
RINT1792 nd1792 nd2443 8.224999893383e+00
RINT1793 nd1793 nd2444 8.224999893383e+00
RINT1794 nd1794 nd2445 8.224999893383e+00
RINT1795 nd1795 nd2446 8.224999893383e+00
RINT1796 nd1796 nd2447 8.224999893383e+00
RINT1797 nd1797 nd2448 8.224999893383e+00
RINT1798 nd1798 nd2449 1.322170110122e+01
RINT1799 nd1799 nd2450 1.141700390059e+01
RINT1800 nd1800 nd2451 1.141700390059e+01
RINT1801 nd1801 nd2452 6.623989372047e+02
RINT1802 nd1802 nd2453 2.349813476405e+01
RINT1803 nd1803 nd2454 2.366433535758e+01
RINT1804 nd1804 nd2455 2.366433535758e+01
RINT1805 nd1805 nd2456 1.239106136042e+03
RINT1806 nd1806 nd2457 1.373695180523e+02
RINT1807 nd1807 nd2458 2.711285174478e+02
RINT1808 nd1808 nd2459 2.711285174478e+02
RINT1809 nd1809 nd2460 2.711285174478e+02
RINT1810 nd1810 nd2461 2.711285174478e+02
RINT1811 nd1811 nd2462 2.711285174478e+02
RINT1812 nd1812 nd2463 2.711285174478e+02
RINT1813 nd1813 nd2464 2.711285174478e+02
RINT1814 nd1814 nd2465 5.233124497231e+01
RINT1815 nd1815 nd2466 5.390580832121e+01
RINT1816 nd1816 nd2467 1.237294118776e+03
RINT1817 nd1817 nd2468 8.899307866519e+01
RINT1818 nd1818 nd2469 1.973999974412e+03
RINT1819 nd1819 nd2470 8.224999893383e+00
RINT1820 nd1820 nd2471 8.224999893383e+00
RINT1821 nd1821 nd2472 8.224999893383e+00
RINT1822 nd1822 nd2473 8.224999893383e+00
RINT1823 nd1823 nd2474 8.224999893383e+00
RINT1824 nd1824 nd2475 8.224999893383e+00
RINT1825 nd1825 nd2476 8.224999893383e+00
RINT1826 nd1826 nd2477 8.224999893383e+00
RINT1827 nd1827 nd2478 8.224999893383e+00
RINT1828 nd1828 nd2479 8.224999893383e+00
RINT1829 nd1829 nd2480 1.265942732753e+02
RINT1830 nd1830 nd2481 1.093147773279e+02
RINT1831 nd1831 nd2482 1.093147773279e+02
RINT1832 nd1832 nd2483 6.342293736017e+03
RINT1833 nd1833 nd2484 2.249883937783e+02
RINT1834 nd1834 nd2485 2.265797202797e+02
RINT1835 nd1835 nd2486 2.265797202797e+02
RINT1836 nd1836 nd2487 5.906414062500e+05
RINT1837 nd1837 nd2488 9.844023437500e+04
RINT1838 nd1838 nd2489 1.687546875000e+05
RINT1839 nd1839 nd2490 1.687546875000e+05
RINT1840 nd1840 nd2491 1.687546875000e+05
RINT1841 nd1841 nd2492 1.687546875000e+05
RINT1842 nd1842 nd2493 1.687546875000e+05
RINT1843 nd1843 nd2494 1.687546875000e+05
RINT1844 nd1844 nd2495 1.687546875000e+05
RINT1845 nd1845 nd2496 3.750104166667e+04
RINT1846 nd1846 nd2497 3.750104166667e+04
RINT1847 nd1847 nd2498 1.184676227326e+04
RINT1848 nd1848 nd2499 8.520850708924e+02
RINT1849 nd1849 nd2500 1.890052500000e+04
RINT1850 nd1850 nd2501 7.875218750000e+01
RINT1851 nd1851 nd2502 7.875218750000e+01
RINT1852 nd1852 nd2503 7.875218750000e+01
RINT1853 nd1853 nd2504 7.875218750000e+01
RINT1854 nd1854 nd2505 7.875218750000e+01
RINT1855 nd1855 nd2506 7.875218750000e+01
RINT1856 nd1856 nd2507 7.875218750000e+01
RINT1857 nd1857 nd2508 7.875218750000e+01
RINT1858 nd1858 nd2509 7.875218750000e+01
RINT1859 nd1859 nd2510 7.875218750000e+01
RINT1860 nd1860 nd2511 1.722097716126e+01
RINT1861 nd1861 nd2512 1.487039843942e+01
RINT1862 nd1862 nd2513 1.487039843942e+01
RINT1863 nd1863 nd2514 8.627601608838e+02
RINT1864 nd1864 nd2515 3.060580775545e+01
RINT1865 nd1865 nd2516 3.082228040171e+01
RINT1866 nd1866 nd2517 3.082228040171e+01
RINT1867 nd1867 nd2518 1.224329471512e+03
RINT1868 nd1868 nd2519 2.040549119187e+02
RINT1869 nd1869 nd2520 3.498084204321e+02
RINT1870 nd1870 nd2521 3.498084204321e+02
RINT1871 nd1871 nd2522 3.498084204321e+02
RINT1872 nd1872 nd2523 3.498084204321e+02
RINT1873 nd1873 nd2524 3.498084204321e+02
RINT1874 nd1874 nd2525 3.498084204321e+02
RINT1875 nd1875 nd2526 3.498084204321e+02
RINT1876 nd1876 nd2527 7.773520454047e+01
RINT1877 nd1877 nd2528 7.773520454047e+01
RINT1878 nd1878 nd2529 1.611548589557e+03
RINT1879 nd1879 nd2530 1.159115429604e+02
RINT1880 nd1880 nd2531 2.571091890176e+03
RINT1881 nd1881 nd2532 1.071288287573e+01
RINT1882 nd1882 nd2533 1.071288287573e+01
RINT1883 nd1883 nd2534 1.071288287573e+01
RINT1884 nd1884 nd2535 1.071288287573e+01
RINT1885 nd1885 nd2536 1.071288287573e+01
RINT1886 nd1886 nd2537 1.071288287573e+01
RINT1887 nd1887 nd2538 1.071288287573e+01
RINT1888 nd1888 nd2539 1.071288287573e+01
RINT1889 nd1889 nd2540 1.071288287573e+01
RINT1890 nd1890 nd2541 1.071288287573e+01
RINT1891 nd1891 nd2542 1.722097716126e+01
RINT1892 nd1892 nd2543 1.487039843942e+01
RINT1893 nd1893 nd2544 1.487039843942e+01
RINT1894 nd1894 nd2545 8.627601608838e+02
RINT1895 nd1895 nd2546 3.060580775545e+01
RINT1896 nd1896 nd2547 3.082228040171e+01
RINT1897 nd1897 nd2548 3.082228040171e+01
RINT1898 nd1898 nd2549 1.224329471512e+03
RINT1899 nd1899 nd2550 2.040549119187e+02
RINT1900 nd1900 nd2551 3.498084204321e+02
RINT1901 nd1901 nd2552 3.498084204321e+02
RINT1902 nd1902 nd2553 3.498084204321e+02
RINT1903 nd1903 nd2554 3.498084204321e+02
RINT1904 nd1904 nd2555 3.498084204321e+02
RINT1905 nd1905 nd2556 3.498084204321e+02
RINT1906 nd1906 nd2557 3.498084204321e+02
RINT1907 nd1907 nd2558 7.773520454047e+01
RINT1908 nd1908 nd2559 7.773520454047e+01
RINT1909 nd1909 nd2560 1.611548589557e+03
RINT1910 nd1910 nd2561 1.159115429604e+02
RINT1911 nd1911 nd2562 2.571091890176e+03
RINT1912 nd1912 nd2563 1.071288287573e+01
RINT1913 nd1913 nd2564 1.071288287573e+01
RINT1914 nd1914 nd2565 1.071288287573e+01
RINT1915 nd1915 nd2566 1.071288287573e+01
RINT1916 nd1916 nd2567 1.071288287573e+01
RINT1917 nd1917 nd2568 1.071288287573e+01
RINT1918 nd1918 nd2569 1.071288287573e+01
RINT1919 nd1919 nd2570 1.071288287573e+01
RINT1920 nd1920 nd2571 1.071288287573e+01
RINT1921 nd1921 nd2572 1.071288287573e+01
RINT1922 nd1922 nd2573 1.722097716126e+01
RINT1923 nd1923 nd2574 1.487039843942e+01
RINT1924 nd1924 nd2575 1.487039843942e+01
RINT1925 nd1925 nd2576 8.627601608838e+02
RINT1926 nd1926 nd2577 3.060580775545e+01
RINT1927 nd1927 nd2578 3.082228040171e+01
RINT1928 nd1928 nd2579 3.082228040171e+01
RINT1929 nd1929 nd2580 1.224329471512e+03
RINT1930 nd1930 nd2581 2.040549119187e+02
RINT1931 nd1931 nd2582 3.498084204321e+02
RINT1932 nd1932 nd2583 3.498084204321e+02
RINT1933 nd1933 nd2584 3.498084204321e+02
RINT1934 nd1934 nd2585 3.498084204321e+02
RINT1935 nd1935 nd2586 3.498084204321e+02
RINT1936 nd1936 nd2587 3.498084204321e+02
RINT1937 nd1937 nd2588 3.498084204321e+02
RINT1938 nd1938 nd2589 7.773520454047e+01
RINT1939 nd1939 nd2590 7.773520454047e+01
RINT1940 nd1940 nd2591 1.611548589557e+03
RINT1941 nd1941 nd2592 1.159115429604e+02
RINT1942 nd1942 nd2593 2.571091890176e+03
RINT1943 nd1943 nd2594 1.071288287573e+01
RINT1944 nd1944 nd2595 1.071288287573e+01
RINT1945 nd1945 nd2596 1.071288287573e+01
RINT1946 nd1946 nd2597 1.071288287573e+01
RINT1947 nd1947 nd2598 1.071288287573e+01
RINT1948 nd1948 nd2599 1.071288287573e+01
RINT1949 nd1949 nd2600 1.071288287573e+01
RINT1950 nd1950 nd2601 1.071288287573e+01
RINT1951 nd1951 nd2602 1.071288287573e+01
RINT1952 nd1952 nd2603 1.071288287573e+01
RINT1953 nd1953 nd2604 1.722097716126e+01
RINT1954 nd1954 nd2605 1.487039843942e+01
RINT1955 nd1955 nd2606 1.487039843942e+01
RINT1956 nd1956 nd2607 8.627601608838e+02
RINT1957 nd1957 nd2608 3.060580775545e+01
RINT1958 nd1958 nd2609 3.082228040171e+01
RINT1959 nd1959 nd2610 3.082228040171e+01
RINT1960 nd1960 nd2611 1.224329471512e+03
RINT1961 nd1961 nd2612 2.040549119187e+02
RINT1962 nd1962 nd2613 3.498084204321e+02
RINT1963 nd1963 nd2614 3.498084204321e+02
RINT1964 nd1964 nd2615 3.498084204321e+02
RINT1965 nd1965 nd2616 3.498084204321e+02
RINT1966 nd1966 nd2617 3.498084204321e+02
RINT1967 nd1967 nd2618 3.498084204321e+02
RINT1968 nd1968 nd2619 3.498084204321e+02
RINT1969 nd1969 nd2620 7.773520454047e+01
RINT1970 nd1970 nd2621 7.773520454047e+01
RINT1971 nd1971 nd2622 1.611548589557e+03
RINT1972 nd1972 nd2623 1.159115429604e+02
RINT1973 nd1973 nd2624 2.571091890176e+03
RINT1974 nd1974 nd2625 1.071288287573e+01
RINT1975 nd1975 nd2626 1.071288287573e+01
RINT1976 nd1976 nd2627 1.071288287573e+01
RINT1977 nd1977 nd2628 1.071288287573e+01
RINT1978 nd1978 nd2629 1.071288287573e+01
RINT1979 nd1979 nd2630 1.071288287573e+01
RINT1980 nd1980 nd2631 1.071288287573e+01
RINT1981 nd1981 nd2632 1.071288287573e+01
RINT1982 nd1982 nd2633 1.071288287573e+01
RINT1983 nd1983 nd2634 1.071288287573e+01
RINT1984 nd1984 nd2635 1.722097716126e+01
RINT1985 nd1985 nd2636 1.487039843942e+01
RINT1986 nd1986 nd2637 1.487039843942e+01
RINT1987 nd1987 nd2638 8.627601608838e+02
RINT1988 nd1988 nd2639 3.060580775545e+01
RINT1989 nd1989 nd2640 3.082228040171e+01
RINT1990 nd1990 nd2641 3.082228040171e+01
RINT1991 nd1991 nd2642 1.224329471512e+03
RINT1992 nd1992 nd2643 2.040549119187e+02
RINT1993 nd1993 nd2644 3.498084204321e+02
RINT1994 nd1994 nd2645 3.498084204321e+02
RINT1995 nd1995 nd2646 3.498084204321e+02
RINT1996 nd1996 nd2647 3.498084204321e+02
RINT1997 nd1997 nd2648 3.498084204321e+02
RINT1998 nd1998 nd2649 3.498084204321e+02
RINT1999 nd1999 nd2650 3.498084204321e+02
RINT2000 nd2000 nd2651 7.773520454047e+01
RINT2001 nd2001 nd2652 7.773520454047e+01
RINT2002 nd2002 nd2653 1.611548589557e+03
RINT2003 nd2003 nd2654 1.159115429604e+02
RINT2004 nd2004 nd2655 2.571091890176e+03
RINT2005 nd2005 nd2656 1.071288287573e+01
RINT2006 nd2006 nd2657 1.071288287573e+01
RINT2007 nd2007 nd2658 1.071288287573e+01
RINT2008 nd2008 nd2659 1.071288287573e+01
RINT2009 nd2009 nd2660 1.071288287573e+01
RINT2010 nd2010 nd2661 1.071288287573e+01
RINT2011 nd2011 nd2662 1.071288287573e+01
RINT2012 nd2012 nd2663 1.071288287573e+01
RINT2013 nd2013 nd2664 1.071288287573e+01
RINT2014 nd2014 nd2665 1.071288287573e+01
RINT2015 nd2015 nd2666 1.722097716126e+01
RINT2016 nd2016 nd2667 1.487039843942e+01
RINT2017 nd2017 nd2668 1.487039843942e+01
RINT2018 nd2018 nd2669 8.627601608838e+02
RINT2019 nd2019 nd2670 3.060580775545e+01
RINT2020 nd2020 nd2671 3.082228040171e+01
RINT2021 nd2021 nd2672 3.082228040171e+01
RINT2022 nd2022 nd2673 1.224329471512e+03
RINT2023 nd2023 nd2674 2.040549119187e+02
RINT2024 nd2024 nd2675 3.498084204321e+02
RINT2025 nd2025 nd2676 3.498084204321e+02
RINT2026 nd2026 nd2677 3.498084204321e+02
RINT2027 nd2027 nd2678 3.498084204321e+02
RINT2028 nd2028 nd2679 3.498084204321e+02
RINT2029 nd2029 nd2680 3.498084204321e+02
RINT2030 nd2030 nd2681 3.498084204321e+02
RINT2031 nd2031 nd2682 7.773520454047e+01
RINT2032 nd2032 nd2683 7.773520454047e+01
RINT2033 nd2033 nd2684 1.611548589557e+03
RINT2034 nd2034 nd2685 1.159115429604e+02
RINT2035 nd2035 nd2686 2.571091890176e+03
RINT2036 nd2036 nd2687 1.071288287573e+01
RINT2037 nd2037 nd2688 1.071288287573e+01
RINT2038 nd2038 nd2689 1.071288287573e+01
RINT2039 nd2039 nd2690 1.071288287573e+01
RINT2040 nd2040 nd2691 1.071288287573e+01
RINT2041 nd2041 nd2692 1.071288287573e+01
RINT2042 nd2042 nd2693 1.071288287573e+01
RINT2043 nd2043 nd2694 1.071288287573e+01
RINT2044 nd2044 nd2695 1.071288287573e+01
RINT2045 nd2045 nd2696 1.071288287573e+01
RINT2046 nd2046 nd2697 1.265942732753e+02
RINT2047 nd2047 nd2698 1.093147773279e+02
RINT2048 nd2048 nd2699 1.093147773279e+02
RINT2049 nd2049 nd2700 6.342293736017e+03
RINT2050 nd2050 nd2701 2.249883937783e+02
RINT2051 nd2051 nd2702 2.265797202797e+02
RINT2052 nd2052 nd2703 2.265797202797e+02
RINT2053 nd2053 nd2704 5.906414062500e+05
RINT2054 nd2054 nd2705 9.844023437500e+04
RINT2055 nd2055 nd2706 1.687546875000e+05
RINT2056 nd2056 nd2707 1.687546875000e+05
RINT2057 nd2057 nd2708 1.687546875000e+05
RINT2058 nd2058 nd2709 1.687546875000e+05
RINT2059 nd2059 nd2710 1.687546875000e+05
RINT2060 nd2060 nd2711 1.687546875000e+05
RINT2061 nd2061 nd2712 1.687546875000e+05
RINT2062 nd2062 nd2713 3.750104166667e+04
RINT2063 nd2063 nd2714 3.750104166667e+04
RINT2064 nd2064 nd2715 1.184676227326e+04
RINT2065 nd2065 nd2716 8.520850708924e+02
RINT2066 nd2066 nd2717 1.890052500000e+04
RINT2067 nd2067 nd2718 7.875218750000e+01
RINT2068 nd2068 nd2719 7.875218750000e+01
RINT2069 nd2069 nd2720 7.875218750000e+01
RINT2070 nd2070 nd2721 7.875218750000e+01
RINT2071 nd2071 nd2722 7.875218750000e+01
RINT2072 nd2072 nd2723 7.875218750000e+01
RINT2073 nd2073 nd2724 7.875218750000e+01
RINT2074 nd2074 nd2725 7.875218750000e+01
RINT2075 nd2075 nd2726 7.875218750000e+01
RINT2076 nd2076 nd2727 7.875218750000e+01
RINT2077 nd2077 nd2728 1.322170110122e+01
RINT2078 nd2078 nd2729 1.141700390059e+01
RINT2079 nd2079 nd2730 1.141700390059e+01
RINT2080 nd2080 nd2731 6.623989372047e+02
RINT2081 nd2081 nd2732 2.349813476405e+01
RINT2082 nd2082 nd2733 2.366433535758e+01
RINT2083 nd2083 nd2734 2.366433535758e+01
RINT2084 nd2084 nd2735 1.239106136042e+03
RINT2085 nd2085 nd2736 1.373695180523e+02
RINT2086 nd2086 nd2737 2.711285174478e+02
RINT2087 nd2087 nd2738 2.711285174478e+02
RINT2088 nd2088 nd2739 2.711285174478e+02
RINT2089 nd2089 nd2740 2.711285174478e+02
RINT2090 nd2090 nd2741 2.711285174478e+02
RINT2091 nd2091 nd2742 2.711285174478e+02
RINT2092 nd2092 nd2743 2.711285174478e+02
RINT2093 nd2093 nd2744 5.233124497231e+01
RINT2094 nd2094 nd2745 5.390580832121e+01
RINT2095 nd2095 nd2746 1.237294118776e+03
RINT2096 nd2096 nd2747 8.899307866519e+01
RINT2097 nd2097 nd2748 1.973999974412e+03
RINT2098 nd2098 nd2749 8.224999893383e+00
RINT2099 nd2099 nd2750 8.224999893383e+00
RINT2100 nd2100 nd2751 8.224999893383e+00
RINT2101 nd2101 nd2752 8.224999893383e+00
RINT2102 nd2102 nd2753 8.224999893383e+00
RINT2103 nd2103 nd2754 8.224999893383e+00
RINT2104 nd2104 nd2755 8.224999893383e+00
RINT2105 nd2105 nd2756 8.224999893383e+00
RINT2106 nd2106 nd2757 8.224999893383e+00
RINT2107 nd2107 nd2758 8.224999893383e+00
RINT2108 nd2108 nd2759 1.322170110122e+01
RINT2109 nd2109 nd2760 1.141700390059e+01
RINT2110 nd2110 nd2761 1.141700390059e+01
RINT2111 nd2111 nd2762 6.623989372047e+02
RINT2112 nd2112 nd2763 2.349813476405e+01
RINT2113 nd2113 nd2764 2.366433535758e+01
RINT2114 nd2114 nd2765 2.366433535758e+01
RINT2115 nd2115 nd2766 1.239106136042e+03
RINT2116 nd2116 nd2767 1.373695180523e+02
RINT2117 nd2117 nd2768 2.711285174478e+02
RINT2118 nd2118 nd2769 2.711285174478e+02
RINT2119 nd2119 nd2770 2.711285174478e+02
RINT2120 nd2120 nd2771 2.711285174478e+02
RINT2121 nd2121 nd2772 2.711285174478e+02
RINT2122 nd2122 nd2773 2.711285174478e+02
RINT2123 nd2123 nd2774 2.711285174478e+02
RINT2124 nd2124 nd2775 5.233124497231e+01
RINT2125 nd2125 nd2776 5.390580832121e+01
RINT2126 nd2126 nd2777 1.237294118776e+03
RINT2127 nd2127 nd2778 8.899307866519e+01
RINT2128 nd2128 nd2779 1.973999974412e+03
RINT2129 nd2129 nd2780 8.224999893383e+00
RINT2130 nd2130 nd2781 8.224999893383e+00
RINT2131 nd2131 nd2782 8.224999893383e+00
RINT2132 nd2132 nd2783 8.224999893383e+00
RINT2133 nd2133 nd2784 8.224999893383e+00
RINT2134 nd2134 nd2785 8.224999893383e+00
RINT2135 nd2135 nd2786 8.224999893383e+00
RINT2136 nd2136 nd2787 8.224999893383e+00
RINT2137 nd2137 nd2788 8.224999893383e+00
RINT2138 nd2138 nd2789 8.224999893383e+00
RINT2139 nd2139 nd2790 1.322170110122e+01
RINT2140 nd2140 nd2791 1.141700390059e+01
RINT2141 nd2141 nd2792 1.141700390059e+01
RINT2142 nd2142 nd2793 6.623989372047e+02
RINT2143 nd2143 nd2794 2.349813476405e+01
RINT2144 nd2144 nd2795 2.366433535758e+01
RINT2145 nd2145 nd2796 2.366433535758e+01
RINT2146 nd2146 nd2797 1.239106136042e+03
RINT2147 nd2147 nd2798 1.373695180523e+02
RINT2148 nd2148 nd2799 2.711285174478e+02
RINT2149 nd2149 nd2800 2.711285174478e+02
RINT2150 nd2150 nd2801 2.711285174478e+02
RINT2151 nd2151 nd2802 2.711285174478e+02
RINT2152 nd2152 nd2803 2.711285174478e+02
RINT2153 nd2153 nd2804 2.711285174478e+02
RINT2154 nd2154 nd2805 2.711285174478e+02
RINT2155 nd2155 nd2806 5.233124497231e+01
RINT2156 nd2156 nd2807 5.390580832121e+01
RINT2157 nd2157 nd2808 1.237294118776e+03
RINT2158 nd2158 nd2809 8.899307866519e+01
RINT2159 nd2159 nd2810 1.973999974412e+03
RINT2160 nd2160 nd2811 8.224999893383e+00
RINT2161 nd2161 nd2812 8.224999893383e+00
RINT2162 nd2162 nd2813 8.224999893383e+00
RINT2163 nd2163 nd2814 8.224999893383e+00
RINT2164 nd2164 nd2815 8.224999893383e+00
RINT2165 nd2165 nd2816 8.224999893383e+00
RINT2166 nd2166 nd2817 8.224999893383e+00
RINT2167 nd2167 nd2818 8.224999893383e+00
RINT2168 nd2168 nd2819 8.224999893383e+00
RINT2169 nd2169 nd2820 8.224999893383e+00
RINT2170 nd2170 nd2821 1.322170110122e+01
RINT2171 nd2171 nd2822 1.141700390059e+01
RINT2172 nd2172 nd2823 1.141700390059e+01
RINT2173 nd2173 nd2824 6.623989372047e+02
RINT2174 nd2174 nd2825 2.349813476405e+01
RINT2175 nd2175 nd2826 2.366433535758e+01
RINT2176 nd2176 nd2827 2.366433535758e+01
RINT2177 nd2177 nd2828 1.239106136042e+03
RINT2178 nd2178 nd2829 1.373695180523e+02
RINT2179 nd2179 nd2830 2.711285174478e+02
RINT2180 nd2180 nd2831 2.711285174478e+02
RINT2181 nd2181 nd2832 2.711285174478e+02
RINT2182 nd2182 nd2833 2.711285174478e+02
RINT2183 nd2183 nd2834 2.711285174478e+02
RINT2184 nd2184 nd2835 2.711285174478e+02
RINT2185 nd2185 nd2836 2.711285174478e+02
RINT2186 nd2186 nd2837 5.233124497231e+01
RINT2187 nd2187 nd2838 5.390580832121e+01
RINT2188 nd2188 nd2839 1.237294118776e+03
RINT2189 nd2189 nd2840 8.899307866519e+01
RINT2190 nd2190 nd2841 1.973999974412e+03
RINT2191 nd2191 nd2842 8.224999893383e+00
RINT2192 nd2192 nd2843 8.224999893383e+00
RINT2193 nd2193 nd2844 8.224999893383e+00
RINT2194 nd2194 nd2845 8.224999893383e+00
RINT2195 nd2195 nd2846 8.224999893383e+00
RINT2196 nd2196 nd2847 8.224999893383e+00
RINT2197 nd2197 nd2848 8.224999893383e+00
RINT2198 nd2198 nd2849 8.224999893383e+00
RINT2199 nd2199 nd2850 8.224999893383e+00
RINT2200 nd2200 nd2851 8.224999893383e+00
RINT2201 nd2201 nd2852 1.322170110122e+01
RINT2202 nd2202 nd2853 1.141700390059e+01
RINT2203 nd2203 nd2854 1.141700390059e+01
RINT2204 nd2204 nd2855 6.623989372047e+02
RINT2205 nd2205 nd2856 2.349813476405e+01
RINT2206 nd2206 nd2857 2.366433535758e+01
RINT2207 nd2207 nd2858 2.366433535758e+01
RINT2208 nd2208 nd2859 1.239106136042e+03
RINT2209 nd2209 nd2860 1.373695180523e+02
RINT2210 nd2210 nd2861 2.711285174478e+02
RINT2211 nd2211 nd2862 2.711285174478e+02
RINT2212 nd2212 nd2863 2.711285174478e+02
RINT2213 nd2213 nd2864 2.711285174478e+02
RINT2214 nd2214 nd2865 2.711285174478e+02
RINT2215 nd2215 nd2866 2.711285174478e+02
RINT2216 nd2216 nd2867 2.711285174478e+02
RINT2217 nd2217 nd2868 5.233124497231e+01
RINT2218 nd2218 nd2869 5.390580832121e+01
RINT2219 nd2219 nd2870 1.237294118776e+03
RINT2220 nd2220 nd2871 8.899307866519e+01
RINT2221 nd2221 nd2872 1.973999974412e+03
RINT2222 nd2222 nd2873 8.224999893383e+00
RINT2223 nd2223 nd2874 8.224999893383e+00
RINT2224 nd2224 nd2875 8.224999893383e+00
RINT2225 nd2225 nd2876 8.224999893383e+00
RINT2226 nd2226 nd2877 8.224999893383e+00
RINT2227 nd2227 nd2878 8.224999893383e+00
RINT2228 nd2228 nd2879 8.224999893383e+00
RINT2229 nd2229 nd2880 8.224999893383e+00
RINT2230 nd2230 nd2881 8.224999893383e+00
RINT2231 nd2231 nd2882 8.224999893383e+00
RINT2232 nd2232 nd2883 1.322170110122e+01
RINT2233 nd2233 nd2884 1.141700390059e+01
RINT2234 nd2234 nd2885 1.141700390059e+01
RINT2235 nd2235 nd2886 6.623989372047e+02
RINT2236 nd2236 nd2887 2.349813476405e+01
RINT2237 nd2237 nd2888 2.366433535758e+01
RINT2238 nd2238 nd2889 2.366433535758e+01
RINT2239 nd2239 nd2890 1.239106136042e+03
RINT2240 nd2240 nd2891 1.373695180523e+02
RINT2241 nd2241 nd2892 2.711285174478e+02
RINT2242 nd2242 nd2893 2.711285174478e+02
RINT2243 nd2243 nd2894 2.711285174478e+02
RINT2244 nd2244 nd2895 2.711285174478e+02
RINT2245 nd2245 nd2896 2.711285174478e+02
RINT2246 nd2246 nd2897 2.711285174478e+02
RINT2247 nd2247 nd2898 2.711285174478e+02
RINT2248 nd2248 nd2899 5.233124497231e+01
RINT2249 nd2249 nd2900 5.390580832121e+01
RINT2250 nd2250 nd2901 1.237294118776e+03
RINT2251 nd2251 nd2902 8.899307866519e+01
RINT2252 nd2252 nd2903 1.973999974412e+03
RINT2253 nd2253 nd2904 8.224999893383e+00
RINT2254 nd2254 nd2905 8.224999893383e+00
RINT2255 nd2255 nd2906 8.224999893383e+00
RINT2256 nd2256 nd2907 8.224999893383e+00
RINT2257 nd2257 nd2908 8.224999893383e+00
RINT2258 nd2258 nd2909 8.224999893383e+00
RINT2259 nd2259 nd2910 8.224999893383e+00
RINT2260 nd2260 nd2911 8.224999893383e+00
RINT2261 nd2261 nd2912 8.224999893383e+00
RINT2262 nd2262 nd2913 8.224999893383e+00
RINT2263 nd2263 nd2914 1.265942732753e+02
RINT2264 nd2264 nd2915 1.093147773279e+02
RINT2265 nd2265 nd2916 1.093147773279e+02
RINT2266 nd2266 nd2917 6.342293736017e+03
RINT2267 nd2267 nd2918 2.249883937783e+02
RINT2268 nd2268 nd2919 2.265797202797e+02
RINT2269 nd2269 nd2920 2.265797202797e+02
RINT2270 nd2270 nd2921 5.906414062500e+05
RINT2271 nd2271 nd2922 9.844023437500e+04
RINT2272 nd2272 nd2923 1.687546875000e+05
RINT2273 nd2273 nd2924 1.687546875000e+05
RINT2274 nd2274 nd2925 1.687546875000e+05
RINT2275 nd2275 nd2926 1.687546875000e+05
RINT2276 nd2276 nd2927 1.687546875000e+05
RINT2277 nd2277 nd2928 1.687546875000e+05
RINT2278 nd2278 nd2929 1.687546875000e+05
RINT2279 nd2279 nd2930 3.750104166667e+04
RINT2280 nd2280 nd2931 3.750104166667e+04
RINT2281 nd2281 nd2932 1.184676227326e+04
RINT2282 nd2282 nd2933 8.520850708924e+02
RINT2283 nd2283 nd2934 1.890052500000e+04
RINT2284 nd2284 nd2935 7.875218750000e+01
RINT2285 nd2285 nd2936 7.875218750000e+01
RINT2286 nd2286 nd2937 7.875218750000e+01
RINT2287 nd2287 nd2938 7.875218750000e+01
RINT2288 nd2288 nd2939 7.875218750000e+01
RINT2289 nd2289 nd2940 7.875218750000e+01
RINT2290 nd2290 nd2941 7.875218750000e+01
RINT2291 nd2291 nd2942 7.875218750000e+01
RINT2292 nd2292 nd2943 7.875218750000e+01
RINT2293 nd2293 nd2944 7.875218750000e+01
RINT2294 nd2294 nd2945 1.322170110122e+01
RINT2295 nd2295 nd2946 1.141700390059e+01
RINT2296 nd2296 nd2947 1.141700390059e+01
RINT2297 nd2297 nd2948 6.623989372047e+02
RINT2298 nd2298 nd2949 2.349813476405e+01
RINT2299 nd2299 nd2950 2.366433535758e+01
RINT2300 nd2300 nd2951 2.366433535758e+01
RINT2301 nd2301 nd2952 1.239106136042e+03
RINT2302 nd2302 nd2953 1.373695180523e+02
RINT2303 nd2303 nd2954 2.711285174478e+02
RINT2304 nd2304 nd2955 2.711285174478e+02
RINT2305 nd2305 nd2956 2.711285174478e+02
RINT2306 nd2306 nd2957 2.711285174478e+02
RINT2307 nd2307 nd2958 2.711285174478e+02
RINT2308 nd2308 nd2959 2.711285174478e+02
RINT2309 nd2309 nd2960 2.711285174478e+02
RINT2310 nd2310 nd2961 5.233124497231e+01
RINT2311 nd2311 nd2962 5.390580832121e+01
RINT2312 nd2312 nd2963 1.237294118776e+03
RINT2313 nd2313 nd2964 8.899307866519e+01
RINT2314 nd2314 nd2965 1.973999974412e+03
RINT2315 nd2315 nd2966 8.224999893383e+00
RINT2316 nd2316 nd2967 8.224999893383e+00
RINT2317 nd2317 nd2968 8.224999893383e+00
RINT2318 nd2318 nd2969 8.224999893383e+00
RINT2319 nd2319 nd2970 8.224999893383e+00
RINT2320 nd2320 nd2971 8.224999893383e+00
RINT2321 nd2321 nd2972 8.224999893383e+00
RINT2322 nd2322 nd2973 8.224999893383e+00
RINT2323 nd2323 nd2974 8.224999893383e+00
RINT2324 nd2324 nd2975 8.224999893383e+00
RINT2325 nd2325 nd2976 1.322170110122e+01
RINT2326 nd2326 nd2977 1.141700390059e+01
RINT2327 nd2327 nd2978 1.141700390059e+01
RINT2328 nd2328 nd2979 6.623989372047e+02
RINT2329 nd2329 nd2980 2.349813476405e+01
RINT2330 nd2330 nd2981 2.366433535758e+01
RINT2331 nd2331 nd2982 2.366433535758e+01
RINT2332 nd2332 nd2983 1.239106136042e+03
RINT2333 nd2333 nd2984 1.373695180523e+02
RINT2334 nd2334 nd2985 2.711285174478e+02
RINT2335 nd2335 nd2986 2.711285174478e+02
RINT2336 nd2336 nd2987 2.711285174478e+02
RINT2337 nd2337 nd2988 2.711285174478e+02
RINT2338 nd2338 nd2989 2.711285174478e+02
RINT2339 nd2339 nd2990 2.711285174478e+02
RINT2340 nd2340 nd2991 2.711285174478e+02
RINT2341 nd2341 nd2992 5.233124497231e+01
RINT2342 nd2342 nd2993 5.390580832121e+01
RINT2343 nd2343 nd2994 1.237294118776e+03
RINT2344 nd2344 nd2995 8.899307866519e+01
RINT2345 nd2345 nd2996 1.973999974412e+03
RINT2346 nd2346 nd2997 8.224999893383e+00
RINT2347 nd2347 nd2998 8.224999893383e+00
RINT2348 nd2348 nd2999 8.224999893383e+00
RINT2349 nd2349 nd3000 8.224999893383e+00
RINT2350 nd2350 nd3001 8.224999893383e+00
RINT2351 nd2351 nd3002 8.224999893383e+00
RINT2352 nd2352 nd3003 8.224999893383e+00
RINT2353 nd2353 nd3004 8.224999893383e+00
RINT2354 nd2354 nd3005 8.224999893383e+00
RINT2355 nd2355 nd3006 8.224999893383e+00
RINT2356 nd2356 nd3007 1.322170110122e+01
RINT2357 nd2357 nd3008 1.141700390059e+01
RINT2358 nd2358 nd3009 1.141700390059e+01
RINT2359 nd2359 nd3010 6.623989372047e+02
RINT2360 nd2360 nd3011 2.349813476405e+01
RINT2361 nd2361 nd3012 2.366433535758e+01
RINT2362 nd2362 nd3013 2.366433535758e+01
RINT2363 nd2363 nd3014 1.239106136042e+03
RINT2364 nd2364 nd3015 1.373695180523e+02
RINT2365 nd2365 nd3016 2.711285174478e+02
RINT2366 nd2366 nd3017 2.711285174478e+02
RINT2367 nd2367 nd3018 2.711285174478e+02
RINT2368 nd2368 nd3019 2.711285174478e+02
RINT2369 nd2369 nd3020 2.711285174478e+02
RINT2370 nd2370 nd3021 2.711285174478e+02
RINT2371 nd2371 nd3022 2.711285174478e+02
RINT2372 nd2372 nd3023 5.233124497231e+01
RINT2373 nd2373 nd3024 5.390580832121e+01
RINT2374 nd2374 nd3025 1.237294118776e+03
RINT2375 nd2375 nd3026 8.899307866519e+01
RINT2376 nd2376 nd3027 1.973999974412e+03
RINT2377 nd2377 nd3028 8.224999893383e+00
RINT2378 nd2378 nd3029 8.224999893383e+00
RINT2379 nd2379 nd3030 8.224999893383e+00
RINT2380 nd2380 nd3031 8.224999893383e+00
RINT2381 nd2381 nd3032 8.224999893383e+00
RINT2382 nd2382 nd3033 8.224999893383e+00
RINT2383 nd2383 nd3034 8.224999893383e+00
RINT2384 nd2384 nd3035 8.224999893383e+00
RINT2385 nd2385 nd3036 8.224999893383e+00
RINT2386 nd2386 nd3037 8.224999893383e+00
RINT2387 nd2387 nd3038 1.322170110122e+01
RINT2388 nd2388 nd3039 1.141700390059e+01
RINT2389 nd2389 nd3040 1.141700390059e+01
RINT2390 nd2390 nd3041 6.623989372047e+02
RINT2391 nd2391 nd3042 2.349813476405e+01
RINT2392 nd2392 nd3043 2.366433535758e+01
RINT2393 nd2393 nd3044 2.366433535758e+01
RINT2394 nd2394 nd3045 1.239106136042e+03
RINT2395 nd2395 nd3046 1.373695180523e+02
RINT2396 nd2396 nd3047 2.711285174478e+02
RINT2397 nd2397 nd3048 2.711285174478e+02
RINT2398 nd2398 nd3049 2.711285174478e+02
RINT2399 nd2399 nd3050 2.711285174478e+02
RINT2400 nd2400 nd3051 2.711285174478e+02
RINT2401 nd2401 nd3052 2.711285174478e+02
RINT2402 nd2402 nd3053 2.711285174478e+02
RINT2403 nd2403 nd3054 5.233124497231e+01
RINT2404 nd2404 nd3055 5.390580832121e+01
RINT2405 nd2405 nd3056 1.237294118776e+03
RINT2406 nd2406 nd3057 8.899307866519e+01
RINT2407 nd2407 nd3058 1.973999974412e+03
RINT2408 nd2408 nd3059 8.224999893383e+00
RINT2409 nd2409 nd3060 8.224999893383e+00
RINT2410 nd2410 nd3061 8.224999893383e+00
RINT2411 nd2411 nd3062 8.224999893383e+00
RINT2412 nd2412 nd3063 8.224999893383e+00
RINT2413 nd2413 nd3064 8.224999893383e+00
RINT2414 nd2414 nd3065 8.224999893383e+00
RINT2415 nd2415 nd3066 8.224999893383e+00
RINT2416 nd2416 nd3067 8.224999893383e+00
RINT2417 nd2417 nd3068 8.224999893383e+00
RINT2418 nd2418 nd3069 1.322170110122e+01
RINT2419 nd2419 nd3070 1.141700390059e+01
RINT2420 nd2420 nd3071 1.141700390059e+01
RINT2421 nd2421 nd3072 6.623989372047e+02
RINT2422 nd2422 nd3073 2.349813476405e+01
RINT2423 nd2423 nd3074 2.366433535758e+01
RINT2424 nd2424 nd3075 2.366433535758e+01
RINT2425 nd2425 nd3076 1.239106136042e+03
RINT2426 nd2426 nd3077 1.373695180523e+02
RINT2427 nd2427 nd3078 2.711285174478e+02
RINT2428 nd2428 nd3079 2.711285174478e+02
RINT2429 nd2429 nd3080 2.711285174478e+02
RINT2430 nd2430 nd3081 2.711285174478e+02
RINT2431 nd2431 nd3082 2.711285174478e+02
RINT2432 nd2432 nd3083 2.711285174478e+02
RINT2433 nd2433 nd3084 2.711285174478e+02
RINT2434 nd2434 nd3085 5.233124497231e+01
RINT2435 nd2435 nd3086 5.390580832121e+01
RINT2436 nd2436 nd3087 1.237294118776e+03
RINT2437 nd2437 nd3088 8.899307866519e+01
RINT2438 nd2438 nd3089 1.973999974412e+03
RINT2439 nd2439 nd3090 8.224999893383e+00
RINT2440 nd2440 nd3091 8.224999893383e+00
RINT2441 nd2441 nd3092 8.224999893383e+00
RINT2442 nd2442 nd3093 8.224999893383e+00
RINT2443 nd2443 nd3094 8.224999893383e+00
RINT2444 nd2444 nd3095 8.224999893383e+00
RINT2445 nd2445 nd3096 8.224999893383e+00
RINT2446 nd2446 nd3097 8.224999893383e+00
RINT2447 nd2447 nd3098 8.224999893383e+00
RINT2448 nd2448 nd3099 8.224999893383e+00
RINT2449 nd2449 nd3100 1.322170110122e+01
RINT2450 nd2450 nd3101 1.141700390059e+01
RINT2451 nd2451 nd3102 1.141700390059e+01
RINT2452 nd2452 nd3103 6.623989372047e+02
RINT2453 nd2453 nd3104 2.349813476405e+01
RINT2454 nd2454 nd3105 2.366433535758e+01
RINT2455 nd2455 nd3106 2.366433535758e+01
RINT2456 nd2456 nd3107 1.239106136042e+03
RINT2457 nd2457 nd3108 1.373695180523e+02
RINT2458 nd2458 nd3109 2.711285174478e+02
RINT2459 nd2459 nd3110 2.711285174478e+02
RINT2460 nd2460 nd3111 2.711285174478e+02
RINT2461 nd2461 nd3112 2.711285174478e+02
RINT2462 nd2462 nd3113 2.711285174478e+02
RINT2463 nd2463 nd3114 2.711285174478e+02
RINT2464 nd2464 nd3115 2.711285174478e+02
RINT2465 nd2465 nd3116 5.233124497231e+01
RINT2466 nd2466 nd3117 5.390580832121e+01
RINT2467 nd2467 nd3118 1.237294118776e+03
RINT2468 nd2468 nd3119 8.899307866519e+01
RINT2469 nd2469 nd3120 1.973999974412e+03
RINT2470 nd2470 nd3121 8.224999893383e+00
RINT2471 nd2471 nd3122 8.224999893383e+00
RINT2472 nd2472 nd3123 8.224999893383e+00
RINT2473 nd2473 nd3124 8.224999893383e+00
RINT2474 nd2474 nd3125 8.224999893383e+00
RINT2475 nd2475 nd3126 8.224999893383e+00
RINT2476 nd2476 nd3127 8.224999893383e+00
RINT2477 nd2477 nd3128 8.224999893383e+00
RINT2478 nd2478 nd3129 8.224999893383e+00
RINT2479 nd2479 nd3130 8.224999893383e+00
RINT2480 nd2480 nd3131 1.265942732753e+02
RINT2481 nd2481 nd3132 1.093147773279e+02
RINT2482 nd2482 nd3133 1.093147773279e+02
RINT2483 nd2483 nd3134 6.342293736017e+03
RINT2484 nd2484 nd3135 2.249883937783e+02
RINT2485 nd2485 nd3136 2.265797202797e+02
RINT2486 nd2486 nd3137 2.265797202797e+02
RINT2487 nd2487 nd3138 5.906414062500e+05
RINT2488 nd2488 nd3139 9.844023437500e+04
RINT2489 nd2489 nd3140 1.687546875000e+05
RINT2490 nd2490 nd3141 1.687546875000e+05
RINT2491 nd2491 nd3142 1.687546875000e+05
RINT2492 nd2492 nd3143 1.687546875000e+05
RINT2493 nd2493 nd3144 1.687546875000e+05
RINT2494 nd2494 nd3145 1.687546875000e+05
RINT2495 nd2495 nd3146 1.687546875000e+05
RINT2496 nd2496 nd3147 3.750104166667e+04
RINT2497 nd2497 nd3148 3.750104166667e+04
RINT2498 nd2498 nd3149 1.184676227326e+04
RINT2499 nd2499 nd3150 8.520850708924e+02
RINT2500 nd2500 nd3151 1.890052500000e+04
RINT2501 nd2501 nd3152 7.875218750000e+01
RINT2502 nd2502 nd3153 7.875218750000e+01
RINT2503 nd2503 nd3154 7.875218750000e+01
RINT2504 nd2504 nd3155 7.875218750000e+01
RINT2505 nd2505 nd3156 7.875218750000e+01
RINT2506 nd2506 nd3157 7.875218750000e+01
RINT2507 nd2507 nd3158 7.875218750000e+01
RINT2508 nd2508 nd3159 7.875218750000e+01
RINT2509 nd2509 nd3160 7.875218750000e+01
RINT2510 nd2510 nd3161 7.875218750000e+01
RINT2511 nd2511 nd3162 1.722097716126e+01
RINT2512 nd2512 nd3163 1.487039843942e+01
RINT2513 nd2513 nd3164 1.487039843942e+01
RINT2514 nd2514 nd3165 8.627601608838e+02
RINT2515 nd2515 nd3166 3.060580775545e+01
RINT2516 nd2516 nd3167 3.082228040171e+01
RINT2517 nd2517 nd3168 3.082228040171e+01
RINT2518 nd2518 nd3169 1.224329471512e+03
RINT2519 nd2519 nd3170 2.040549119187e+02
RINT2520 nd2520 nd3171 3.498084204321e+02
RINT2521 nd2521 nd3172 3.498084204321e+02
RINT2522 nd2522 nd3173 3.498084204321e+02
RINT2523 nd2523 nd3174 3.498084204321e+02
RINT2524 nd2524 nd3175 3.498084204321e+02
RINT2525 nd2525 nd3176 3.498084204321e+02
RINT2526 nd2526 nd3177 3.498084204321e+02
RINT2527 nd2527 nd3178 7.773520454047e+01
RINT2528 nd2528 nd3179 7.773520454047e+01
RINT2529 nd2529 nd3180 1.611548589557e+03
RINT2530 nd2530 nd3181 1.159115429604e+02
RINT2531 nd2531 nd3182 2.571091890176e+03
RINT2532 nd2532 nd3183 1.071288287573e+01
RINT2533 nd2533 nd3184 1.071288287573e+01
RINT2534 nd2534 nd3185 1.071288287573e+01
RINT2535 nd2535 nd3186 1.071288287573e+01
RINT2536 nd2536 nd3187 1.071288287573e+01
RINT2537 nd2537 nd3188 1.071288287573e+01
RINT2538 nd2538 nd3189 1.071288287573e+01
RINT2539 nd2539 nd3190 1.071288287573e+01
RINT2540 nd2540 nd3191 1.071288287573e+01
RINT2541 nd2541 nd3192 1.071288287573e+01
RINT2542 nd2542 nd3193 1.722097716126e+01
RINT2543 nd2543 nd3194 1.487039843942e+01
RINT2544 nd2544 nd3195 1.487039843942e+01
RINT2545 nd2545 nd3196 8.627601608838e+02
RINT2546 nd2546 nd3197 3.060580775545e+01
RINT2547 nd2547 nd3198 3.082228040171e+01
RINT2548 nd2548 nd3199 3.082228040171e+01
RINT2549 nd2549 nd3200 1.224329471512e+03
RINT2550 nd2550 nd3201 2.040549119187e+02
RINT2551 nd2551 nd3202 3.498084204321e+02
RINT2552 nd2552 nd3203 3.498084204321e+02
RINT2553 nd2553 nd3204 3.498084204321e+02
RINT2554 nd2554 nd3205 3.498084204321e+02
RINT2555 nd2555 nd3206 3.498084204321e+02
RINT2556 nd2556 nd3207 3.498084204321e+02
RINT2557 nd2557 nd3208 3.498084204321e+02
RINT2558 nd2558 nd3209 7.773520454047e+01
RINT2559 nd2559 nd3210 7.773520454047e+01
RINT2560 nd2560 nd3211 1.611548589557e+03
RINT2561 nd2561 nd3212 1.159115429604e+02
RINT2562 nd2562 nd3213 2.571091890176e+03
RINT2563 nd2563 nd3214 1.071288287573e+01
RINT2564 nd2564 nd3215 1.071288287573e+01
RINT2565 nd2565 nd3216 1.071288287573e+01
RINT2566 nd2566 nd3217 1.071288287573e+01
RINT2567 nd2567 nd3218 1.071288287573e+01
RINT2568 nd2568 nd3219 1.071288287573e+01
RINT2569 nd2569 nd3220 1.071288287573e+01
RINT2570 nd2570 nd3221 1.071288287573e+01
RINT2571 nd2571 nd3222 1.071288287573e+01
RINT2572 nd2572 nd3223 1.071288287573e+01
RINT2573 nd2573 nd3224 1.722097716126e+01
RINT2574 nd2574 nd3225 1.487039843942e+01
RINT2575 nd2575 nd3226 1.487039843942e+01
RINT2576 nd2576 nd3227 8.627601608838e+02
RINT2577 nd2577 nd3228 3.060580775545e+01
RINT2578 nd2578 nd3229 3.082228040171e+01
RINT2579 nd2579 nd3230 3.082228040171e+01
RINT2580 nd2580 nd3231 1.224329471512e+03
RINT2581 nd2581 nd3232 2.040549119187e+02
RINT2582 nd2582 nd3233 3.498084204321e+02
RINT2583 nd2583 nd3234 3.498084204321e+02
RINT2584 nd2584 nd3235 3.498084204321e+02
RINT2585 nd2585 nd3236 3.498084204321e+02
RINT2586 nd2586 nd3237 3.498084204321e+02
RINT2587 nd2587 nd3238 3.498084204321e+02
RINT2588 nd2588 nd3239 3.498084204321e+02
RINT2589 nd2589 nd3240 7.773520454047e+01
RINT2590 nd2590 nd3241 7.773520454047e+01
RINT2591 nd2591 nd3242 1.611548589557e+03
RINT2592 nd2592 nd3243 1.159115429604e+02
RINT2593 nd2593 nd3244 2.571091890176e+03
RINT2594 nd2594 nd3245 1.071288287573e+01
RINT2595 nd2595 nd3246 1.071288287573e+01
RINT2596 nd2596 nd3247 1.071288287573e+01
RINT2597 nd2597 nd3248 1.071288287573e+01
RINT2598 nd2598 nd3249 1.071288287573e+01
RINT2599 nd2599 nd3250 1.071288287573e+01
RINT2600 nd2600 nd3251 1.071288287573e+01
RINT2601 nd2601 nd3252 1.071288287573e+01
RINT2602 nd2602 nd3253 1.071288287573e+01
RINT2603 nd2603 nd3254 1.071288287573e+01
RINT2604 nd2604 nd3255 1.722097716126e+01
RINT2605 nd2605 nd3256 1.487039843942e+01
RINT2606 nd2606 nd3257 1.487039843942e+01
RINT2607 nd2607 nd3258 8.627601608838e+02
RINT2608 nd2608 nd3259 3.060580775545e+01
RINT2609 nd2609 nd3260 3.082228040171e+01
RINT2610 nd2610 nd3261 3.082228040171e+01
RINT2611 nd2611 nd3262 1.224329471512e+03
RINT2612 nd2612 nd3263 2.040549119187e+02
RINT2613 nd2613 nd3264 3.498084204321e+02
RINT2614 nd2614 nd3265 3.498084204321e+02
RINT2615 nd2615 nd3266 3.498084204321e+02
RINT2616 nd2616 nd3267 3.498084204321e+02
RINT2617 nd2617 nd3268 3.498084204321e+02
RINT2618 nd2618 nd3269 3.498084204321e+02
RINT2619 nd2619 nd3270 3.498084204321e+02
RINT2620 nd2620 nd3271 7.773520454047e+01
RINT2621 nd2621 nd3272 7.773520454047e+01
RINT2622 nd2622 nd3273 1.611548589557e+03
RINT2623 nd2623 nd3274 1.159115429604e+02
RINT2624 nd2624 nd3275 2.571091890176e+03
RINT2625 nd2625 nd3276 1.071288287573e+01
RINT2626 nd2626 nd3277 1.071288287573e+01
RINT2627 nd2627 nd3278 1.071288287573e+01
RINT2628 nd2628 nd3279 1.071288287573e+01
RINT2629 nd2629 nd3280 1.071288287573e+01
RINT2630 nd2630 nd3281 1.071288287573e+01
RINT2631 nd2631 nd3282 1.071288287573e+01
RINT2632 nd2632 nd3283 1.071288287573e+01
RINT2633 nd2633 nd3284 1.071288287573e+01
RINT2634 nd2634 nd3285 1.071288287573e+01
RINT2635 nd2635 nd3286 1.722097716126e+01
RINT2636 nd2636 nd3287 1.487039843942e+01
RINT2637 nd2637 nd3288 1.487039843942e+01
RINT2638 nd2638 nd3289 8.627601608838e+02
RINT2639 nd2639 nd3290 3.060580775545e+01
RINT2640 nd2640 nd3291 3.082228040171e+01
RINT2641 nd2641 nd3292 3.082228040171e+01
RINT2642 nd2642 nd3293 1.224329471512e+03
RINT2643 nd2643 nd3294 2.040549119187e+02
RINT2644 nd2644 nd3295 3.498084204321e+02
RINT2645 nd2645 nd3296 3.498084204321e+02
RINT2646 nd2646 nd3297 3.498084204321e+02
RINT2647 nd2647 nd3298 3.498084204321e+02
RINT2648 nd2648 nd3299 3.498084204321e+02
RINT2649 nd2649 nd3300 3.498084204321e+02
RINT2650 nd2650 nd3301 3.498084204321e+02
RINT2651 nd2651 nd3302 7.773520454047e+01
RINT2652 nd2652 nd3303 7.773520454047e+01
RINT2653 nd2653 nd3304 1.611548589557e+03
RINT2654 nd2654 nd3305 1.159115429604e+02
RINT2655 nd2655 nd3306 2.571091890176e+03
RINT2656 nd2656 nd3307 1.071288287573e+01
RINT2657 nd2657 nd3308 1.071288287573e+01
RINT2658 nd2658 nd3309 1.071288287573e+01
RINT2659 nd2659 nd3310 1.071288287573e+01
RINT2660 nd2660 nd3311 1.071288287573e+01
RINT2661 nd2661 nd3312 1.071288287573e+01
RINT2662 nd2662 nd3313 1.071288287573e+01
RINT2663 nd2663 nd3314 1.071288287573e+01
RINT2664 nd2664 nd3315 1.071288287573e+01
RINT2665 nd2665 nd3316 1.071288287573e+01
RINT2666 nd2666 nd3317 1.722097716126e+01
RINT2667 nd2667 nd3318 1.487039843942e+01
RINT2668 nd2668 nd3319 1.487039843942e+01
RINT2669 nd2669 nd3320 8.627601608838e+02
RINT2670 nd2670 nd3321 3.060580775545e+01
RINT2671 nd2671 nd3322 3.082228040171e+01
RINT2672 nd2672 nd3323 3.082228040171e+01
RINT2673 nd2673 nd3324 1.224329471512e+03
RINT2674 nd2674 nd3325 2.040549119187e+02
RINT2675 nd2675 nd3326 3.498084204321e+02
RINT2676 nd2676 nd3327 3.498084204321e+02
RINT2677 nd2677 nd3328 3.498084204321e+02
RINT2678 nd2678 nd3329 3.498084204321e+02
RINT2679 nd2679 nd3330 3.498084204321e+02
RINT2680 nd2680 nd3331 3.498084204321e+02
RINT2681 nd2681 nd3332 3.498084204321e+02
RINT2682 nd2682 nd3333 7.773520454047e+01
RINT2683 nd2683 nd3334 7.773520454047e+01
RINT2684 nd2684 nd3335 1.611548589557e+03
RINT2685 nd2685 nd3336 1.159115429604e+02
RINT2686 nd2686 nd3337 2.571091890176e+03
RINT2687 nd2687 nd3338 1.071288287573e+01
RINT2688 nd2688 nd3339 1.071288287573e+01
RINT2689 nd2689 nd3340 1.071288287573e+01
RINT2690 nd2690 nd3341 1.071288287573e+01
RINT2691 nd2691 nd3342 1.071288287573e+01
RINT2692 nd2692 nd3343 1.071288287573e+01
RINT2693 nd2693 nd3344 1.071288287573e+01
RINT2694 nd2694 nd3345 1.071288287573e+01
RINT2695 nd2695 nd3346 1.071288287573e+01
RINT2696 nd2696 nd3347 1.071288287573e+01
RINT2697 nd2697 nd3348 1.265942732753e+02
RINT2698 nd2698 nd3349 1.093147773279e+02
RINT2699 nd2699 nd3350 1.093147773279e+02
RINT2700 nd2700 nd3351 6.342293736017e+03
RINT2701 nd2701 nd3352 2.249883937783e+02
RINT2702 nd2702 nd3353 2.265797202797e+02
RINT2703 nd2703 nd3354 2.265797202797e+02
RINT2704 nd2704 nd3355 5.906414062500e+05
RINT2705 nd2705 nd3356 9.844023437500e+04
RINT2706 nd2706 nd3357 1.687546875000e+05
RINT2707 nd2707 nd3358 1.687546875000e+05
RINT2708 nd2708 nd3359 1.687546875000e+05
RINT2709 nd2709 nd3360 1.687546875000e+05
RINT2710 nd2710 nd3361 1.687546875000e+05
RINT2711 nd2711 nd3362 1.687546875000e+05
RINT2712 nd2712 nd3363 1.687546875000e+05
RINT2713 nd2713 nd3364 3.750104166667e+04
RINT2714 nd2714 nd3365 3.750104166667e+04
RINT2715 nd2715 nd3366 1.184676227326e+04
RINT2716 nd2716 nd3367 8.520850708924e+02
RINT2717 nd2717 nd3368 1.890052500000e+04
RINT2718 nd2718 nd3369 7.875218750000e+01
RINT2719 nd2719 nd3370 7.875218750000e+01
RINT2720 nd2720 nd3371 7.875218750000e+01
RINT2721 nd2721 nd3372 7.875218750000e+01
RINT2722 nd2722 nd3373 7.875218750000e+01
RINT2723 nd2723 nd3374 7.875218750000e+01
RINT2724 nd2724 nd3375 7.875218750000e+01
RINT2725 nd2725 nd3376 7.875218750000e+01
RINT2726 nd2726 nd3377 7.875218750000e+01
RINT2727 nd2727 nd3378 7.875218750000e+01
RINT2728 nd2728 nd3379 1.322170110122e+01
RINT2729 nd2729 nd3380 1.141700390059e+01
RINT2730 nd2730 nd3381 1.141700390059e+01
RINT2731 nd2731 nd3382 6.623989372047e+02
RINT2732 nd2732 nd3383 2.349813476405e+01
RINT2733 nd2733 nd3384 2.366433535758e+01
RINT2734 nd2734 nd3385 2.366433535758e+01
RINT2735 nd2735 nd3386 1.239106136042e+03
RINT2736 nd2736 nd3387 1.373695180523e+02
RINT2737 nd2737 nd3388 2.711285174478e+02
RINT2738 nd2738 nd3389 2.711285174478e+02
RINT2739 nd2739 nd3390 2.711285174478e+02
RINT2740 nd2740 nd3391 2.711285174478e+02
RINT2741 nd2741 nd3392 2.711285174478e+02
RINT2742 nd2742 nd3393 2.711285174478e+02
RINT2743 nd2743 nd3394 2.711285174478e+02
RINT2744 nd2744 nd3395 5.233124497231e+01
RINT2745 nd2745 nd3396 5.390580832121e+01
RINT2746 nd2746 nd3397 1.237294118776e+03
RINT2747 nd2747 nd3398 8.899307866519e+01
RINT2748 nd2748 nd3399 1.973999974412e+03
RINT2749 nd2749 nd3400 8.224999893383e+00
RINT2750 nd2750 nd3401 8.224999893383e+00
RINT2751 nd2751 nd3402 8.224999893383e+00
RINT2752 nd2752 nd3403 8.224999893383e+00
RINT2753 nd2753 nd3404 8.224999893383e+00
RINT2754 nd2754 nd3405 8.224999893383e+00
RINT2755 nd2755 nd3406 8.224999893383e+00
RINT2756 nd2756 nd3407 8.224999893383e+00
RINT2757 nd2757 nd3408 8.224999893383e+00
RINT2758 nd2758 nd3409 8.224999893383e+00
RINT2759 nd2759 nd3410 1.322170110122e+01
RINT2760 nd2760 nd3411 1.141700390059e+01
RINT2761 nd2761 nd3412 1.141700390059e+01
RINT2762 nd2762 nd3413 6.623989372047e+02
RINT2763 nd2763 nd3414 2.349813476405e+01
RINT2764 nd2764 nd3415 2.366433535758e+01
RINT2765 nd2765 nd3416 2.366433535758e+01
RINT2766 nd2766 nd3417 1.239106136042e+03
RINT2767 nd2767 nd3418 1.373695180523e+02
RINT2768 nd2768 nd3419 2.711285174478e+02
RINT2769 nd2769 nd3420 2.711285174478e+02
RINT2770 nd2770 nd3421 2.711285174478e+02
RINT2771 nd2771 nd3422 2.711285174478e+02
RINT2772 nd2772 nd3423 2.711285174478e+02
RINT2773 nd2773 nd3424 2.711285174478e+02
RINT2774 nd2774 nd3425 2.711285174478e+02
RINT2775 nd2775 nd3426 5.233124497231e+01
RINT2776 nd2776 nd3427 5.390580832121e+01
RINT2777 nd2777 nd3428 1.237294118776e+03
RINT2778 nd2778 nd3429 8.899307866519e+01
RINT2779 nd2779 nd3430 1.973999974412e+03
RINT2780 nd2780 nd3431 8.224999893383e+00
RINT2781 nd2781 nd3432 8.224999893383e+00
RINT2782 nd2782 nd3433 8.224999893383e+00
RINT2783 nd2783 nd3434 8.224999893383e+00
RINT2784 nd2784 nd3435 8.224999893383e+00
RINT2785 nd2785 nd3436 8.224999893383e+00
RINT2786 nd2786 nd3437 8.224999893383e+00
RINT2787 nd2787 nd3438 8.224999893383e+00
RINT2788 nd2788 nd3439 8.224999893383e+00
RINT2789 nd2789 nd3440 8.224999893383e+00
RINT2790 nd2790 nd3441 1.322170110122e+01
RINT2791 nd2791 nd3442 1.141700390059e+01
RINT2792 nd2792 nd3443 1.141700390059e+01
RINT2793 nd2793 nd3444 6.623989372047e+02
RINT2794 nd2794 nd3445 2.349813476405e+01
RINT2795 nd2795 nd3446 2.366433535758e+01
RINT2796 nd2796 nd3447 2.366433535758e+01
RINT2797 nd2797 nd3448 1.239106136042e+03
RINT2798 nd2798 nd3449 1.373695180523e+02
RINT2799 nd2799 nd3450 2.711285174478e+02
RINT2800 nd2800 nd3451 2.711285174478e+02
RINT2801 nd2801 nd3452 2.711285174478e+02
RINT2802 nd2802 nd3453 2.711285174478e+02
RINT2803 nd2803 nd3454 2.711285174478e+02
RINT2804 nd2804 nd3455 2.711285174478e+02
RINT2805 nd2805 nd3456 2.711285174478e+02
RINT2806 nd2806 nd3457 5.233124497231e+01
RINT2807 nd2807 nd3458 5.390580832121e+01
RINT2808 nd2808 nd3459 1.237294118776e+03
RINT2809 nd2809 nd3460 8.899307866519e+01
RINT2810 nd2810 nd3461 1.973999974412e+03
RINT2811 nd2811 nd3462 8.224999893383e+00
RINT2812 nd2812 nd3463 8.224999893383e+00
RINT2813 nd2813 nd3464 8.224999893383e+00
RINT2814 nd2814 nd3465 8.224999893383e+00
RINT2815 nd2815 nd3466 8.224999893383e+00
RINT2816 nd2816 nd3467 8.224999893383e+00
RINT2817 nd2817 nd3468 8.224999893383e+00
RINT2818 nd2818 nd3469 8.224999893383e+00
RINT2819 nd2819 nd3470 8.224999893383e+00
RINT2820 nd2820 nd3471 8.224999893383e+00
RINT2821 nd2821 nd3472 1.322170110122e+01
RINT2822 nd2822 nd3473 1.141700390059e+01
RINT2823 nd2823 nd3474 1.141700390059e+01
RINT2824 nd2824 nd3475 6.623989372047e+02
RINT2825 nd2825 nd3476 2.349813476405e+01
RINT2826 nd2826 nd3477 2.366433535758e+01
RINT2827 nd2827 nd3478 2.366433535758e+01
RINT2828 nd2828 nd3479 1.239106136042e+03
RINT2829 nd2829 nd3480 1.373695180523e+02
RINT2830 nd2830 nd3481 2.711285174478e+02
RINT2831 nd2831 nd3482 2.711285174478e+02
RINT2832 nd2832 nd3483 2.711285174478e+02
RINT2833 nd2833 nd3484 2.711285174478e+02
RINT2834 nd2834 nd3485 2.711285174478e+02
RINT2835 nd2835 nd3486 2.711285174478e+02
RINT2836 nd2836 nd3487 2.711285174478e+02
RINT2837 nd2837 nd3488 5.233124497231e+01
RINT2838 nd2838 nd3489 5.390580832121e+01
RINT2839 nd2839 nd3490 1.237294118776e+03
RINT2840 nd2840 nd3491 8.899307866519e+01
RINT2841 nd2841 nd3492 1.973999974412e+03
RINT2842 nd2842 nd3493 8.224999893383e+00
RINT2843 nd2843 nd3494 8.224999893383e+00
RINT2844 nd2844 nd3495 8.224999893383e+00
RINT2845 nd2845 nd3496 8.224999893383e+00
RINT2846 nd2846 nd3497 8.224999893383e+00
RINT2847 nd2847 nd3498 8.224999893383e+00
RINT2848 nd2848 nd3499 8.224999893383e+00
RINT2849 nd2849 nd3500 8.224999893383e+00
RINT2850 nd2850 nd3501 8.224999893383e+00
RINT2851 nd2851 nd3502 8.224999893383e+00
RINT2852 nd2852 nd3503 1.322170110122e+01
RINT2853 nd2853 nd3504 1.141700390059e+01
RINT2854 nd2854 nd3505 1.141700390059e+01
RINT2855 nd2855 nd3506 6.623989372047e+02
RINT2856 nd2856 nd3507 2.349813476405e+01
RINT2857 nd2857 nd3508 2.366433535758e+01
RINT2858 nd2858 nd3509 2.366433535758e+01
RINT2859 nd2859 nd3510 1.239106136042e+03
RINT2860 nd2860 nd3511 1.373695180523e+02
RINT2861 nd2861 nd3512 2.711285174478e+02
RINT2862 nd2862 nd3513 2.711285174478e+02
RINT2863 nd2863 nd3514 2.711285174478e+02
RINT2864 nd2864 nd3515 2.711285174478e+02
RINT2865 nd2865 nd3516 2.711285174478e+02
RINT2866 nd2866 nd3517 2.711285174478e+02
RINT2867 nd2867 nd3518 2.711285174478e+02
RINT2868 nd2868 nd3519 5.233124497231e+01
RINT2869 nd2869 nd3520 5.390580832121e+01
RINT2870 nd2870 nd3521 1.237294118776e+03
RINT2871 nd2871 nd3522 8.899307866519e+01
RINT2872 nd2872 nd3523 1.973999974412e+03
RINT2873 nd2873 nd3524 8.224999893383e+00
RINT2874 nd2874 nd3525 8.224999893383e+00
RINT2875 nd2875 nd3526 8.224999893383e+00
RINT2876 nd2876 nd3527 8.224999893383e+00
RINT2877 nd2877 nd3528 8.224999893383e+00
RINT2878 nd2878 nd3529 8.224999893383e+00
RINT2879 nd2879 nd3530 8.224999893383e+00
RINT2880 nd2880 nd3531 8.224999893383e+00
RINT2881 nd2881 nd3532 8.224999893383e+00
RINT2882 nd2882 nd3533 8.224999893383e+00
RINT2883 nd2883 nd3534 1.322170110122e+01
RINT2884 nd2884 nd3535 1.141700390059e+01
RINT2885 nd2885 nd3536 1.141700390059e+01
RINT2886 nd2886 nd3537 6.623989372047e+02
RINT2887 nd2887 nd3538 2.349813476405e+01
RINT2888 nd2888 nd3539 2.366433535758e+01
RINT2889 nd2889 nd3540 2.366433535758e+01
RINT2890 nd2890 nd3541 1.239106136042e+03
RINT2891 nd2891 nd3542 1.373695180523e+02
RINT2892 nd2892 nd3543 2.711285174478e+02
RINT2893 nd2893 nd3544 2.711285174478e+02
RINT2894 nd2894 nd3545 2.711285174478e+02
RINT2895 nd2895 nd3546 2.711285174478e+02
RINT2896 nd2896 nd3547 2.711285174478e+02
RINT2897 nd2897 nd3548 2.711285174478e+02
RINT2898 nd2898 nd3549 2.711285174478e+02
RINT2899 nd2899 nd3550 5.233124497231e+01
RINT2900 nd2900 nd3551 5.390580832121e+01
RINT2901 nd2901 nd3552 1.237294118776e+03
RINT2902 nd2902 nd3553 8.899307866519e+01
RINT2903 nd2903 nd3554 1.973999974412e+03
RINT2904 nd2904 nd3555 8.224999893383e+00
RINT2905 nd2905 nd3556 8.224999893383e+00
RINT2906 nd2906 nd3557 8.224999893383e+00
RINT2907 nd2907 nd3558 8.224999893383e+00
RINT2908 nd2908 nd3559 8.224999893383e+00
RINT2909 nd2909 nd3560 8.224999893383e+00
RINT2910 nd2910 nd3561 8.224999893383e+00
RINT2911 nd2911 nd3562 8.224999893383e+00
RINT2912 nd2912 nd3563 8.224999893383e+00
RINT2913 nd2913 nd3564 8.224999893383e+00
RINT2914 nd2914 nd3565 1.265942732753e+02
RINT2915 nd2915 nd3566 1.093147773279e+02
RINT2916 nd2916 nd3567 1.093147773279e+02
RINT2917 nd2917 nd3568 6.342293736017e+03
RINT2918 nd2918 nd3569 2.249883937783e+02
RINT2919 nd2919 nd3570 2.265797202797e+02
RINT2920 nd2920 nd3571 2.265797202797e+02
RINT2921 nd2921 nd3572 5.906414062500e+05
RINT2922 nd2922 nd3573 9.844023437500e+04
RINT2923 nd2923 nd3574 1.687546875000e+05
RINT2924 nd2924 nd3575 1.687546875000e+05
RINT2925 nd2925 nd3576 1.687546875000e+05
RINT2926 nd2926 nd3577 1.687546875000e+05
RINT2927 nd2927 nd3578 1.687546875000e+05
RINT2928 nd2928 nd3579 1.687546875000e+05
RINT2929 nd2929 nd3580 1.687546875000e+05
RINT2930 nd2930 nd3581 3.750104166667e+04
RINT2931 nd2931 nd3582 3.750104166667e+04
RINT2932 nd2932 nd3583 1.184676227326e+04
RINT2933 nd2933 nd3584 8.520850708924e+02
RINT2934 nd2934 nd3585 1.890052500000e+04
RINT2935 nd2935 nd3586 7.875218750000e+01
RINT2936 nd2936 nd3587 7.875218750000e+01
RINT2937 nd2937 nd3588 7.875218750000e+01
RINT2938 nd2938 nd3589 7.875218750000e+01
RINT2939 nd2939 nd3590 7.875218750000e+01
RINT2940 nd2940 nd3591 7.875218750000e+01
RINT2941 nd2941 nd3592 7.875218750000e+01
RINT2942 nd2942 nd3593 7.875218750000e+01
RINT2943 nd2943 nd3594 7.875218750000e+01
RINT2944 nd2944 nd3595 7.875218750000e+01
RINT2945 nd2945 nd3596 1.322170110122e+01
RINT2946 nd2946 nd3597 1.141700390059e+01
RINT2947 nd2947 nd3598 1.141700390059e+01
RINT2948 nd2948 nd3599 6.623989372047e+02
RINT2949 nd2949 nd3600 2.349813476405e+01
RINT2950 nd2950 nd3601 2.366433535758e+01
RINT2951 nd2951 nd3602 2.366433535758e+01
RINT2952 nd2952 nd3603 1.239106136042e+03
RINT2953 nd2953 nd3604 1.373695180523e+02
RINT2954 nd2954 nd3605 2.711285174478e+02
RINT2955 nd2955 nd3606 2.711285174478e+02
RINT2956 nd2956 nd3607 2.711285174478e+02
RINT2957 nd2957 nd3608 2.711285174478e+02
RINT2958 nd2958 nd3609 2.711285174478e+02
RINT2959 nd2959 nd3610 2.711285174478e+02
RINT2960 nd2960 nd3611 2.711285174478e+02
RINT2961 nd2961 nd3612 5.233124497231e+01
RINT2962 nd2962 nd3613 5.390580832121e+01
RINT2963 nd2963 nd3614 1.237294118776e+03
RINT2964 nd2964 nd3615 8.899307866519e+01
RINT2965 nd2965 nd3616 1.973999974412e+03
RINT2966 nd2966 nd3617 8.224999893383e+00
RINT2967 nd2967 nd3618 8.224999893383e+00
RINT2968 nd2968 nd3619 8.224999893383e+00
RINT2969 nd2969 nd3620 8.224999893383e+00
RINT2970 nd2970 nd3621 8.224999893383e+00
RINT2971 nd2971 nd3622 8.224999893383e+00
RINT2972 nd2972 nd3623 8.224999893383e+00
RINT2973 nd2973 nd3624 8.224999893383e+00
RINT2974 nd2974 nd3625 8.224999893383e+00
RINT2975 nd2975 nd3626 8.224999893383e+00
RINT2976 nd2976 nd3627 1.322170110122e+01
RINT2977 nd2977 nd3628 1.141700390059e+01
RINT2978 nd2978 nd3629 1.141700390059e+01
RINT2979 nd2979 nd3630 6.623989372047e+02
RINT2980 nd2980 nd3631 2.349813476405e+01
RINT2981 nd2981 nd3632 2.366433535758e+01
RINT2982 nd2982 nd3633 2.366433535758e+01
RINT2983 nd2983 nd3634 1.239106136042e+03
RINT2984 nd2984 nd3635 1.373695180523e+02
RINT2985 nd2985 nd3636 2.711285174478e+02
RINT2986 nd2986 nd3637 2.711285174478e+02
RINT2987 nd2987 nd3638 2.711285174478e+02
RINT2988 nd2988 nd3639 2.711285174478e+02
RINT2989 nd2989 nd3640 2.711285174478e+02
RINT2990 nd2990 nd3641 2.711285174478e+02
RINT2991 nd2991 nd3642 2.711285174478e+02
RINT2992 nd2992 nd3643 5.233124497231e+01
RINT2993 nd2993 nd3644 5.390580832121e+01
RINT2994 nd2994 nd3645 1.237294118776e+03
RINT2995 nd2995 nd3646 8.899307866519e+01
RINT2996 nd2996 nd3647 1.973999974412e+03
RINT2997 nd2997 nd3648 8.224999893383e+00
RINT2998 nd2998 nd3649 8.224999893383e+00
RINT2999 nd2999 nd3650 8.224999893383e+00
RINT3000 nd3000 nd3651 8.224999893383e+00
RINT3001 nd3001 nd3652 8.224999893383e+00
RINT3002 nd3002 nd3653 8.224999893383e+00
RINT3003 nd3003 nd3654 8.224999893383e+00
RINT3004 nd3004 nd3655 8.224999893383e+00
RINT3005 nd3005 nd3656 8.224999893383e+00
RINT3006 nd3006 nd3657 8.224999893383e+00
RINT3007 nd3007 nd3658 1.322170110122e+01
RINT3008 nd3008 nd3659 1.141700390059e+01
RINT3009 nd3009 nd3660 1.141700390059e+01
RINT3010 nd3010 nd3661 6.623989372047e+02
RINT3011 nd3011 nd3662 2.349813476405e+01
RINT3012 nd3012 nd3663 2.366433535758e+01
RINT3013 nd3013 nd3664 2.366433535758e+01
RINT3014 nd3014 nd3665 1.239106136042e+03
RINT3015 nd3015 nd3666 1.373695180523e+02
RINT3016 nd3016 nd3667 2.711285174478e+02
RINT3017 nd3017 nd3668 2.711285174478e+02
RINT3018 nd3018 nd3669 2.711285174478e+02
RINT3019 nd3019 nd3670 2.711285174478e+02
RINT3020 nd3020 nd3671 2.711285174478e+02
RINT3021 nd3021 nd3672 2.711285174478e+02
RINT3022 nd3022 nd3673 2.711285174478e+02
RINT3023 nd3023 nd3674 5.233124497231e+01
RINT3024 nd3024 nd3675 5.390580832121e+01
RINT3025 nd3025 nd3676 1.237294118776e+03
RINT3026 nd3026 nd3677 8.899307866519e+01
RINT3027 nd3027 nd3678 1.973999974412e+03
RINT3028 nd3028 nd3679 8.224999893383e+00
RINT3029 nd3029 nd3680 8.224999893383e+00
RINT3030 nd3030 nd3681 8.224999893383e+00
RINT3031 nd3031 nd3682 8.224999893383e+00
RINT3032 nd3032 nd3683 8.224999893383e+00
RINT3033 nd3033 nd3684 8.224999893383e+00
RINT3034 nd3034 nd3685 8.224999893383e+00
RINT3035 nd3035 nd3686 8.224999893383e+00
RINT3036 nd3036 nd3687 8.224999893383e+00
RINT3037 nd3037 nd3688 8.224999893383e+00
RINT3038 nd3038 nd3689 1.322170110122e+01
RINT3039 nd3039 nd3690 1.141700390059e+01
RINT3040 nd3040 nd3691 1.141700390059e+01
RINT3041 nd3041 nd3692 6.623989372047e+02
RINT3042 nd3042 nd3693 2.349813476405e+01
RINT3043 nd3043 nd3694 2.366433535758e+01
RINT3044 nd3044 nd3695 2.366433535758e+01
RINT3045 nd3045 nd3696 1.239106136042e+03
RINT3046 nd3046 nd3697 1.373695180523e+02
RINT3047 nd3047 nd3698 2.711285174478e+02
RINT3048 nd3048 nd3699 2.711285174478e+02
RINT3049 nd3049 nd3700 2.711285174478e+02
RINT3050 nd3050 nd3701 2.711285174478e+02
RINT3051 nd3051 nd3702 2.711285174478e+02
RINT3052 nd3052 nd3703 2.711285174478e+02
RINT3053 nd3053 nd3704 2.711285174478e+02
RINT3054 nd3054 nd3705 5.233124497231e+01
RINT3055 nd3055 nd3706 5.390580832121e+01
RINT3056 nd3056 nd3707 1.237294118776e+03
RINT3057 nd3057 nd3708 8.899307866519e+01
RINT3058 nd3058 nd3709 1.973999974412e+03
RINT3059 nd3059 nd3710 8.224999893383e+00
RINT3060 nd3060 nd3711 8.224999893383e+00
RINT3061 nd3061 nd3712 8.224999893383e+00
RINT3062 nd3062 nd3713 8.224999893383e+00
RINT3063 nd3063 nd3714 8.224999893383e+00
RINT3064 nd3064 nd3715 8.224999893383e+00
RINT3065 nd3065 nd3716 8.224999893383e+00
RINT3066 nd3066 nd3717 8.224999893383e+00
RINT3067 nd3067 nd3718 8.224999893383e+00
RINT3068 nd3068 nd3719 8.224999893383e+00
RINT3069 nd3069 nd3720 1.322170110122e+01
RINT3070 nd3070 nd3721 1.141700390059e+01
RINT3071 nd3071 nd3722 1.141700390059e+01
RINT3072 nd3072 nd3723 6.623989372047e+02
RINT3073 nd3073 nd3724 2.349813476405e+01
RINT3074 nd3074 nd3725 2.366433535758e+01
RINT3075 nd3075 nd3726 2.366433535758e+01
RINT3076 nd3076 nd3727 1.239106136042e+03
RINT3077 nd3077 nd3728 1.373695180523e+02
RINT3078 nd3078 nd3729 2.711285174478e+02
RINT3079 nd3079 nd3730 2.711285174478e+02
RINT3080 nd3080 nd3731 2.711285174478e+02
RINT3081 nd3081 nd3732 2.711285174478e+02
RINT3082 nd3082 nd3733 2.711285174478e+02
RINT3083 nd3083 nd3734 2.711285174478e+02
RINT3084 nd3084 nd3735 2.711285174478e+02
RINT3085 nd3085 nd3736 5.233124497231e+01
RINT3086 nd3086 nd3737 5.390580832121e+01
RINT3087 nd3087 nd3738 1.237294118776e+03
RINT3088 nd3088 nd3739 8.899307866519e+01
RINT3089 nd3089 nd3740 1.973999974412e+03
RINT3090 nd3090 nd3741 8.224999893383e+00
RINT3091 nd3091 nd3742 8.224999893383e+00
RINT3092 nd3092 nd3743 8.224999893383e+00
RINT3093 nd3093 nd3744 8.224999893383e+00
RINT3094 nd3094 nd3745 8.224999893383e+00
RINT3095 nd3095 nd3746 8.224999893383e+00
RINT3096 nd3096 nd3747 8.224999893383e+00
RINT3097 nd3097 nd3748 8.224999893383e+00
RINT3098 nd3098 nd3749 8.224999893383e+00
RINT3099 nd3099 nd3750 8.224999893383e+00
RINT3100 nd3100 nd3751 1.322170110122e+01
RINT3101 nd3101 nd3752 1.141700390059e+01
RINT3102 nd3102 nd3753 1.141700390059e+01
RINT3103 nd3103 nd3754 6.623989372047e+02
RINT3104 nd3104 nd3755 2.349813476405e+01
RINT3105 nd3105 nd3756 2.366433535758e+01
RINT3106 nd3106 nd3757 2.366433535758e+01
RINT3107 nd3107 nd3758 1.239106136042e+03
RINT3108 nd3108 nd3759 1.373695180523e+02
RINT3109 nd3109 nd3760 2.711285174478e+02
RINT3110 nd3110 nd3761 2.711285174478e+02
RINT3111 nd3111 nd3762 2.711285174478e+02
RINT3112 nd3112 nd3763 2.711285174478e+02
RINT3113 nd3113 nd3764 2.711285174478e+02
RINT3114 nd3114 nd3765 2.711285174478e+02
RINT3115 nd3115 nd3766 2.711285174478e+02
RINT3116 nd3116 nd3767 5.233124497231e+01
RINT3117 nd3117 nd3768 5.390580832121e+01
RINT3118 nd3118 nd3769 1.237294118776e+03
RINT3119 nd3119 nd3770 8.899307866519e+01
RINT3120 nd3120 nd3771 1.973999974412e+03
RINT3121 nd3121 nd3772 8.224999893383e+00
RINT3122 nd3122 nd3773 8.224999893383e+00
RINT3123 nd3123 nd3774 8.224999893383e+00
RINT3124 nd3124 nd3775 8.224999893383e+00
RINT3125 nd3125 nd3776 8.224999893383e+00
RINT3126 nd3126 nd3777 8.224999893383e+00
RINT3127 nd3127 nd3778 8.224999893383e+00
RINT3128 nd3128 nd3779 8.224999893383e+00
RINT3129 nd3129 nd3780 8.224999893383e+00
RINT3130 nd3130 nd3781 8.224999893383e+00
RINT3131 nd3131 nd3782 1.265942732753e+02
RINT3132 nd3132 nd3783 1.093147773279e+02
RINT3133 nd3133 nd3784 1.093147773279e+02
RINT3134 nd3134 nd3785 6.342293736017e+03
RINT3135 nd3135 nd3786 2.249883937783e+02
RINT3136 nd3136 nd3787 2.265797202797e+02
RINT3137 nd3137 nd3788 2.265797202797e+02
RINT3138 nd3138 nd3789 5.906414062500e+05
RINT3139 nd3139 nd3790 9.844023437500e+04
RINT3140 nd3140 nd3791 1.687546875000e+05
RINT3141 nd3141 nd3792 1.687546875000e+05
RINT3142 nd3142 nd3793 1.687546875000e+05
RINT3143 nd3143 nd3794 1.687546875000e+05
RINT3144 nd3144 nd3795 1.687546875000e+05
RINT3145 nd3145 nd3796 1.687546875000e+05
RINT3146 nd3146 nd3797 1.687546875000e+05
RINT3147 nd3147 nd3798 3.750104166667e+04
RINT3148 nd3148 nd3799 3.750104166667e+04
RINT3149 nd3149 nd3800 1.184676227326e+04
RINT3150 nd3150 nd3801 8.520850708924e+02
RINT3151 nd3151 nd3802 1.890052500000e+04
RINT3152 nd3152 nd3803 7.875218750000e+01
RINT3153 nd3153 nd3804 7.875218750000e+01
RINT3154 nd3154 nd3805 7.875218750000e+01
RINT3155 nd3155 nd3806 7.875218750000e+01
RINT3156 nd3156 nd3807 7.875218750000e+01
RINT3157 nd3157 nd3808 7.875218750000e+01
RINT3158 nd3158 nd3809 7.875218750000e+01
RINT3159 nd3159 nd3810 7.875218750000e+01
RINT3160 nd3160 nd3811 7.875218750000e+01
RINT3161 nd3161 nd3812 7.875218750000e+01
RINT3162 nd3162 nd3813 1.722097716126e+01
RINT3163 nd3163 nd3814 1.487039843942e+01
RINT3164 nd3164 nd3815 1.487039843942e+01
RINT3165 nd3165 nd3816 8.627601608838e+02
RINT3166 nd3166 nd3817 3.060580775545e+01
RINT3167 nd3167 nd3818 3.082228040171e+01
RINT3168 nd3168 nd3819 3.082228040171e+01
RINT3169 nd3169 nd3820 1.224329471512e+03
RINT3170 nd3170 nd3821 2.040549119187e+02
RINT3171 nd3171 nd3822 3.498084204321e+02
RINT3172 nd3172 nd3823 3.498084204321e+02
RINT3173 nd3173 nd3824 3.498084204321e+02
RINT3174 nd3174 nd3825 3.498084204321e+02
RINT3175 nd3175 nd3826 3.498084204321e+02
RINT3176 nd3176 nd3827 3.498084204321e+02
RINT3177 nd3177 nd3828 3.498084204321e+02
RINT3178 nd3178 nd3829 7.773520454047e+01
RINT3179 nd3179 nd3830 7.773520454047e+01
RINT3180 nd3180 nd3831 1.611548589557e+03
RINT3181 nd3181 nd3832 1.159115429604e+02
RINT3182 nd3182 nd3833 2.571091890176e+03
RINT3183 nd3183 nd3834 1.071288287573e+01
RINT3184 nd3184 nd3835 1.071288287573e+01
RINT3185 nd3185 nd3836 1.071288287573e+01
RINT3186 nd3186 nd3837 1.071288287573e+01
RINT3187 nd3187 nd3838 1.071288287573e+01
RINT3188 nd3188 nd3839 1.071288287573e+01
RINT3189 nd3189 nd3840 1.071288287573e+01
RINT3190 nd3190 nd3841 1.071288287573e+01
RINT3191 nd3191 nd3842 1.071288287573e+01
RINT3192 nd3192 nd3843 1.071288287573e+01
RINT3193 nd3193 nd3844 1.722097716126e+01
RINT3194 nd3194 nd3845 1.487039843942e+01
RINT3195 nd3195 nd3846 1.487039843942e+01
RINT3196 nd3196 nd3847 8.627601608838e+02
RINT3197 nd3197 nd3848 3.060580775545e+01
RINT3198 nd3198 nd3849 3.082228040171e+01
RINT3199 nd3199 nd3850 3.082228040171e+01
RINT3200 nd3200 nd3851 1.224329471512e+03
RINT3201 nd3201 nd3852 2.040549119187e+02
RINT3202 nd3202 nd3853 3.498084204321e+02
RINT3203 nd3203 nd3854 3.498084204321e+02
RINT3204 nd3204 nd3855 3.498084204321e+02
RINT3205 nd3205 nd3856 3.498084204321e+02
RINT3206 nd3206 nd3857 3.498084204321e+02
RINT3207 nd3207 nd3858 3.498084204321e+02
RINT3208 nd3208 nd3859 3.498084204321e+02
RINT3209 nd3209 nd3860 7.773520454047e+01
RINT3210 nd3210 nd3861 7.773520454047e+01
RINT3211 nd3211 nd3862 1.611548589557e+03
RINT3212 nd3212 nd3863 1.159115429604e+02
RINT3213 nd3213 nd3864 2.571091890176e+03
RINT3214 nd3214 nd3865 1.071288287573e+01
RINT3215 nd3215 nd3866 1.071288287573e+01
RINT3216 nd3216 nd3867 1.071288287573e+01
RINT3217 nd3217 nd3868 1.071288287573e+01
RINT3218 nd3218 nd3869 1.071288287573e+01
RINT3219 nd3219 nd3870 1.071288287573e+01
RINT3220 nd3220 nd3871 1.071288287573e+01
RINT3221 nd3221 nd3872 1.071288287573e+01
RINT3222 nd3222 nd3873 1.071288287573e+01
RINT3223 nd3223 nd3874 1.071288287573e+01
RINT3224 nd3224 nd3875 1.722097716126e+01
RINT3225 nd3225 nd3876 1.487039843942e+01
RINT3226 nd3226 nd3877 1.487039843942e+01
RINT3227 nd3227 nd3878 8.627601608838e+02
RINT3228 nd3228 nd3879 3.060580775545e+01
RINT3229 nd3229 nd3880 3.082228040171e+01
RINT3230 nd3230 nd3881 3.082228040171e+01
RINT3231 nd3231 nd3882 1.224329471512e+03
RINT3232 nd3232 nd3883 2.040549119187e+02
RINT3233 nd3233 nd3884 3.498084204321e+02
RINT3234 nd3234 nd3885 3.498084204321e+02
RINT3235 nd3235 nd3886 3.498084204321e+02
RINT3236 nd3236 nd3887 3.498084204321e+02
RINT3237 nd3237 nd3888 3.498084204321e+02
RINT3238 nd3238 nd3889 3.498084204321e+02
RINT3239 nd3239 nd3890 3.498084204321e+02
RINT3240 nd3240 nd3891 7.773520454047e+01
RINT3241 nd3241 nd3892 7.773520454047e+01
RINT3242 nd3242 nd3893 1.611548589557e+03
RINT3243 nd3243 nd3894 1.159115429604e+02
RINT3244 nd3244 nd3895 2.571091890176e+03
RINT3245 nd3245 nd3896 1.071288287573e+01
RINT3246 nd3246 nd3897 1.071288287573e+01
RINT3247 nd3247 nd3898 1.071288287573e+01
RINT3248 nd3248 nd3899 1.071288287573e+01
RINT3249 nd3249 nd3900 1.071288287573e+01
RINT3250 nd3250 nd3901 1.071288287573e+01
RINT3251 nd3251 nd3902 1.071288287573e+01
RINT3252 nd3252 nd3903 1.071288287573e+01
RINT3253 nd3253 nd3904 1.071288287573e+01
RINT3254 nd3254 nd3905 1.071288287573e+01
RINT3255 nd3255 nd3906 9.521626084020e+00
RINT3256 nd3256 nd3907 8.221970933165e+00
RINT3257 nd3257 nd3908 8.221970933165e+00
RINT3258 nd3258 nd3909 4.770274982191e+02
RINT3259 nd3259 nd3910 1.692221380459e+01
RINT3260 nd3260 nd3911 1.704190338874e+01
RINT3261 nd3261 nd3912 1.704190338874e+01
RINT3262 nd3262 nd3913 6.769422734972e+02
RINT3263 nd3263 nd3914 1.128237122495e+02
RINT3264 nd3264 nd3915 1.934120781421e+02
RINT3265 nd3265 nd3916 1.934120781421e+02
RINT3266 nd3266 nd3917 1.934120781421e+02
RINT3267 nd3267 nd3918 1.934120781421e+02
RINT3268 nd3268 nd3919 1.934120781421e+02
RINT3269 nd3269 nd3920 1.934120781421e+02
RINT3270 nd3270 nd3921 1.934120781421e+02
RINT3271 nd3271 nd3922 4.298046180935e+01
RINT3272 nd3272 nd3923 4.298046180935e+01
RINT3273 nd3273 nd3924 8.910390474536e+02
RINT3274 nd3274 nd3925 6.408848699791e+01
RINT3275 nd3275 nd3926 1.421578774344e+03
RINT3276 nd3276 nd3927 5.923244893101e+00
RINT3277 nd3277 nd3928 5.923244893101e+00
RINT3278 nd3278 nd3929 5.923244893101e+00
RINT3279 nd3279 nd3930 5.923244893101e+00
RINT3280 nd3280 nd3931 5.923244893101e+00
RINT3281 nd3281 nd3932 5.923244893101e+00
RINT3282 nd3282 nd3933 5.923244893101e+00
RINT3283 nd3283 nd3934 5.923244893101e+00
RINT3284 nd3284 nd3935 5.923244893101e+00
RINT3285 nd3285 nd3936 5.923244893101e+00
RINT3286 nd3286 nd3937 9.521626084020e+00
RINT3287 nd3287 nd3938 8.221970933165e+00
RINT3288 nd3288 nd3939 8.221970933165e+00
RINT3289 nd3289 nd3940 4.770274982191e+02
RINT3290 nd3290 nd3941 1.692221380459e+01
RINT3291 nd3291 nd3942 1.704190338874e+01
RINT3292 nd3292 nd3943 1.704190338874e+01
RINT3293 nd3293 nd3944 6.769422734972e+02
RINT3294 nd3294 nd3945 1.128237122495e+02
RINT3295 nd3295 nd3946 1.934120781421e+02
RINT3296 nd3296 nd3947 1.934120781421e+02
RINT3297 nd3297 nd3948 1.934120781421e+02
RINT3298 nd3298 nd3949 1.934120781421e+02
RINT3299 nd3299 nd3950 1.934120781421e+02
RINT3300 nd3300 nd3951 1.934120781421e+02
RINT3301 nd3301 nd3952 1.934120781421e+02
RINT3302 nd3302 nd3953 4.298046180935e+01
RINT3303 nd3303 nd3954 4.298046180935e+01
RINT3304 nd3304 nd3955 8.910390474536e+02
RINT3305 nd3305 nd3956 6.408848699791e+01
RINT3306 nd3306 nd3957 1.421578774344e+03
RINT3307 nd3307 nd3958 5.923244893101e+00
RINT3308 nd3308 nd3959 5.923244893101e+00
RINT3309 nd3309 nd3960 5.923244893101e+00
RINT3310 nd3310 nd3961 5.923244893101e+00
RINT3311 nd3311 nd3962 5.923244893101e+00
RINT3312 nd3312 nd3963 5.923244893101e+00
RINT3313 nd3313 nd3964 5.923244893101e+00
RINT3314 nd3314 nd3965 5.923244893101e+00
RINT3315 nd3315 nd3966 5.923244893101e+00
RINT3316 nd3316 nd3967 5.923244893101e+00
RINT3317 nd3317 nd3968 9.521626084020e+00
RINT3318 nd3318 nd3969 8.221970933165e+00
RINT3319 nd3319 nd3970 8.221970933165e+00
RINT3320 nd3320 nd3971 4.770274982191e+02
RINT3321 nd3321 nd3972 1.692221380459e+01
RINT3322 nd3322 nd3973 1.704190338874e+01
RINT3323 nd3323 nd3974 1.704190338874e+01
RINT3324 nd3324 nd3975 6.769422734972e+02
RINT3325 nd3325 nd3976 1.128237122495e+02
RINT3326 nd3326 nd3977 1.934120781421e+02
RINT3327 nd3327 nd3978 1.934120781421e+02
RINT3328 nd3328 nd3979 1.934120781421e+02
RINT3329 nd3329 nd3980 1.934120781421e+02
RINT3330 nd3330 nd3981 1.934120781421e+02
RINT3331 nd3331 nd3982 1.934120781421e+02
RINT3332 nd3332 nd3983 1.934120781421e+02
RINT3333 nd3333 nd3984 4.298046180935e+01
RINT3334 nd3334 nd3985 4.298046180935e+01
RINT3335 nd3335 nd3986 8.910390474536e+02
RINT3336 nd3336 nd3987 6.408848699791e+01
RINT3337 nd3337 nd3988 1.421578774344e+03
RINT3338 nd3338 nd3989 5.923244893101e+00
RINT3339 nd3339 nd3990 5.923244893101e+00
RINT3340 nd3340 nd3991 5.923244893101e+00
RINT3341 nd3341 nd3992 5.923244893101e+00
RINT3342 nd3342 nd3993 5.923244893101e+00
RINT3343 nd3343 nd3994 5.923244893101e+00
RINT3344 nd3344 nd3995 5.923244893101e+00
RINT3345 nd3345 nd3996 5.923244893101e+00
RINT3346 nd3346 nd3997 5.923244893101e+00
RINT3347 nd3347 nd3998 5.923244893101e+00
RINT3348 nd3348 nd3999 6.999506028131e+01
RINT3349 nd3349 nd4000 6.044107865818e+01
RINT3350 nd3350 nd4001 6.044107865818e+01
RINT3351 nd3351 nd4002 3.506708643992e+03
RINT3352 nd3352 nd4003 1.243980140465e+02
RINT3353 nd3353 nd4004 1.252778721279e+02
RINT3354 nd3354 nd4005 1.252778721279e+02
RINT3355 nd3355 nd4006 3.265707031250e+05
RINT3356 nd3356 nd4007 5.442845052083e+04
RINT3357 nd3357 nd4008 9.330591517857e+04
RINT3358 nd3358 nd4009 9.330591517857e+04
RINT3359 nd3359 nd4010 9.330591517857e+04
RINT3360 nd3360 nd4011 9.330591517857e+04
RINT3361 nd3361 nd4012 9.330591517857e+04
RINT3362 nd3362 nd4013 9.330591517857e+04
RINT3363 nd3363 nd4014 9.330591517857e+04
RINT3364 nd3364 nd4015 2.073464781746e+04
RINT3365 nd3365 nd4016 2.073464781746e+04
RINT3366 nd3366 nd4017 6.550176544339e+03
RINT3367 nd3367 nd4018 4.711251493362e+02
RINT3368 nd3368 nd4019 1.045026250000e+04
RINT3369 nd3369 nd4020 4.354276041667e+01
RINT3370 nd3370 nd4021 4.354276041667e+01
RINT3371 nd3371 nd4022 4.354276041667e+01
RINT3372 nd3372 nd4023 4.354276041667e+01
RINT3373 nd3373 nd4024 4.354276041667e+01
RINT3374 nd3374 nd4025 4.354276041667e+01
RINT3375 nd3375 nd4026 4.354276041667e+01
RINT3376 nd3376 nd4027 4.354276041667e+01
RINT3377 nd3377 nd4028 4.354276041667e+01
RINT3378 nd3378 nd4029 4.354276041667e+01
RINT3379 nd3379 nd4030 7.310392023728e+00
RINT3380 nd3380 nd4031 6.312559451374e+00
RINT3381 nd3381 nd4032 6.312559451374e+00
RINT3382 nd3382 nd4033 3.662460579010e+02
RINT3383 nd3383 nd4034 1.299232040087e+01
RINT3384 nd3384 nd4035 1.308421413557e+01
RINT3385 nd3385 nd4036 1.308421413557e+01
RINT3386 nd3386 nd4037 3.883351253541e+03
RINT3387 nd3387 nd4038 6.126511232794e+02
RINT3388 nd3388 nd4039 1.068078026015e+03
RINT3389 nd3389 nd4040 1.068078026015e+03
RINT3390 nd3390 nd4041 1.068078026015e+03
RINT3391 nd3391 nd4042 1.068078026015e+03
RINT3392 nd3392 nd4043 1.068078026015e+03
RINT3393 nd3393 nd4044 1.068078026015e+03
RINT3394 nd3394 nd4045 1.068078026015e+03
RINT3395 nd3395 nd4046 2.333909041065e+02
RINT3396 nd3396 nd4047 2.341781857809e+02
RINT3397 nd3397 nd4048 6.841105382479e+02
RINT3398 nd3398 nd4049 4.920503704179e+01
RINT3399 nd3399 nd4050 1.091441529143e+03
RINT3400 nd3400 nd4051 4.547673038094e+00
RINT3401 nd3401 nd4052 4.547673038094e+00
RINT3402 nd3402 nd4053 4.547673038094e+00
RINT3403 nd3403 nd4054 4.547673038094e+00
RINT3404 nd3404 nd4055 4.547673038094e+00
RINT3405 nd3405 nd4056 4.547673038094e+00
RINT3406 nd3406 nd4057 4.547673038094e+00
RINT3407 nd3407 nd4058 4.547673038094e+00
RINT3408 nd3408 nd4059 4.547673038094e+00
RINT3409 nd3409 nd4060 4.547673038094e+00
RINT3410 nd3410 nd4061 7.310392023728e+00
RINT3411 nd3411 nd4062 6.312559451374e+00
RINT3412 nd3412 nd4063 6.312559451374e+00
RINT3413 nd3413 nd4064 3.662460579010e+02
RINT3414 nd3414 nd4065 1.299232040087e+01
RINT3415 nd3415 nd4066 1.308421413557e+01
RINT3416 nd3416 nd4067 1.308421413557e+01
RINT3417 nd3417 nd4068 3.883351253541e+03
RINT3418 nd3418 nd4069 6.126511232794e+02
RINT3419 nd3419 nd4070 1.068078026015e+03
RINT3420 nd3420 nd4071 1.068078026015e+03
RINT3421 nd3421 nd4072 1.068078026015e+03
RINT3422 nd3422 nd4073 1.068078026015e+03
RINT3423 nd3423 nd4074 1.068078026015e+03
RINT3424 nd3424 nd4075 1.068078026015e+03
RINT3425 nd3425 nd4076 1.068078026015e+03
RINT3426 nd3426 nd4077 2.333909041065e+02
RINT3427 nd3427 nd4078 2.341781857809e+02
RINT3428 nd3428 nd4079 6.841105382479e+02
RINT3429 nd3429 nd4080 4.920503704179e+01
RINT3430 nd3430 nd4081 1.091441529143e+03
RINT3431 nd3431 nd4082 4.547673038094e+00
RINT3432 nd3432 nd4083 4.547673038094e+00
RINT3433 nd3433 nd4084 4.547673038094e+00
RINT3434 nd3434 nd4085 4.547673038094e+00
RINT3435 nd3435 nd4086 4.547673038094e+00
RINT3436 nd3436 nd4087 4.547673038094e+00
RINT3437 nd3437 nd4088 4.547673038094e+00
RINT3438 nd3438 nd4089 4.547673038094e+00
RINT3439 nd3439 nd4090 4.547673038094e+00
RINT3440 nd3440 nd4091 4.547673038094e+00
RINT3441 nd3441 nd4092 7.310392023728e+00
RINT3442 nd3442 nd4093 6.312559451374e+00
RINT3443 nd3443 nd4094 6.312559451374e+00
RINT3444 nd3444 nd4095 3.662460579010e+02
RINT3445 nd3445 nd4096 1.299232040087e+01
RINT3446 nd3446 nd4097 1.308421413557e+01
RINT3447 nd3447 nd4098 1.308421413557e+01
RINT3448 nd3448 nd4099 3.883351253541e+03
RINT3449 nd3449 nd4100 6.126511232794e+02
RINT3450 nd3450 nd4101 1.068078026015e+03
RINT3451 nd3451 nd4102 1.068078026015e+03
RINT3452 nd3452 nd4103 1.068078026015e+03
RINT3453 nd3453 nd4104 1.068078026015e+03
RINT3454 nd3454 nd4105 1.068078026015e+03
RINT3455 nd3455 nd4106 1.068078026015e+03
RINT3456 nd3456 nd4107 1.068078026015e+03
RINT3457 nd3457 nd4108 2.333909041065e+02
RINT3458 nd3458 nd4109 2.341781857809e+02
RINT3459 nd3459 nd4110 6.841105382479e+02
RINT3460 nd3460 nd4111 4.920503704179e+01
RINT3461 nd3461 nd4112 1.091441529143e+03
RINT3462 nd3462 nd4113 4.547673038094e+00
RINT3463 nd3463 nd4114 4.547673038094e+00
RINT3464 nd3464 nd4115 4.547673038094e+00
RINT3465 nd3465 nd4116 4.547673038094e+00
RINT3466 nd3466 nd4117 4.547673038094e+00
RINT3467 nd3467 nd4118 4.547673038094e+00
RINT3468 nd3468 nd4119 4.547673038094e+00
RINT3469 nd3469 nd4120 4.547673038094e+00
RINT3470 nd3470 nd4121 4.547673038094e+00
RINT3471 nd3471 nd4122 4.547673038094e+00
RINT3472 nd3472 nd4123 7.310392023728e+00
RINT3473 nd3473 nd4124 6.312559451374e+00
RINT3474 nd3474 nd4125 6.312559451374e+00
RINT3475 nd3475 nd4126 3.662460579010e+02
RINT3476 nd3476 nd4127 1.299232040087e+01
RINT3477 nd3477 nd4128 1.308421413557e+01
RINT3478 nd3478 nd4129 1.308421413557e+01
RINT3479 nd3479 nd4130 3.883351253541e+03
RINT3480 nd3480 nd4131 6.126511232794e+02
RINT3481 nd3481 nd4132 1.068078026015e+03
RINT3482 nd3482 nd4133 1.068078026015e+03
RINT3483 nd3483 nd4134 1.068078026015e+03
RINT3484 nd3484 nd4135 1.068078026015e+03
RINT3485 nd3485 nd4136 1.068078026015e+03
RINT3486 nd3486 nd4137 1.068078026015e+03
RINT3487 nd3487 nd4138 1.068078026015e+03
RINT3488 nd3488 nd4139 2.333909041065e+02
RINT3489 nd3489 nd4140 2.341781857809e+02
RINT3490 nd3490 nd4141 6.841105382479e+02
RINT3491 nd3491 nd4142 4.920503704179e+01
RINT3492 nd3492 nd4143 1.091441529143e+03
RINT3493 nd3493 nd4144 4.547673038094e+00
RINT3494 nd3494 nd4145 4.547673038094e+00
RINT3495 nd3495 nd4146 4.547673038094e+00
RINT3496 nd3496 nd4147 4.547673038094e+00
RINT3497 nd3497 nd4148 4.547673038094e+00
RINT3498 nd3498 nd4149 4.547673038094e+00
RINT3499 nd3499 nd4150 4.547673038094e+00
RINT3500 nd3500 nd4151 4.547673038094e+00
RINT3501 nd3501 nd4152 4.547673038094e+00
RINT3502 nd3502 nd4153 4.547673038094e+00
RINT3503 nd3503 nd4154 7.310392023728e+00
RINT3504 nd3504 nd4155 6.312559451374e+00
RINT3505 nd3505 nd4156 6.312559451374e+00
RINT3506 nd3506 nd4157 3.662460579010e+02
RINT3507 nd3507 nd4158 1.299232040087e+01
RINT3508 nd3508 nd4159 1.308421413557e+01
RINT3509 nd3509 nd4160 1.308421413557e+01
RINT3510 nd3510 nd4161 3.883351253541e+03
RINT3511 nd3511 nd4162 6.126511232794e+02
RINT3512 nd3512 nd4163 1.068078026015e+03
RINT3513 nd3513 nd4164 1.068078026015e+03
RINT3514 nd3514 nd4165 1.068078026015e+03
RINT3515 nd3515 nd4166 1.068078026015e+03
RINT3516 nd3516 nd4167 1.068078026015e+03
RINT3517 nd3517 nd4168 1.068078026015e+03
RINT3518 nd3518 nd4169 1.068078026015e+03
RINT3519 nd3519 nd4170 2.333909041065e+02
RINT3520 nd3520 nd4171 2.341781857809e+02
RINT3521 nd3521 nd4172 6.841105382479e+02
RINT3522 nd3522 nd4173 4.920503704179e+01
RINT3523 nd3523 nd4174 1.091441529143e+03
RINT3524 nd3524 nd4175 4.547673038094e+00
RINT3525 nd3525 nd4176 4.547673038094e+00
RINT3526 nd3526 nd4177 4.547673038094e+00
RINT3527 nd3527 nd4178 4.547673038094e+00
RINT3528 nd3528 nd4179 4.547673038094e+00
RINT3529 nd3529 nd4180 4.547673038094e+00
RINT3530 nd3530 nd4181 4.547673038094e+00
RINT3531 nd3531 nd4182 4.547673038094e+00
RINT3532 nd3532 nd4183 4.547673038094e+00
RINT3533 nd3533 nd4184 4.547673038094e+00
RINT3534 nd3534 nd4185 7.310392023728e+00
RINT3535 nd3535 nd4186 6.312559451374e+00
RINT3536 nd3536 nd4187 6.312559451374e+00
RINT3537 nd3537 nd4188 3.662460579010e+02
RINT3538 nd3538 nd4189 1.299232040087e+01
RINT3539 nd3539 nd4190 1.308421413557e+01
RINT3540 nd3540 nd4191 1.308421413557e+01
RINT3541 nd3541 nd4192 3.883351253541e+03
RINT3542 nd3542 nd4193 6.126511232794e+02
RINT3543 nd3543 nd4194 1.068078026015e+03
RINT3544 nd3544 nd4195 1.068078026015e+03
RINT3545 nd3545 nd4196 1.068078026015e+03
RINT3546 nd3546 nd4197 1.068078026015e+03
RINT3547 nd3547 nd4198 1.068078026015e+03
RINT3548 nd3548 nd4199 1.068078026015e+03
RINT3549 nd3549 nd4200 1.068078026015e+03
RINT3550 nd3550 nd4201 2.333909041065e+02
RINT3551 nd3551 nd4202 2.341781857809e+02
RINT3552 nd3552 nd4203 6.841105382479e+02
RINT3553 nd3553 nd4204 4.920503704179e+01
RINT3554 nd3554 nd4205 1.091441529143e+03
RINT3555 nd3555 nd4206 4.547673038094e+00
RINT3556 nd3556 nd4207 4.547673038094e+00
RINT3557 nd3557 nd4208 4.547673038094e+00
RINT3558 nd3558 nd4209 4.547673038094e+00
RINT3559 nd3559 nd4210 4.547673038094e+00
RINT3560 nd3560 nd4211 4.547673038094e+00
RINT3561 nd3561 nd4212 4.547673038094e+00
RINT3562 nd3562 nd4213 4.547673038094e+00
RINT3563 nd3563 nd4214 4.547673038094e+00
RINT3564 nd3564 nd4215 4.547673038094e+00
RINT3565 nd3565 nd4216 6.999506028131e+01
RINT3566 nd3566 nd4217 6.044107865818e+01
RINT3567 nd3567 nd4218 6.044107865818e+01
RINT3568 nd3568 nd4219 3.506708643992e+03
RINT3569 nd3569 nd4220 1.243980140465e+02
RINT3570 nd3570 nd4221 1.252778721279e+02
RINT3571 nd3571 nd4222 1.252778721279e+02
RINT3572 nd3572 nd4223 3.265707031250e+05
RINT3573 nd3573 nd4224 5.442845052083e+04
RINT3574 nd3574 nd4225 9.330591517857e+04
RINT3575 nd3575 nd4226 9.330591517857e+04
RINT3576 nd3576 nd4227 9.330591517857e+04
RINT3577 nd3577 nd4228 9.330591517857e+04
RINT3578 nd3578 nd4229 9.330591517857e+04
RINT3579 nd3579 nd4230 9.330591517857e+04
RINT3580 nd3580 nd4231 9.330591517857e+04
RINT3581 nd3581 nd4232 2.073464781746e+04
RINT3582 nd3582 nd4233 2.073464781746e+04
RINT3583 nd3583 nd4234 6.550176544339e+03
RINT3584 nd3584 nd4235 4.711251493362e+02
RINT3585 nd3585 nd4236 1.045026250000e+04
RINT3586 nd3586 nd4237 4.354276041667e+01
RINT3587 nd3587 nd4238 4.354276041667e+01
RINT3588 nd3588 nd4239 4.354276041667e+01
RINT3589 nd3589 nd4240 4.354276041667e+01
RINT3590 nd3590 nd4241 4.354276041667e+01
RINT3591 nd3591 nd4242 4.354276041667e+01
RINT3592 nd3592 nd4243 4.354276041667e+01
RINT3593 nd3593 nd4244 4.354276041667e+01
RINT3594 nd3594 nd4245 4.354276041667e+01
RINT3595 nd3595 nd4246 4.354276041667e+01
RINT3596 nd3596 nd4247 7.310392023728e+00
RINT3597 nd3597 nd4248 6.312559451374e+00
RINT3598 nd3598 nd4249 6.312559451374e+00
RINT3599 nd3599 nd4250 3.662460579010e+02
RINT3600 nd3600 nd4251 1.299232040087e+01
RINT3601 nd3601 nd4252 1.308421413557e+01
RINT3602 nd3602 nd4253 1.308421413557e+01
RINT3603 nd3603 nd4254 3.883351253541e+03
RINT3604 nd3604 nd4255 6.126511232794e+02
RINT3605 nd3605 nd4256 1.068078026015e+03
RINT3606 nd3606 nd4257 1.068078026015e+03
RINT3607 nd3607 nd4258 1.068078026015e+03
RINT3608 nd3608 nd4259 1.068078026015e+03
RINT3609 nd3609 nd4260 1.068078026015e+03
RINT3610 nd3610 nd4261 1.068078026015e+03
RINT3611 nd3611 nd4262 1.068078026015e+03
RINT3612 nd3612 nd4263 2.333909041065e+02
RINT3613 nd3613 nd4264 2.341781857809e+02
RINT3614 nd3614 nd4265 6.841105382479e+02
RINT3615 nd3615 nd4266 4.920503704179e+01
RINT3616 nd3616 nd4267 1.091441529143e+03
RINT3617 nd3617 nd4268 4.547673038094e+00
RINT3618 nd3618 nd4269 4.547673038094e+00
RINT3619 nd3619 nd4270 4.547673038094e+00
RINT3620 nd3620 nd4271 4.547673038094e+00
RINT3621 nd3621 nd4272 4.547673038094e+00
RINT3622 nd3622 nd4273 4.547673038094e+00
RINT3623 nd3623 nd4274 4.547673038094e+00
RINT3624 nd3624 nd4275 4.547673038094e+00
RINT3625 nd3625 nd4276 4.547673038094e+00
RINT3626 nd3626 nd4277 4.547673038094e+00
RINT3627 nd3627 nd4278 7.310392023728e+00
RINT3628 nd3628 nd4279 6.312559451374e+00
RINT3629 nd3629 nd4280 6.312559451374e+00
RINT3630 nd3630 nd4281 3.662460579010e+02
RINT3631 nd3631 nd4282 1.299232040087e+01
RINT3632 nd3632 nd4283 1.308421413557e+01
RINT3633 nd3633 nd4284 1.308421413557e+01
RINT3634 nd3634 nd4285 3.883351253541e+03
RINT3635 nd3635 nd4286 6.126511232794e+02
RINT3636 nd3636 nd4287 1.068078026015e+03
RINT3637 nd3637 nd4288 1.068078026015e+03
RINT3638 nd3638 nd4289 1.068078026015e+03
RINT3639 nd3639 nd4290 1.068078026015e+03
RINT3640 nd3640 nd4291 1.068078026015e+03
RINT3641 nd3641 nd4292 1.068078026015e+03
RINT3642 nd3642 nd4293 1.068078026015e+03
RINT3643 nd3643 nd4294 2.333909041065e+02
RINT3644 nd3644 nd4295 2.341781857809e+02
RINT3645 nd3645 nd4296 6.841105382479e+02
RINT3646 nd3646 nd4297 4.920503704179e+01
RINT3647 nd3647 nd4298 1.091441529143e+03
RINT3648 nd3648 nd4299 4.547673038094e+00
RINT3649 nd3649 nd4300 4.547673038094e+00
RINT3650 nd3650 nd4301 4.547673038094e+00
RINT3651 nd3651 nd4302 4.547673038094e+00
RINT3652 nd3652 nd4303 4.547673038094e+00
RINT3653 nd3653 nd4304 4.547673038094e+00
RINT3654 nd3654 nd4305 4.547673038094e+00
RINT3655 nd3655 nd4306 4.547673038094e+00
RINT3656 nd3656 nd4307 4.547673038094e+00
RINT3657 nd3657 nd4308 4.547673038094e+00
RINT3658 nd3658 nd4309 7.310392023728e+00
RINT3659 nd3659 nd4310 6.312559451374e+00
RINT3660 nd3660 nd4311 6.312559451374e+00
RINT3661 nd3661 nd4312 3.662460579010e+02
RINT3662 nd3662 nd4313 1.299232040087e+01
RINT3663 nd3663 nd4314 1.308421413557e+01
RINT3664 nd3664 nd4315 1.308421413557e+01
RINT3665 nd3665 nd4316 3.883351253541e+03
RINT3666 nd3666 nd4317 6.126511232794e+02
RINT3667 nd3667 nd4318 1.068078026015e+03
RINT3668 nd3668 nd4319 1.068078026015e+03
RINT3669 nd3669 nd4320 1.068078026015e+03
RINT3670 nd3670 nd4321 1.068078026015e+03
RINT3671 nd3671 nd4322 1.068078026015e+03
RINT3672 nd3672 nd4323 1.068078026015e+03
RINT3673 nd3673 nd4324 1.068078026015e+03
RINT3674 nd3674 nd4325 2.333909041065e+02
RINT3675 nd3675 nd4326 2.341781857809e+02
RINT3676 nd3676 nd4327 6.841105382479e+02
RINT3677 nd3677 nd4328 4.920503704179e+01
RINT3678 nd3678 nd4329 1.091441529143e+03
RINT3679 nd3679 nd4330 4.547673038094e+00
RINT3680 nd3680 nd4331 4.547673038094e+00
RINT3681 nd3681 nd4332 4.547673038094e+00
RINT3682 nd3682 nd4333 4.547673038094e+00
RINT3683 nd3683 nd4334 4.547673038094e+00
RINT3684 nd3684 nd4335 4.547673038094e+00
RINT3685 nd3685 nd4336 4.547673038094e+00
RINT3686 nd3686 nd4337 4.547673038094e+00
RINT3687 nd3687 nd4338 4.547673038094e+00
RINT3688 nd3688 nd4339 4.547673038094e+00
RINT3689 nd3689 nd4340 7.310392023728e+00
RINT3690 nd3690 nd4341 6.312559451374e+00
RINT3691 nd3691 nd4342 6.312559451374e+00
RINT3692 nd3692 nd4343 3.662460579010e+02
RINT3693 nd3693 nd4344 1.299232040087e+01
RINT3694 nd3694 nd4345 1.308421413557e+01
RINT3695 nd3695 nd4346 1.308421413557e+01
RINT3696 nd3696 nd4347 3.883351253541e+03
RINT3697 nd3697 nd4348 6.126511232794e+02
RINT3698 nd3698 nd4349 1.068078026015e+03
RINT3699 nd3699 nd4350 1.068078026015e+03
RINT3700 nd3700 nd4351 1.068078026015e+03
RINT3701 nd3701 nd4352 1.068078026015e+03
RINT3702 nd3702 nd4353 1.068078026015e+03
RINT3703 nd3703 nd4354 1.068078026015e+03
RINT3704 nd3704 nd4355 1.068078026015e+03
RINT3705 nd3705 nd4356 2.333909041065e+02
RINT3706 nd3706 nd4357 2.341781857809e+02
RINT3707 nd3707 nd4358 6.841105382479e+02
RINT3708 nd3708 nd4359 4.920503704179e+01
RINT3709 nd3709 nd4360 1.091441529143e+03
RINT3710 nd3710 nd4361 4.547673038094e+00
RINT3711 nd3711 nd4362 4.547673038094e+00
RINT3712 nd3712 nd4363 4.547673038094e+00
RINT3713 nd3713 nd4364 4.547673038094e+00
RINT3714 nd3714 nd4365 4.547673038094e+00
RINT3715 nd3715 nd4366 4.547673038094e+00
RINT3716 nd3716 nd4367 4.547673038094e+00
RINT3717 nd3717 nd4368 4.547673038094e+00
RINT3718 nd3718 nd4369 4.547673038094e+00
RINT3719 nd3719 nd4370 4.547673038094e+00
RINT3720 nd3720 nd4371 7.310392023728e+00
RINT3721 nd3721 nd4372 6.312559451374e+00
RINT3722 nd3722 nd4373 6.312559451374e+00
RINT3723 nd3723 nd4374 3.662460579010e+02
RINT3724 nd3724 nd4375 1.299232040087e+01
RINT3725 nd3725 nd4376 1.308421413557e+01
RINT3726 nd3726 nd4377 1.308421413557e+01
RINT3727 nd3727 nd4378 3.883351253541e+03
RINT3728 nd3728 nd4379 6.126511232794e+02
RINT3729 nd3729 nd4380 1.068078026015e+03
RINT3730 nd3730 nd4381 1.068078026015e+03
RINT3731 nd3731 nd4382 1.068078026015e+03
RINT3732 nd3732 nd4383 1.068078026015e+03
RINT3733 nd3733 nd4384 1.068078026015e+03
RINT3734 nd3734 nd4385 1.068078026015e+03
RINT3735 nd3735 nd4386 1.068078026015e+03
RINT3736 nd3736 nd4387 2.333909041065e+02
RINT3737 nd3737 nd4388 2.341781857809e+02
RINT3738 nd3738 nd4389 6.841105382479e+02
RINT3739 nd3739 nd4390 4.920503704179e+01
RINT3740 nd3740 nd4391 1.091441529143e+03
RINT3741 nd3741 nd4392 4.547673038094e+00
RINT3742 nd3742 nd4393 4.547673038094e+00
RINT3743 nd3743 nd4394 4.547673038094e+00
RINT3744 nd3744 nd4395 4.547673038094e+00
RINT3745 nd3745 nd4396 4.547673038094e+00
RINT3746 nd3746 nd4397 4.547673038094e+00
RINT3747 nd3747 nd4398 4.547673038094e+00
RINT3748 nd3748 nd4399 4.547673038094e+00
RINT3749 nd3749 nd4400 4.547673038094e+00
RINT3750 nd3750 nd4401 4.547673038094e+00
RINT3751 nd3751 nd4402 7.310392023728e+00
RINT3752 nd3752 nd4403 6.312559451374e+00
RINT3753 nd3753 nd4404 6.312559451374e+00
RINT3754 nd3754 nd4405 3.662460579010e+02
RINT3755 nd3755 nd4406 1.299232040087e+01
RINT3756 nd3756 nd4407 1.308421413557e+01
RINT3757 nd3757 nd4408 1.308421413557e+01
RINT3758 nd3758 nd4409 3.883351253541e+03
RINT3759 nd3759 nd4410 6.126511232794e+02
RINT3760 nd3760 nd4411 1.068078026015e+03
RINT3761 nd3761 nd4412 1.068078026015e+03
RINT3762 nd3762 nd4413 1.068078026015e+03
RINT3763 nd3763 nd4414 1.068078026015e+03
RINT3764 nd3764 nd4415 1.068078026015e+03
RINT3765 nd3765 nd4416 1.068078026015e+03
RINT3766 nd3766 nd4417 1.068078026015e+03
RINT3767 nd3767 nd4418 2.333909041065e+02
RINT3768 nd3768 nd4419 2.341781857809e+02
RINT3769 nd3769 nd4420 6.841105382479e+02
RINT3770 nd3770 nd4421 4.920503704179e+01
RINT3771 nd3771 nd4422 1.091441529143e+03
RINT3772 nd3772 nd4423 4.547673038094e+00
RINT3773 nd3773 nd4424 4.547673038094e+00
RINT3774 nd3774 nd4425 4.547673038094e+00
RINT3775 nd3775 nd4426 4.547673038094e+00
RINT3776 nd3776 nd4427 4.547673038094e+00
RINT3777 nd3777 nd4428 4.547673038094e+00
RINT3778 nd3778 nd4429 4.547673038094e+00
RINT3779 nd3779 nd4430 4.547673038094e+00
RINT3780 nd3780 nd4431 4.547673038094e+00
RINT3781 nd3781 nd4432 4.547673038094e+00
RINT3782 nd3782 nd4433 6.999506028131e+01
RINT3783 nd3783 nd4434 6.044107865818e+01
RINT3784 nd3784 nd4435 6.044107865818e+01
RINT3785 nd3785 nd4436 3.506708643992e+03
RINT3786 nd3786 nd4437 1.243980140465e+02
RINT3787 nd3787 nd4438 1.252778721279e+02
RINT3788 nd3788 nd4439 1.252778721279e+02
RINT3789 nd3789 nd4440 3.265707031250e+05
RINT3790 nd3790 nd4441 5.442845052083e+04
RINT3791 nd3791 nd4442 9.330591517857e+04
RINT3792 nd3792 nd4443 9.330591517857e+04
RINT3793 nd3793 nd4444 9.330591517857e+04
RINT3794 nd3794 nd4445 9.330591517857e+04
RINT3795 nd3795 nd4446 9.330591517857e+04
RINT3796 nd3796 nd4447 9.330591517857e+04
RINT3797 nd3797 nd4448 9.330591517857e+04
RINT3798 nd3798 nd4449 2.073464781746e+04
RINT3799 nd3799 nd4450 2.073464781746e+04
RINT3800 nd3800 nd4451 6.550176544339e+03
RINT3801 nd3801 nd4452 4.711251493362e+02
RINT3802 nd3802 nd4453 1.045026250000e+04
RINT3803 nd3803 nd4454 4.354276041667e+01
RINT3804 nd3804 nd4455 4.354276041667e+01
RINT3805 nd3805 nd4456 4.354276041667e+01
RINT3806 nd3806 nd4457 4.354276041667e+01
RINT3807 nd3807 nd4458 4.354276041667e+01
RINT3808 nd3808 nd4459 4.354276041667e+01
RINT3809 nd3809 nd4460 4.354276041667e+01
RINT3810 nd3810 nd4461 4.354276041667e+01
RINT3811 nd3811 nd4462 4.354276041667e+01
RINT3812 nd3812 nd4463 4.354276041667e+01
RINT3813 nd3813 nd4464 9.521626084020e+00
RINT3814 nd3814 nd4465 8.221970933165e+00
RINT3815 nd3815 nd4466 8.221970933165e+00
RINT3816 nd3816 nd4467 4.770274982191e+02
RINT3817 nd3817 nd4468 1.692221380459e+01
RINT3818 nd3818 nd4469 1.704190338874e+01
RINT3819 nd3819 nd4470 1.704190338874e+01
RINT3820 nd3820 nd4471 6.769422734972e+02
RINT3821 nd3821 nd4472 1.128237122495e+02
RINT3822 nd3822 nd4473 1.934120781421e+02
RINT3823 nd3823 nd4474 1.934120781421e+02
RINT3824 nd3824 nd4475 1.934120781421e+02
RINT3825 nd3825 nd4476 1.934120781421e+02
RINT3826 nd3826 nd4477 1.934120781421e+02
RINT3827 nd3827 nd4478 1.934120781421e+02
RINT3828 nd3828 nd4479 1.934120781421e+02
RINT3829 nd3829 nd4480 4.298046180935e+01
RINT3830 nd3830 nd4481 4.298046180935e+01
RINT3831 nd3831 nd4482 8.910390474536e+02
RINT3832 nd3832 nd4483 6.408848699791e+01
RINT3833 nd3833 nd4484 1.421578774344e+03
RINT3834 nd3834 nd4485 5.923244893101e+00
RINT3835 nd3835 nd4486 5.923244893101e+00
RINT3836 nd3836 nd4487 5.923244893101e+00
RINT3837 nd3837 nd4488 5.923244893101e+00
RINT3838 nd3838 nd4489 5.923244893101e+00
RINT3839 nd3839 nd4490 5.923244893101e+00
RINT3840 nd3840 nd4491 5.923244893101e+00
RINT3841 nd3841 nd4492 5.923244893101e+00
RINT3842 nd3842 nd4493 5.923244893101e+00
RINT3843 nd3843 nd4494 5.923244893101e+00
RINT3844 nd3844 nd4495 9.521626084020e+00
RINT3845 nd3845 nd4496 8.221970933165e+00
RINT3846 nd3846 nd4497 8.221970933165e+00
RINT3847 nd3847 nd4498 4.770274982191e+02
RINT3848 nd3848 nd4499 1.692221380459e+01
RINT3849 nd3849 nd4500 1.704190338874e+01
RINT3850 nd3850 nd4501 1.704190338874e+01
RINT3851 nd3851 nd4502 6.769422734972e+02
RINT3852 nd3852 nd4503 1.128237122495e+02
RINT3853 nd3853 nd4504 1.934120781421e+02
RINT3854 nd3854 nd4505 1.934120781421e+02
RINT3855 nd3855 nd4506 1.934120781421e+02
RINT3856 nd3856 nd4507 1.934120781421e+02
RINT3857 nd3857 nd4508 1.934120781421e+02
RINT3858 nd3858 nd4509 1.934120781421e+02
RINT3859 nd3859 nd4510 1.934120781421e+02
RINT3860 nd3860 nd4511 4.298046180935e+01
RINT3861 nd3861 nd4512 4.298046180935e+01
RINT3862 nd3862 nd4513 8.910390474536e+02
RINT3863 nd3863 nd4514 6.408848699791e+01
RINT3864 nd3864 nd4515 1.421578774344e+03
RINT3865 nd3865 nd4516 5.923244893101e+00
RINT3866 nd3866 nd4517 5.923244893101e+00
RINT3867 nd3867 nd4518 5.923244893101e+00
RINT3868 nd3868 nd4519 5.923244893101e+00
RINT3869 nd3869 nd4520 5.923244893101e+00
RINT3870 nd3870 nd4521 5.923244893101e+00
RINT3871 nd3871 nd4522 5.923244893101e+00
RINT3872 nd3872 nd4523 5.923244893101e+00
RINT3873 nd3873 nd4524 5.923244893101e+00
RINT3874 nd3874 nd4525 5.923244893101e+00
RINT3875 nd3875 nd4526 9.521626084020e+00
RINT3876 nd3876 nd4527 8.221970933165e+00
RINT3877 nd3877 nd4528 8.221970933165e+00
RINT3878 nd3878 nd4529 4.770274982191e+02
RINT3879 nd3879 nd4530 1.692221380459e+01
RINT3880 nd3880 nd4531 1.704190338874e+01
RINT3881 nd3881 nd4532 1.704190338874e+01
RINT3882 nd3882 nd4533 6.769422734972e+02
RINT3883 nd3883 nd4534 1.128237122495e+02
RINT3884 nd3884 nd4535 1.934120781421e+02
RINT3885 nd3885 nd4536 1.934120781421e+02
RINT3886 nd3886 nd4537 1.934120781421e+02
RINT3887 nd3887 nd4538 1.934120781421e+02
RINT3888 nd3888 nd4539 1.934120781421e+02
RINT3889 nd3889 nd4540 1.934120781421e+02
RINT3890 nd3890 nd4541 1.934120781421e+02
RINT3891 nd3891 nd4542 4.298046180935e+01
RINT3892 nd3892 nd4543 4.298046180935e+01
RINT3893 nd3893 nd4544 8.910390474536e+02
RINT3894 nd3894 nd4545 6.408848699791e+01
RINT3895 nd3895 nd4546 1.421578774344e+03
RINT3896 nd3896 nd4547 5.923244893101e+00
RINT3897 nd3897 nd4548 5.923244893101e+00
RINT3898 nd3898 nd4549 5.923244893101e+00
RINT3899 nd3899 nd4550 5.923244893101e+00
RINT3900 nd3900 nd4551 5.923244893101e+00
RINT3901 nd3901 nd4552 5.923244893101e+00
RINT3902 nd3902 nd4553 5.923244893101e+00
RINT3903 nd3903 nd4554 5.923244893101e+00
RINT3904 nd3904 nd4555 5.923244893101e+00
RINT3905 nd3905 nd4556 5.923244893101e+00
RINT3906 nd3906 nd4557 9.521626084020e+00
RINT3907 nd3907 nd4558 8.221970933165e+00
RINT3908 nd3908 nd4559 8.221970933165e+00
RINT3909 nd3909 nd4560 4.770274982191e+02
RINT3910 nd3910 nd4561 1.692221380459e+01
RINT3911 nd3911 nd4562 1.704190338874e+01
RINT3912 nd3912 nd4563 1.704190338874e+01
RINT3913 nd3913 nd4564 6.769422734972e+02
RINT3914 nd3914 nd4565 1.128237122495e+02
RINT3915 nd3915 nd4566 1.934120781421e+02
RINT3916 nd3916 nd4567 1.934120781421e+02
RINT3917 nd3917 nd4568 1.934120781421e+02
RINT3918 nd3918 nd4569 1.934120781421e+02
RINT3919 nd3919 nd4570 1.934120781421e+02
RINT3920 nd3920 nd4571 1.934120781421e+02
RINT3921 nd3921 nd4572 1.934120781421e+02
RINT3922 nd3922 nd4573 4.298046180935e+01
RINT3923 nd3923 nd4574 4.298046180935e+01
RINT3924 nd3924 nd4575 8.910390474536e+02
RINT3925 nd3925 nd4576 6.408848699791e+01
RINT3926 nd3926 nd4577 1.421578774344e+03
RINT3927 nd3927 nd4578 5.923244893101e+00
RINT3928 nd3928 nd4579 5.923244893101e+00
RINT3929 nd3929 nd4580 5.923244893101e+00
RINT3930 nd3930 nd4581 5.923244893101e+00
RINT3931 nd3931 nd4582 5.923244893101e+00
RINT3932 nd3932 nd4583 5.923244893101e+00
RINT3933 nd3933 nd4584 5.923244893101e+00
RINT3934 nd3934 nd4585 5.923244893101e+00
RINT3935 nd3935 nd4586 5.923244893101e+00
RINT3936 nd3936 nd4587 5.923244893101e+00
RINT3937 nd3937 nd4588 9.521626084020e+00
RINT3938 nd3938 nd4589 8.221970933165e+00
RINT3939 nd3939 nd4590 8.221970933165e+00
RINT3940 nd3940 nd4591 4.770274982191e+02
RINT3941 nd3941 nd4592 1.692221380459e+01
RINT3942 nd3942 nd4593 1.704190338874e+01
RINT3943 nd3943 nd4594 1.704190338874e+01
RINT3944 nd3944 nd4595 6.769422734972e+02
RINT3945 nd3945 nd4596 1.128237122495e+02
RINT3946 nd3946 nd4597 1.934120781421e+02
RINT3947 nd3947 nd4598 1.934120781421e+02
RINT3948 nd3948 nd4599 1.934120781421e+02
RINT3949 nd3949 nd4600 1.934120781421e+02
RINT3950 nd3950 nd4601 1.934120781421e+02
RINT3951 nd3951 nd4602 1.934120781421e+02
RINT3952 nd3952 nd4603 1.934120781421e+02
RINT3953 nd3953 nd4604 4.298046180935e+01
RINT3954 nd3954 nd4605 4.298046180935e+01
RINT3955 nd3955 nd4606 8.910390474536e+02
RINT3956 nd3956 nd4607 6.408848699791e+01
RINT3957 nd3957 nd4608 1.421578774344e+03
RINT3958 nd3958 nd4609 5.923244893101e+00
RINT3959 nd3959 nd4610 5.923244893101e+00
RINT3960 nd3960 nd4611 5.923244893101e+00
RINT3961 nd3961 nd4612 5.923244893101e+00
RINT3962 nd3962 nd4613 5.923244893101e+00
RINT3963 nd3963 nd4614 5.923244893101e+00
RINT3964 nd3964 nd4615 5.923244893101e+00
RINT3965 nd3965 nd4616 5.923244893101e+00
RINT3966 nd3966 nd4617 5.923244893101e+00
RINT3967 nd3967 nd4618 5.923244893101e+00
RINT3968 nd3968 nd4619 9.521626084020e+00
RINT3969 nd3969 nd4620 8.221970933165e+00
RINT3970 nd3970 nd4621 8.221970933165e+00
RINT3971 nd3971 nd4622 4.770274982191e+02
RINT3972 nd3972 nd4623 1.692221380459e+01
RINT3973 nd3973 nd4624 1.704190338874e+01
RINT3974 nd3974 nd4625 1.704190338874e+01
RINT3975 nd3975 nd4626 6.769422734972e+02
RINT3976 nd3976 nd4627 1.128237122495e+02
RINT3977 nd3977 nd4628 1.934120781421e+02
RINT3978 nd3978 nd4629 1.934120781421e+02
RINT3979 nd3979 nd4630 1.934120781421e+02
RINT3980 nd3980 nd4631 1.934120781421e+02
RINT3981 nd3981 nd4632 1.934120781421e+02
RINT3982 nd3982 nd4633 1.934120781421e+02
RINT3983 nd3983 nd4634 1.934120781421e+02
RINT3984 nd3984 nd4635 4.298046180935e+01
RINT3985 nd3985 nd4636 4.298046180935e+01
RINT3986 nd3986 nd4637 8.910390474536e+02
RINT3987 nd3987 nd4638 6.408848699791e+01
RINT3988 nd3988 nd4639 1.421578774344e+03
RINT3989 nd3989 nd4640 5.923244893101e+00
RINT3990 nd3990 nd4641 5.923244893101e+00
RINT3991 nd3991 nd4642 5.923244893101e+00
RINT3992 nd3992 nd4643 5.923244893101e+00
RINT3993 nd3993 nd4644 5.923244893101e+00
RINT3994 nd3994 nd4645 5.923244893101e+00
RINT3995 nd3995 nd4646 5.923244893101e+00
RINT3996 nd3996 nd4647 5.923244893101e+00
RINT3997 nd3997 nd4648 5.923244893101e+00
RINT3998 nd3998 nd4649 5.923244893101e+00
RINT3999 nd3999 nd4650 6.999506028131e+01
RINT4000 nd4000 nd4651 6.044107865818e+01
RINT4001 nd4001 nd4652 6.044107865818e+01
RINT4002 nd4002 nd4653 3.506708643992e+03
RINT4003 nd4003 nd4654 1.243980140465e+02
RINT4004 nd4004 nd4655 1.252778721279e+02
RINT4005 nd4005 nd4656 1.252778721279e+02
RINT4006 nd4006 nd4657 3.265707031250e+05
RINT4007 nd4007 nd4658 5.442845052083e+04
RINT4008 nd4008 nd4659 9.330591517857e+04
RINT4009 nd4009 nd4660 9.330591517857e+04
RINT4010 nd4010 nd4661 9.330591517857e+04
RINT4011 nd4011 nd4662 9.330591517857e+04
RINT4012 nd4012 nd4663 9.330591517857e+04
RINT4013 nd4013 nd4664 9.330591517857e+04
RINT4014 nd4014 nd4665 9.330591517857e+04
RINT4015 nd4015 nd4666 2.073464781746e+04
RINT4016 nd4016 nd4667 2.073464781746e+04
RINT4017 nd4017 nd4668 6.550176544339e+03
RINT4018 nd4018 nd4669 4.711251493362e+02
RINT4019 nd4019 nd4670 1.045026250000e+04
RINT4020 nd4020 nd4671 4.354276041667e+01
RINT4021 nd4021 nd4672 4.354276041667e+01
RINT4022 nd4022 nd4673 4.354276041667e+01
RINT4023 nd4023 nd4674 4.354276041667e+01
RINT4024 nd4024 nd4675 4.354276041667e+01
RINT4025 nd4025 nd4676 4.354276041667e+01
RINT4026 nd4026 nd4677 4.354276041667e+01
RINT4027 nd4027 nd4678 4.354276041667e+01
RINT4028 nd4028 nd4679 4.354276041667e+01
RINT4029 nd4029 nd4680 4.354276041667e+01
RINT4030 nd4030 nd4681 7.310392023728e+00
RINT4031 nd4031 nd4682 6.312559451374e+00
RINT4032 nd4032 nd4683 6.312559451374e+00
RINT4033 nd4033 nd4684 3.662460579010e+02
RINT4034 nd4034 nd4685 1.299232040087e+01
RINT4035 nd4035 nd4686 1.308421413557e+01
RINT4036 nd4036 nd4687 1.308421413557e+01
RINT4037 nd4037 nd4688 3.883351253541e+03
RINT4038 nd4038 nd4689 6.126511232794e+02
RINT4039 nd4039 nd4690 1.068078026015e+03
RINT4040 nd4040 nd4691 1.068078026015e+03
RINT4041 nd4041 nd4692 1.068078026015e+03
RINT4042 nd4042 nd4693 1.068078026015e+03
RINT4043 nd4043 nd4694 1.068078026015e+03
RINT4044 nd4044 nd4695 1.068078026015e+03
RINT4045 nd4045 nd4696 1.068078026015e+03
RINT4046 nd4046 nd4697 2.333909041065e+02
RINT4047 nd4047 nd4698 2.341781857809e+02
RINT4048 nd4048 nd4699 6.841105382479e+02
RINT4049 nd4049 nd4700 4.920503704179e+01
RINT4050 nd4050 nd4701 1.091441529143e+03
RINT4051 nd4051 nd4702 4.547673038094e+00
RINT4052 nd4052 nd4703 4.547673038094e+00
RINT4053 nd4053 nd4704 4.547673038094e+00
RINT4054 nd4054 nd4705 4.547673038094e+00
RINT4055 nd4055 nd4706 4.547673038094e+00
RINT4056 nd4056 nd4707 4.547673038094e+00
RINT4057 nd4057 nd4708 4.547673038094e+00
RINT4058 nd4058 nd4709 4.547673038094e+00
RINT4059 nd4059 nd4710 4.547673038094e+00
RINT4060 nd4060 nd4711 4.547673038094e+00
RINT4061 nd4061 nd4712 7.310392023728e+00
RINT4062 nd4062 nd4713 6.312559451374e+00
RINT4063 nd4063 nd4714 6.312559451374e+00
RINT4064 nd4064 nd4715 3.662460579010e+02
RINT4065 nd4065 nd4716 1.299232040087e+01
RINT4066 nd4066 nd4717 1.308421413557e+01
RINT4067 nd4067 nd4718 1.308421413557e+01
RINT4068 nd4068 nd4719 3.883351253541e+03
RINT4069 nd4069 nd4720 6.126511232794e+02
RINT4070 nd4070 nd4721 1.068078026015e+03
RINT4071 nd4071 nd4722 1.068078026015e+03
RINT4072 nd4072 nd4723 1.068078026015e+03
RINT4073 nd4073 nd4724 1.068078026015e+03
RINT4074 nd4074 nd4725 1.068078026015e+03
RINT4075 nd4075 nd4726 1.068078026015e+03
RINT4076 nd4076 nd4727 1.068078026015e+03
RINT4077 nd4077 nd4728 2.333909041065e+02
RINT4078 nd4078 nd4729 2.341781857809e+02
RINT4079 nd4079 nd4730 6.841105382479e+02
RINT4080 nd4080 nd4731 4.920503704179e+01
RINT4081 nd4081 nd4732 1.091441529143e+03
RINT4082 nd4082 nd4733 4.547673038094e+00
RINT4083 nd4083 nd4734 4.547673038094e+00
RINT4084 nd4084 nd4735 4.547673038094e+00
RINT4085 nd4085 nd4736 4.547673038094e+00
RINT4086 nd4086 nd4737 4.547673038094e+00
RINT4087 nd4087 nd4738 4.547673038094e+00
RINT4088 nd4088 nd4739 4.547673038094e+00
RINT4089 nd4089 nd4740 4.547673038094e+00
RINT4090 nd4090 nd4741 4.547673038094e+00
RINT4091 nd4091 nd4742 4.547673038094e+00
RINT4092 nd4092 nd4743 7.310392023728e+00
RINT4093 nd4093 nd4744 6.312559451374e+00
RINT4094 nd4094 nd4745 6.312559451374e+00
RINT4095 nd4095 nd4746 3.662460579010e+02
RINT4096 nd4096 nd4747 1.299232040087e+01
RINT4097 nd4097 nd4748 1.308421413557e+01
RINT4098 nd4098 nd4749 1.308421413557e+01
RINT4099 nd4099 nd4750 3.883351253541e+03
RINT4100 nd4100 nd4751 6.126511232794e+02
RINT4101 nd4101 nd4752 1.068078026015e+03
RINT4102 nd4102 nd4753 1.068078026015e+03
RINT4103 nd4103 nd4754 1.068078026015e+03
RINT4104 nd4104 nd4755 1.068078026015e+03
RINT4105 nd4105 nd4756 1.068078026015e+03
RINT4106 nd4106 nd4757 1.068078026015e+03
RINT4107 nd4107 nd4758 1.068078026015e+03
RINT4108 nd4108 nd4759 2.333909041065e+02
RINT4109 nd4109 nd4760 2.341781857809e+02
RINT4110 nd4110 nd4761 6.841105382479e+02
RINT4111 nd4111 nd4762 4.920503704179e+01
RINT4112 nd4112 nd4763 1.091441529143e+03
RINT4113 nd4113 nd4764 4.547673038094e+00
RINT4114 nd4114 nd4765 4.547673038094e+00
RINT4115 nd4115 nd4766 4.547673038094e+00
RINT4116 nd4116 nd4767 4.547673038094e+00
RINT4117 nd4117 nd4768 4.547673038094e+00
RINT4118 nd4118 nd4769 4.547673038094e+00
RINT4119 nd4119 nd4770 4.547673038094e+00
RINT4120 nd4120 nd4771 4.547673038094e+00
RINT4121 nd4121 nd4772 4.547673038094e+00
RINT4122 nd4122 nd4773 4.547673038094e+00
RINT4123 nd4123 nd4774 7.310392023728e+00
RINT4124 nd4124 nd4775 6.312559451374e+00
RINT4125 nd4125 nd4776 6.312559451374e+00
RINT4126 nd4126 nd4777 3.662460579010e+02
RINT4127 nd4127 nd4778 1.299232040087e+01
RINT4128 nd4128 nd4779 1.308421413557e+01
RINT4129 nd4129 nd4780 1.308421413557e+01
RINT4130 nd4130 nd4781 3.883351253541e+03
RINT4131 nd4131 nd4782 6.126511232794e+02
RINT4132 nd4132 nd4783 1.068078026015e+03
RINT4133 nd4133 nd4784 1.068078026015e+03
RINT4134 nd4134 nd4785 1.068078026015e+03
RINT4135 nd4135 nd4786 1.068078026015e+03
RINT4136 nd4136 nd4787 1.068078026015e+03
RINT4137 nd4137 nd4788 1.068078026015e+03
RINT4138 nd4138 nd4789 1.068078026015e+03
RINT4139 nd4139 nd4790 2.333909041065e+02
RINT4140 nd4140 nd4791 2.341781857809e+02
RINT4141 nd4141 nd4792 6.841105382479e+02
RINT4142 nd4142 nd4793 4.920503704179e+01
RINT4143 nd4143 nd4794 1.091441529143e+03
RINT4144 nd4144 nd4795 4.547673038094e+00
RINT4145 nd4145 nd4796 4.547673038094e+00
RINT4146 nd4146 nd4797 4.547673038094e+00
RINT4147 nd4147 nd4798 4.547673038094e+00
RINT4148 nd4148 nd4799 4.547673038094e+00
RINT4149 nd4149 nd4800 4.547673038094e+00
RINT4150 nd4150 nd4801 4.547673038094e+00
RINT4151 nd4151 nd4802 4.547673038094e+00
RINT4152 nd4152 nd4803 4.547673038094e+00
RINT4153 nd4153 nd4804 4.547673038094e+00
RINT4154 nd4154 nd4805 7.310392023728e+00
RINT4155 nd4155 nd4806 6.312559451374e+00
RINT4156 nd4156 nd4807 6.312559451374e+00
RINT4157 nd4157 nd4808 3.662460579010e+02
RINT4158 nd4158 nd4809 1.299232040087e+01
RINT4159 nd4159 nd4810 1.308421413557e+01
RINT4160 nd4160 nd4811 1.308421413557e+01
RINT4161 nd4161 nd4812 3.883351253541e+03
RINT4162 nd4162 nd4813 6.126511232794e+02
RINT4163 nd4163 nd4814 1.068078026015e+03
RINT4164 nd4164 nd4815 1.068078026015e+03
RINT4165 nd4165 nd4816 1.068078026015e+03
RINT4166 nd4166 nd4817 1.068078026015e+03
RINT4167 nd4167 nd4818 1.068078026015e+03
RINT4168 nd4168 nd4819 1.068078026015e+03
RINT4169 nd4169 nd4820 1.068078026015e+03
RINT4170 nd4170 nd4821 2.333909041065e+02
RINT4171 nd4171 nd4822 2.341781857809e+02
RINT4172 nd4172 nd4823 6.841105382479e+02
RINT4173 nd4173 nd4824 4.920503704179e+01
RINT4174 nd4174 nd4825 1.091441529143e+03
RINT4175 nd4175 nd4826 4.547673038094e+00
RINT4176 nd4176 nd4827 4.547673038094e+00
RINT4177 nd4177 nd4828 4.547673038094e+00
RINT4178 nd4178 nd4829 4.547673038094e+00
RINT4179 nd4179 nd4830 4.547673038094e+00
RINT4180 nd4180 nd4831 4.547673038094e+00
RINT4181 nd4181 nd4832 4.547673038094e+00
RINT4182 nd4182 nd4833 4.547673038094e+00
RINT4183 nd4183 nd4834 4.547673038094e+00
RINT4184 nd4184 nd4835 4.547673038094e+00
RINT4185 nd4185 nd4836 7.310392023728e+00
RINT4186 nd4186 nd4837 6.312559451374e+00
RINT4187 nd4187 nd4838 6.312559451374e+00
RINT4188 nd4188 nd4839 3.662460579010e+02
RINT4189 nd4189 nd4840 1.299232040087e+01
RINT4190 nd4190 nd4841 1.308421413557e+01
RINT4191 nd4191 nd4842 1.308421413557e+01
RINT4192 nd4192 nd4843 3.883351253541e+03
RINT4193 nd4193 nd4844 6.126511232794e+02
RINT4194 nd4194 nd4845 1.068078026015e+03
RINT4195 nd4195 nd4846 1.068078026015e+03
RINT4196 nd4196 nd4847 1.068078026015e+03
RINT4197 nd4197 nd4848 1.068078026015e+03
RINT4198 nd4198 nd4849 1.068078026015e+03
RINT4199 nd4199 nd4850 1.068078026015e+03
RINT4200 nd4200 nd4851 1.068078026015e+03
RINT4201 nd4201 nd4852 2.333909041065e+02
RINT4202 nd4202 nd4853 2.341781857809e+02
RINT4203 nd4203 nd4854 6.841105382479e+02
RINT4204 nd4204 nd4855 4.920503704179e+01
RINT4205 nd4205 nd4856 1.091441529143e+03
RINT4206 nd4206 nd4857 4.547673038094e+00
RINT4207 nd4207 nd4858 4.547673038094e+00
RINT4208 nd4208 nd4859 4.547673038094e+00
RINT4209 nd4209 nd4860 4.547673038094e+00
RINT4210 nd4210 nd4861 4.547673038094e+00
RINT4211 nd4211 nd4862 4.547673038094e+00
RINT4212 nd4212 nd4863 4.547673038094e+00
RINT4213 nd4213 nd4864 4.547673038094e+00
RINT4214 nd4214 nd4865 4.547673038094e+00
RINT4215 nd4215 nd4866 4.547673038094e+00
RINT4216 nd4216 nd4867 6.999506028131e+01
RINT4217 nd4217 nd4868 6.044107865818e+01
RINT4218 nd4218 nd4869 6.044107865818e+01
RINT4219 nd4219 nd4870 3.506708643992e+03
RINT4220 nd4220 nd4871 1.243980140465e+02
RINT4221 nd4221 nd4872 1.252778721279e+02
RINT4222 nd4222 nd4873 1.252778721279e+02
RINT4223 nd4223 nd4874 3.265707031250e+05
RINT4224 nd4224 nd4875 5.442845052083e+04
RINT4225 nd4225 nd4876 9.330591517857e+04
RINT4226 nd4226 nd4877 9.330591517857e+04
RINT4227 nd4227 nd4878 9.330591517857e+04
RINT4228 nd4228 nd4879 9.330591517857e+04
RINT4229 nd4229 nd4880 9.330591517857e+04
RINT4230 nd4230 nd4881 9.330591517857e+04
RINT4231 nd4231 nd4882 9.330591517857e+04
RINT4232 nd4232 nd4883 2.073464781746e+04
RINT4233 nd4233 nd4884 2.073464781746e+04
RINT4234 nd4234 nd4885 6.550176544339e+03
RINT4235 nd4235 nd4886 4.711251493362e+02
RINT4236 nd4236 nd4887 1.045026250000e+04
RINT4237 nd4237 nd4888 4.354276041667e+01
RINT4238 nd4238 nd4889 4.354276041667e+01
RINT4239 nd4239 nd4890 4.354276041667e+01
RINT4240 nd4240 nd4891 4.354276041667e+01
RINT4241 nd4241 nd4892 4.354276041667e+01
RINT4242 nd4242 nd4893 4.354276041667e+01
RINT4243 nd4243 nd4894 4.354276041667e+01
RINT4244 nd4244 nd4895 4.354276041667e+01
RINT4245 nd4245 nd4896 4.354276041667e+01
RINT4246 nd4246 nd4897 4.354276041667e+01
RINT4247 nd4247 nd4898 7.310392023728e+00
RINT4248 nd4248 nd4899 6.312559451374e+00
RINT4249 nd4249 nd4900 6.312559451374e+00
RINT4250 nd4250 nd4901 3.662460579010e+02
RINT4251 nd4251 nd4902 1.299232040087e+01
RINT4252 nd4252 nd4903 1.308421413557e+01
RINT4253 nd4253 nd4904 1.308421413557e+01
RINT4254 nd4254 nd4905 3.883351253541e+03
RINT4255 nd4255 nd4906 6.126511232794e+02
RINT4256 nd4256 nd4907 1.068078026015e+03
RINT4257 nd4257 nd4908 1.068078026015e+03
RINT4258 nd4258 nd4909 1.068078026015e+03
RINT4259 nd4259 nd4910 1.068078026015e+03
RINT4260 nd4260 nd4911 1.068078026015e+03
RINT4261 nd4261 nd4912 1.068078026015e+03
RINT4262 nd4262 nd4913 1.068078026015e+03
RINT4263 nd4263 nd4914 2.333909041065e+02
RINT4264 nd4264 nd4915 2.341781857809e+02
RINT4265 nd4265 nd4916 6.841105382479e+02
RINT4266 nd4266 nd4917 4.920503704179e+01
RINT4267 nd4267 nd4918 1.091441529143e+03
RINT4268 nd4268 nd4919 4.547673038094e+00
RINT4269 nd4269 nd4920 4.547673038094e+00
RINT4270 nd4270 nd4921 4.547673038094e+00
RINT4271 nd4271 nd4922 4.547673038094e+00
RINT4272 nd4272 nd4923 4.547673038094e+00
RINT4273 nd4273 nd4924 4.547673038094e+00
RINT4274 nd4274 nd4925 4.547673038094e+00
RINT4275 nd4275 nd4926 4.547673038094e+00
RINT4276 nd4276 nd4927 4.547673038094e+00
RINT4277 nd4277 nd4928 4.547673038094e+00
RINT4278 nd4278 nd4929 7.310392023728e+00
RINT4279 nd4279 nd4930 6.312559451374e+00
RINT4280 nd4280 nd4931 6.312559451374e+00
RINT4281 nd4281 nd4932 3.662460579010e+02
RINT4282 nd4282 nd4933 1.299232040087e+01
RINT4283 nd4283 nd4934 1.308421413557e+01
RINT4284 nd4284 nd4935 1.308421413557e+01
RINT4285 nd4285 nd4936 3.883351253541e+03
RINT4286 nd4286 nd4937 6.126511232794e+02
RINT4287 nd4287 nd4938 1.068078026015e+03
RINT4288 nd4288 nd4939 1.068078026015e+03
RINT4289 nd4289 nd4940 1.068078026015e+03
RINT4290 nd4290 nd4941 1.068078026015e+03
RINT4291 nd4291 nd4942 1.068078026015e+03
RINT4292 nd4292 nd4943 1.068078026015e+03
RINT4293 nd4293 nd4944 1.068078026015e+03
RINT4294 nd4294 nd4945 2.333909041065e+02
RINT4295 nd4295 nd4946 2.341781857809e+02
RINT4296 nd4296 nd4947 6.841105382479e+02
RINT4297 nd4297 nd4948 4.920503704179e+01
RINT4298 nd4298 nd4949 1.091441529143e+03
RINT4299 nd4299 nd4950 4.547673038094e+00
RINT4300 nd4300 nd4951 4.547673038094e+00
RINT4301 nd4301 nd4952 4.547673038094e+00
RINT4302 nd4302 nd4953 4.547673038094e+00
RINT4303 nd4303 nd4954 4.547673038094e+00
RINT4304 nd4304 nd4955 4.547673038094e+00
RINT4305 nd4305 nd4956 4.547673038094e+00
RINT4306 nd4306 nd4957 4.547673038094e+00
RINT4307 nd4307 nd4958 4.547673038094e+00
RINT4308 nd4308 nd4959 4.547673038094e+00
RINT4309 nd4309 nd4960 7.310392023728e+00
RINT4310 nd4310 nd4961 6.312559451374e+00
RINT4311 nd4311 nd4962 6.312559451374e+00
RINT4312 nd4312 nd4963 3.662460579010e+02
RINT4313 nd4313 nd4964 1.299232040087e+01
RINT4314 nd4314 nd4965 1.308421413557e+01
RINT4315 nd4315 nd4966 1.308421413557e+01
RINT4316 nd4316 nd4967 3.883351253541e+03
RINT4317 nd4317 nd4968 6.126511232794e+02
RINT4318 nd4318 nd4969 1.068078026015e+03
RINT4319 nd4319 nd4970 1.068078026015e+03
RINT4320 nd4320 nd4971 1.068078026015e+03
RINT4321 nd4321 nd4972 1.068078026015e+03
RINT4322 nd4322 nd4973 1.068078026015e+03
RINT4323 nd4323 nd4974 1.068078026015e+03
RINT4324 nd4324 nd4975 1.068078026015e+03
RINT4325 nd4325 nd4976 2.333909041065e+02
RINT4326 nd4326 nd4977 2.341781857809e+02
RINT4327 nd4327 nd4978 6.841105382479e+02
RINT4328 nd4328 nd4979 4.920503704179e+01
RINT4329 nd4329 nd4980 1.091441529143e+03
RINT4330 nd4330 nd4981 4.547673038094e+00
RINT4331 nd4331 nd4982 4.547673038094e+00
RINT4332 nd4332 nd4983 4.547673038094e+00
RINT4333 nd4333 nd4984 4.547673038094e+00
RINT4334 nd4334 nd4985 4.547673038094e+00
RINT4335 nd4335 nd4986 4.547673038094e+00
RINT4336 nd4336 nd4987 4.547673038094e+00
RINT4337 nd4337 nd4988 4.547673038094e+00
RINT4338 nd4338 nd4989 4.547673038094e+00
RINT4339 nd4339 nd4990 4.547673038094e+00
RINT4340 nd4340 nd4991 7.310392023728e+00
RINT4341 nd4341 nd4992 6.312559451374e+00
RINT4342 nd4342 nd4993 6.312559451374e+00
RINT4343 nd4343 nd4994 3.662460579010e+02
RINT4344 nd4344 nd4995 1.299232040087e+01
RINT4345 nd4345 nd4996 1.308421413557e+01
RINT4346 nd4346 nd4997 1.308421413557e+01
RINT4347 nd4347 nd4998 3.883351253541e+03
RINT4348 nd4348 nd4999 6.126511232794e+02
RINT4349 nd4349 nd5000 1.068078026015e+03
RINT4350 nd4350 nd5001 1.068078026015e+03
RINT4351 nd4351 nd5002 1.068078026015e+03
RINT4352 nd4352 nd5003 1.068078026015e+03
RINT4353 nd4353 nd5004 1.068078026015e+03
RINT4354 nd4354 nd5005 1.068078026015e+03
RINT4355 nd4355 nd5006 1.068078026015e+03
RINT4356 nd4356 nd5007 2.333909041065e+02
RINT4357 nd4357 nd5008 2.341781857809e+02
RINT4358 nd4358 nd5009 6.841105382479e+02
RINT4359 nd4359 nd5010 4.920503704179e+01
RINT4360 nd4360 nd5011 1.091441529143e+03
RINT4361 nd4361 nd5012 4.547673038094e+00
RINT4362 nd4362 nd5013 4.547673038094e+00
RINT4363 nd4363 nd5014 4.547673038094e+00
RINT4364 nd4364 nd5015 4.547673038094e+00
RINT4365 nd4365 nd5016 4.547673038094e+00
RINT4366 nd4366 nd5017 4.547673038094e+00
RINT4367 nd4367 nd5018 4.547673038094e+00
RINT4368 nd4368 nd5019 4.547673038094e+00
RINT4369 nd4369 nd5020 4.547673038094e+00
RINT4370 nd4370 nd5021 4.547673038094e+00
RINT4371 nd4371 nd5022 7.310392023728e+00
RINT4372 nd4372 nd5023 6.312559451374e+00
RINT4373 nd4373 nd5024 6.312559451374e+00
RINT4374 nd4374 nd5025 3.662460579010e+02
RINT4375 nd4375 nd5026 1.299232040087e+01
RINT4376 nd4376 nd5027 1.308421413557e+01
RINT4377 nd4377 nd5028 1.308421413557e+01
RINT4378 nd4378 nd5029 3.883351253541e+03
RINT4379 nd4379 nd5030 6.126511232794e+02
RINT4380 nd4380 nd5031 1.068078026015e+03
RINT4381 nd4381 nd5032 1.068078026015e+03
RINT4382 nd4382 nd5033 1.068078026015e+03
RINT4383 nd4383 nd5034 1.068078026015e+03
RINT4384 nd4384 nd5035 1.068078026015e+03
RINT4385 nd4385 nd5036 1.068078026015e+03
RINT4386 nd4386 nd5037 1.068078026015e+03
RINT4387 nd4387 nd5038 2.333909041065e+02
RINT4388 nd4388 nd5039 2.341781857809e+02
RINT4389 nd4389 nd5040 6.841105382479e+02
RINT4390 nd4390 nd5041 4.920503704179e+01
RINT4391 nd4391 nd5042 1.091441529143e+03
RINT4392 nd4392 nd5043 4.547673038094e+00
RINT4393 nd4393 nd5044 4.547673038094e+00
RINT4394 nd4394 nd5045 4.547673038094e+00
RINT4395 nd4395 nd5046 4.547673038094e+00
RINT4396 nd4396 nd5047 4.547673038094e+00
RINT4397 nd4397 nd5048 4.547673038094e+00
RINT4398 nd4398 nd5049 4.547673038094e+00
RINT4399 nd4399 nd5050 4.547673038094e+00
RINT4400 nd4400 nd5051 4.547673038094e+00
RINT4401 nd4401 nd5052 4.547673038094e+00
RINT4402 nd4402 nd5053 7.310392023728e+00
RINT4403 nd4403 nd5054 6.312559451374e+00
RINT4404 nd4404 nd5055 6.312559451374e+00
RINT4405 nd4405 nd5056 3.662460579010e+02
RINT4406 nd4406 nd5057 1.299232040087e+01
RINT4407 nd4407 nd5058 1.308421413557e+01
RINT4408 nd4408 nd5059 1.308421413557e+01
RINT4409 nd4409 nd5060 3.883351253541e+03
RINT4410 nd4410 nd5061 6.126511232794e+02
RINT4411 nd4411 nd5062 1.068078026015e+03
RINT4412 nd4412 nd5063 1.068078026015e+03
RINT4413 nd4413 nd5064 1.068078026015e+03
RINT4414 nd4414 nd5065 1.068078026015e+03
RINT4415 nd4415 nd5066 1.068078026015e+03
RINT4416 nd4416 nd5067 1.068078026015e+03
RINT4417 nd4417 nd5068 1.068078026015e+03
RINT4418 nd4418 nd5069 2.333909041065e+02
RINT4419 nd4419 nd5070 2.341781857809e+02
RINT4420 nd4420 nd5071 6.841105382479e+02
RINT4421 nd4421 nd5072 4.920503704179e+01
RINT4422 nd4422 nd5073 1.091441529143e+03
RINT4423 nd4423 nd5074 4.547673038094e+00
RINT4424 nd4424 nd5075 4.547673038094e+00
RINT4425 nd4425 nd5076 4.547673038094e+00
RINT4426 nd4426 nd5077 4.547673038094e+00
RINT4427 nd4427 nd5078 4.547673038094e+00
RINT4428 nd4428 nd5079 4.547673038094e+00
RINT4429 nd4429 nd5080 4.547673038094e+00
RINT4430 nd4430 nd5081 4.547673038094e+00
RINT4431 nd4431 nd5082 4.547673038094e+00
RINT4432 nd4432 nd5083 4.547673038094e+00
RINT4433 nd4433 nd5084 6.999506028131e+01
RINT4434 nd4434 nd5085 6.044107865818e+01
RINT4435 nd4435 nd5086 6.044107865818e+01
RINT4436 nd4436 nd5087 3.506708643992e+03
RINT4437 nd4437 nd5088 1.243980140465e+02
RINT4438 nd4438 nd5089 1.252778721279e+02
RINT4439 nd4439 nd5090 1.252778721279e+02
RINT4440 nd4440 nd5091 3.265707031250e+05
RINT4441 nd4441 nd5092 5.442845052083e+04
RINT4442 nd4442 nd5093 9.330591517857e+04
RINT4443 nd4443 nd5094 9.330591517857e+04
RINT4444 nd4444 nd5095 9.330591517857e+04
RINT4445 nd4445 nd5096 9.330591517857e+04
RINT4446 nd4446 nd5097 9.330591517857e+04
RINT4447 nd4447 nd5098 9.330591517857e+04
RINT4448 nd4448 nd5099 9.330591517857e+04
RINT4449 nd4449 nd5100 2.073464781746e+04
RINT4450 nd4450 nd5101 2.073464781746e+04
RINT4451 nd4451 nd5102 6.550176544339e+03
RINT4452 nd4452 nd5103 4.711251493362e+02
RINT4453 nd4453 nd5104 1.045026250000e+04
RINT4454 nd4454 nd5105 4.354276041667e+01
RINT4455 nd4455 nd5106 4.354276041667e+01
RINT4456 nd4456 nd5107 4.354276041667e+01
RINT4457 nd4457 nd5108 4.354276041667e+01
RINT4458 nd4458 nd5109 4.354276041667e+01
RINT4459 nd4459 nd5110 4.354276041667e+01
RINT4460 nd4460 nd5111 4.354276041667e+01
RINT4461 nd4461 nd5112 4.354276041667e+01
RINT4462 nd4462 nd5113 4.354276041667e+01
RINT4463 nd4463 nd5114 4.354276041667e+01
RINT4464 nd4464 nd5115 9.521626084020e+00
RINT4465 nd4465 nd5116 8.221970933165e+00
RINT4466 nd4466 nd5117 8.221970933165e+00
RINT4467 nd4467 nd5118 4.770274982191e+02
RINT4468 nd4468 nd5119 1.692221380459e+01
RINT4469 nd4469 nd5120 1.704190338874e+01
RINT4470 nd4470 nd5121 1.704190338874e+01
RINT4471 nd4471 nd5122 6.769422734972e+02
RINT4472 nd4472 nd5123 1.128237122495e+02
RINT4473 nd4473 nd5124 1.934120781421e+02
RINT4474 nd4474 nd5125 1.934120781421e+02
RINT4475 nd4475 nd5126 1.934120781421e+02
RINT4476 nd4476 nd5127 1.934120781421e+02
RINT4477 nd4477 nd5128 1.934120781421e+02
RINT4478 nd4478 nd5129 1.934120781421e+02
RINT4479 nd4479 nd5130 1.934120781421e+02
RINT4480 nd4480 nd5131 4.298046180935e+01
RINT4481 nd4481 nd5132 4.298046180935e+01
RINT4482 nd4482 nd5133 8.910390474536e+02
RINT4483 nd4483 nd5134 6.408848699791e+01
RINT4484 nd4484 nd5135 1.421578774344e+03
RINT4485 nd4485 nd5136 5.923244893101e+00
RINT4486 nd4486 nd5137 5.923244893101e+00
RINT4487 nd4487 nd5138 5.923244893101e+00
RINT4488 nd4488 nd5139 5.923244893101e+00
RINT4489 nd4489 nd5140 5.923244893101e+00
RINT4490 nd4490 nd5141 5.923244893101e+00
RINT4491 nd4491 nd5142 5.923244893101e+00
RINT4492 nd4492 nd5143 5.923244893101e+00
RINT4493 nd4493 nd5144 5.923244893101e+00
RINT4494 nd4494 nd5145 5.923244893101e+00
RINT4495 nd4495 nd5146 9.521626084020e+00
RINT4496 nd4496 nd5147 8.221970933165e+00
RINT4497 nd4497 nd5148 8.221970933165e+00
RINT4498 nd4498 nd5149 4.770274982191e+02
RINT4499 nd4499 nd5150 1.692221380459e+01
RINT4500 nd4500 nd5151 1.704190338874e+01
RINT4501 nd4501 nd5152 1.704190338874e+01
RINT4502 nd4502 nd5153 6.769422734972e+02
RINT4503 nd4503 nd5154 1.128237122495e+02
RINT4504 nd4504 nd5155 1.934120781421e+02
RINT4505 nd4505 nd5156 1.934120781421e+02
RINT4506 nd4506 nd5157 1.934120781421e+02
RINT4507 nd4507 nd5158 1.934120781421e+02
RINT4508 nd4508 nd5159 1.934120781421e+02
RINT4509 nd4509 nd5160 1.934120781421e+02
RINT4510 nd4510 nd5161 1.934120781421e+02
RINT4511 nd4511 nd5162 4.298046180935e+01
RINT4512 nd4512 nd5163 4.298046180935e+01
RINT4513 nd4513 nd5164 8.910390474536e+02
RINT4514 nd4514 nd5165 6.408848699791e+01
RINT4515 nd4515 nd5166 1.421578774344e+03
RINT4516 nd4516 nd5167 5.923244893101e+00
RINT4517 nd4517 nd5168 5.923244893101e+00
RINT4518 nd4518 nd5169 5.923244893101e+00
RINT4519 nd4519 nd5170 5.923244893101e+00
RINT4520 nd4520 nd5171 5.923244893101e+00
RINT4521 nd4521 nd5172 5.923244893101e+00
RINT4522 nd4522 nd5173 5.923244893101e+00
RINT4523 nd4523 nd5174 5.923244893101e+00
RINT4524 nd4524 nd5175 5.923244893101e+00
RINT4525 nd4525 nd5176 5.923244893101e+00
RINT4526 nd4526 nd5177 9.521626084020e+00
RINT4527 nd4527 nd5178 8.221970933165e+00
RINT4528 nd4528 nd5179 8.221970933165e+00
RINT4529 nd4529 nd5180 4.770274982191e+02
RINT4530 nd4530 nd5181 1.692221380459e+01
RINT4531 nd4531 nd5182 1.704190338874e+01
RINT4532 nd4532 nd5183 1.704190338874e+01
RINT4533 nd4533 nd5184 6.769422734972e+02
RINT4534 nd4534 nd5185 1.128237122495e+02
RINT4535 nd4535 nd5186 1.934120781421e+02
RINT4536 nd4536 nd5187 1.934120781421e+02
RINT4537 nd4537 nd5188 1.934120781421e+02
RINT4538 nd4538 nd5189 1.934120781421e+02
RINT4539 nd4539 nd5190 1.934120781421e+02
RINT4540 nd4540 nd5191 1.934120781421e+02
RINT4541 nd4541 nd5192 1.934120781421e+02
RINT4542 nd4542 nd5193 4.298046180935e+01
RINT4543 nd4543 nd5194 4.298046180935e+01
RINT4544 nd4544 nd5195 8.910390474536e+02
RINT4545 nd4545 nd5196 6.408848699791e+01
RINT4546 nd4546 nd5197 1.421578774344e+03
RINT4547 nd4547 nd5198 5.923244893101e+00
RINT4548 nd4548 nd5199 5.923244893101e+00
RINT4549 nd4549 nd5200 5.923244893101e+00
RINT4550 nd4550 nd5201 5.923244893101e+00
RINT4551 nd4551 nd5202 5.923244893101e+00
RINT4552 nd4552 nd5203 5.923244893101e+00
RINT4553 nd4553 nd5204 5.923244893101e+00
RINT4554 nd4554 nd5205 5.923244893101e+00
RINT4555 nd4555 nd5206 5.923244893101e+00
RINT4556 nd4556 nd5207 5.923244893101e+00
RINT4557 nd4557 nd5208 1.722097716126e+01
RINT4558 nd4558 nd5209 1.487039843942e+01
RINT4559 nd4559 nd5210 1.487039843942e+01
RINT4560 nd4560 nd5211 8.627601608838e+02
RINT4561 nd4561 nd5212 3.060580775545e+01
RINT4562 nd4562 nd5213 3.082228040171e+01
RINT4563 nd4563 nd5214 3.082228040171e+01
RINT4564 nd4564 nd5215 1.224329471512e+03
RINT4565 nd4565 nd5216 2.040549119187e+02
RINT4566 nd4566 nd5217 3.498084204321e+02
RINT4567 nd4567 nd5218 3.498084204321e+02
RINT4568 nd4568 nd5219 3.498084204321e+02
RINT4569 nd4569 nd5220 3.498084204321e+02
RINT4570 nd4570 nd5221 3.498084204321e+02
RINT4571 nd4571 nd5222 3.498084204321e+02
RINT4572 nd4572 nd5223 3.498084204321e+02
RINT4573 nd4573 nd5224 7.773520454047e+01
RINT4574 nd4574 nd5225 7.773520454047e+01
RINT4575 nd4575 nd5226 1.611548589557e+03
RINT4576 nd4576 nd5227 1.159115429604e+02
RINT4577 nd4577 nd5228 2.571091890176e+03
RINT4578 nd4578 nd5229 1.071288287573e+01
RINT4579 nd4579 nd5230 1.071288287573e+01
RINT4580 nd4580 nd5231 1.071288287573e+01
RINT4581 nd4581 nd5232 1.071288287573e+01
RINT4582 nd4582 nd5233 1.071288287573e+01
RINT4583 nd4583 nd5234 1.071288287573e+01
RINT4584 nd4584 nd5235 1.071288287573e+01
RINT4585 nd4585 nd5236 1.071288287573e+01
RINT4586 nd4586 nd5237 1.071288287573e+01
RINT4587 nd4587 nd5238 1.071288287573e+01
RINT4588 nd4588 nd5239 1.722097716126e+01
RINT4589 nd4589 nd5240 1.487039843942e+01
RINT4590 nd4590 nd5241 1.487039843942e+01
RINT4591 nd4591 nd5242 8.627601608838e+02
RINT4592 nd4592 nd5243 3.060580775545e+01
RINT4593 nd4593 nd5244 3.082228040171e+01
RINT4594 nd4594 nd5245 3.082228040171e+01
RINT4595 nd4595 nd5246 1.224329471512e+03
RINT4596 nd4596 nd5247 2.040549119187e+02
RINT4597 nd4597 nd5248 3.498084204321e+02
RINT4598 nd4598 nd5249 3.498084204321e+02
RINT4599 nd4599 nd5250 3.498084204321e+02
RINT4600 nd4600 nd5251 3.498084204321e+02
RINT4601 nd4601 nd5252 3.498084204321e+02
RINT4602 nd4602 nd5253 3.498084204321e+02
RINT4603 nd4603 nd5254 3.498084204321e+02
RINT4604 nd4604 nd5255 7.773520454047e+01
RINT4605 nd4605 nd5256 7.773520454047e+01
RINT4606 nd4606 nd5257 1.611548589557e+03
RINT4607 nd4607 nd5258 1.159115429604e+02
RINT4608 nd4608 nd5259 2.571091890176e+03
RINT4609 nd4609 nd5260 1.071288287573e+01
RINT4610 nd4610 nd5261 1.071288287573e+01
RINT4611 nd4611 nd5262 1.071288287573e+01
RINT4612 nd4612 nd5263 1.071288287573e+01
RINT4613 nd4613 nd5264 1.071288287573e+01
RINT4614 nd4614 nd5265 1.071288287573e+01
RINT4615 nd4615 nd5266 1.071288287573e+01
RINT4616 nd4616 nd5267 1.071288287573e+01
RINT4617 nd4617 nd5268 1.071288287573e+01
RINT4618 nd4618 nd5269 1.071288287573e+01
RINT4619 nd4619 nd5270 1.722097716126e+01
RINT4620 nd4620 nd5271 1.487039843942e+01
RINT4621 nd4621 nd5272 1.487039843942e+01
RINT4622 nd4622 nd5273 8.627601608838e+02
RINT4623 nd4623 nd5274 3.060580775545e+01
RINT4624 nd4624 nd5275 3.082228040171e+01
RINT4625 nd4625 nd5276 3.082228040171e+01
RINT4626 nd4626 nd5277 1.224329471512e+03
RINT4627 nd4627 nd5278 2.040549119187e+02
RINT4628 nd4628 nd5279 3.498084204321e+02
RINT4629 nd4629 nd5280 3.498084204321e+02
RINT4630 nd4630 nd5281 3.498084204321e+02
RINT4631 nd4631 nd5282 3.498084204321e+02
RINT4632 nd4632 nd5283 3.498084204321e+02
RINT4633 nd4633 nd5284 3.498084204321e+02
RINT4634 nd4634 nd5285 3.498084204321e+02
RINT4635 nd4635 nd5286 7.773520454047e+01
RINT4636 nd4636 nd5287 7.773520454047e+01
RINT4637 nd4637 nd5288 1.611548589557e+03
RINT4638 nd4638 nd5289 1.159115429604e+02
RINT4639 nd4639 nd5290 2.571091890176e+03
RINT4640 nd4640 nd5291 1.071288287573e+01
RINT4641 nd4641 nd5292 1.071288287573e+01
RINT4642 nd4642 nd5293 1.071288287573e+01
RINT4643 nd4643 nd5294 1.071288287573e+01
RINT4644 nd4644 nd5295 1.071288287573e+01
RINT4645 nd4645 nd5296 1.071288287573e+01
RINT4646 nd4646 nd5297 1.071288287573e+01
RINT4647 nd4647 nd5298 1.071288287573e+01
RINT4648 nd4648 nd5299 1.071288287573e+01
RINT4649 nd4649 nd5300 1.071288287573e+01
RINT4650 nd4650 nd5301 1.265942732753e+02
RINT4651 nd4651 nd5302 1.093147773279e+02
RINT4652 nd4652 nd5303 1.093147773279e+02
RINT4653 nd4653 nd5304 6.342293736017e+03
RINT4654 nd4654 nd5305 2.249883937783e+02
RINT4655 nd4655 nd5306 2.265797202797e+02
RINT4656 nd4656 nd5307 2.265797202797e+02
RINT4657 nd4657 nd5308 5.906414062500e+05
RINT4658 nd4658 nd5309 9.844023437500e+04
RINT4659 nd4659 nd5310 1.687546875000e+05
RINT4660 nd4660 nd5311 1.687546875000e+05
RINT4661 nd4661 nd5312 1.687546875000e+05
RINT4662 nd4662 nd5313 1.687546875000e+05
RINT4663 nd4663 nd5314 1.687546875000e+05
RINT4664 nd4664 nd5315 1.687546875000e+05
RINT4665 nd4665 nd5316 1.687546875000e+05
RINT4666 nd4666 nd5317 3.750104166667e+04
RINT4667 nd4667 nd5318 3.750104166667e+04
RINT4668 nd4668 nd5319 1.184676227326e+04
RINT4669 nd4669 nd5320 8.520850708924e+02
RINT4670 nd4670 nd5321 1.890052500000e+04
RINT4671 nd4671 nd5322 7.875218750000e+01
RINT4672 nd4672 nd5323 7.875218750000e+01
RINT4673 nd4673 nd5324 7.875218750000e+01
RINT4674 nd4674 nd5325 7.875218750000e+01
RINT4675 nd4675 nd5326 7.875218750000e+01
RINT4676 nd4676 nd5327 7.875218750000e+01
RINT4677 nd4677 nd5328 7.875218750000e+01
RINT4678 nd4678 nd5329 7.875218750000e+01
RINT4679 nd4679 nd5330 7.875218750000e+01
RINT4680 nd4680 nd5331 7.875218750000e+01
RINT4681 nd4681 nd5332 1.322170110122e+01
RINT4682 nd4682 nd5333 1.141700390059e+01
RINT4683 nd4683 nd5334 1.141700390059e+01
RINT4684 nd4684 nd5335 6.623989372047e+02
RINT4685 nd4685 nd5336 2.349813476405e+01
RINT4686 nd4686 nd5337 2.366433535758e+01
RINT4687 nd4687 nd5338 2.366433535758e+01
RINT4688 nd4688 nd5339 1.239106136042e+03
RINT4689 nd4689 nd5340 1.373695180523e+02
RINT4690 nd4690 nd5341 2.711285174478e+02
RINT4691 nd4691 nd5342 2.711285174478e+02
RINT4692 nd4692 nd5343 2.711285174478e+02
RINT4693 nd4693 nd5344 2.711285174478e+02
RINT4694 nd4694 nd5345 2.711285174478e+02
RINT4695 nd4695 nd5346 2.711285174478e+02
RINT4696 nd4696 nd5347 2.711285174478e+02
RINT4697 nd4697 nd5348 5.233124497231e+01
RINT4698 nd4698 nd5349 5.390580832121e+01
RINT4699 nd4699 nd5350 1.237294118776e+03
RINT4700 nd4700 nd5351 8.899307866519e+01
RINT4701 nd4701 nd5352 1.973999974412e+03
RINT4702 nd4702 nd5353 8.224999893383e+00
RINT4703 nd4703 nd5354 8.224999893383e+00
RINT4704 nd4704 nd5355 8.224999893383e+00
RINT4705 nd4705 nd5356 8.224999893383e+00
RINT4706 nd4706 nd5357 8.224999893383e+00
RINT4707 nd4707 nd5358 8.224999893383e+00
RINT4708 nd4708 nd5359 8.224999893383e+00
RINT4709 nd4709 nd5360 8.224999893383e+00
RINT4710 nd4710 nd5361 8.224999893383e+00
RINT4711 nd4711 nd5362 8.224999893383e+00
RINT4712 nd4712 nd5363 1.322170110122e+01
RINT4713 nd4713 nd5364 1.141700390059e+01
RINT4714 nd4714 nd5365 1.141700390059e+01
RINT4715 nd4715 nd5366 6.623989372047e+02
RINT4716 nd4716 nd5367 2.349813476405e+01
RINT4717 nd4717 nd5368 2.366433535758e+01
RINT4718 nd4718 nd5369 2.366433535758e+01
RINT4719 nd4719 nd5370 1.239106136042e+03
RINT4720 nd4720 nd5371 1.373695180523e+02
RINT4721 nd4721 nd5372 2.711285174478e+02
RINT4722 nd4722 nd5373 2.711285174478e+02
RINT4723 nd4723 nd5374 2.711285174478e+02
RINT4724 nd4724 nd5375 2.711285174478e+02
RINT4725 nd4725 nd5376 2.711285174478e+02
RINT4726 nd4726 nd5377 2.711285174478e+02
RINT4727 nd4727 nd5378 2.711285174478e+02
RINT4728 nd4728 nd5379 5.233124497231e+01
RINT4729 nd4729 nd5380 5.390580832121e+01
RINT4730 nd4730 nd5381 1.237294118776e+03
RINT4731 nd4731 nd5382 8.899307866519e+01
RINT4732 nd4732 nd5383 1.973999974412e+03
RINT4733 nd4733 nd5384 8.224999893383e+00
RINT4734 nd4734 nd5385 8.224999893383e+00
RINT4735 nd4735 nd5386 8.224999893383e+00
RINT4736 nd4736 nd5387 8.224999893383e+00
RINT4737 nd4737 nd5388 8.224999893383e+00
RINT4738 nd4738 nd5389 8.224999893383e+00
RINT4739 nd4739 nd5390 8.224999893383e+00
RINT4740 nd4740 nd5391 8.224999893383e+00
RINT4741 nd4741 nd5392 8.224999893383e+00
RINT4742 nd4742 nd5393 8.224999893383e+00
RINT4743 nd4743 nd5394 1.322170110122e+01
RINT4744 nd4744 nd5395 1.141700390059e+01
RINT4745 nd4745 nd5396 1.141700390059e+01
RINT4746 nd4746 nd5397 6.623989372047e+02
RINT4747 nd4747 nd5398 2.349813476405e+01
RINT4748 nd4748 nd5399 2.366433535758e+01
RINT4749 nd4749 nd5400 2.366433535758e+01
RINT4750 nd4750 nd5401 1.239106136042e+03
RINT4751 nd4751 nd5402 1.373695180523e+02
RINT4752 nd4752 nd5403 2.711285174478e+02
RINT4753 nd4753 nd5404 2.711285174478e+02
RINT4754 nd4754 nd5405 2.711285174478e+02
RINT4755 nd4755 nd5406 2.711285174478e+02
RINT4756 nd4756 nd5407 2.711285174478e+02
RINT4757 nd4757 nd5408 2.711285174478e+02
RINT4758 nd4758 nd5409 2.711285174478e+02
RINT4759 nd4759 nd5410 5.233124497231e+01
RINT4760 nd4760 nd5411 5.390580832121e+01
RINT4761 nd4761 nd5412 1.237294118776e+03
RINT4762 nd4762 nd5413 8.899307866519e+01
RINT4763 nd4763 nd5414 1.973999974412e+03
RINT4764 nd4764 nd5415 8.224999893383e+00
RINT4765 nd4765 nd5416 8.224999893383e+00
RINT4766 nd4766 nd5417 8.224999893383e+00
RINT4767 nd4767 nd5418 8.224999893383e+00
RINT4768 nd4768 nd5419 8.224999893383e+00
RINT4769 nd4769 nd5420 8.224999893383e+00
RINT4770 nd4770 nd5421 8.224999893383e+00
RINT4771 nd4771 nd5422 8.224999893383e+00
RINT4772 nd4772 nd5423 8.224999893383e+00
RINT4773 nd4773 nd5424 8.224999893383e+00
RINT4774 nd4774 nd5425 1.322170110122e+01
RINT4775 nd4775 nd5426 1.141700390059e+01
RINT4776 nd4776 nd5427 1.141700390059e+01
RINT4777 nd4777 nd5428 6.623989372047e+02
RINT4778 nd4778 nd5429 2.349813476405e+01
RINT4779 nd4779 nd5430 2.366433535758e+01
RINT4780 nd4780 nd5431 2.366433535758e+01
RINT4781 nd4781 nd5432 1.239106136042e+03
RINT4782 nd4782 nd5433 1.373695180523e+02
RINT4783 nd4783 nd5434 2.711285174478e+02
RINT4784 nd4784 nd5435 2.711285174478e+02
RINT4785 nd4785 nd5436 2.711285174478e+02
RINT4786 nd4786 nd5437 2.711285174478e+02
RINT4787 nd4787 nd5438 2.711285174478e+02
RINT4788 nd4788 nd5439 2.711285174478e+02
RINT4789 nd4789 nd5440 2.711285174478e+02
RINT4790 nd4790 nd5441 5.233124497231e+01
RINT4791 nd4791 nd5442 5.390580832121e+01
RINT4792 nd4792 nd5443 1.237294118776e+03
RINT4793 nd4793 nd5444 8.899307866519e+01
RINT4794 nd4794 nd5445 1.973999974412e+03
RINT4795 nd4795 nd5446 8.224999893383e+00
RINT4796 nd4796 nd5447 8.224999893383e+00
RINT4797 nd4797 nd5448 8.224999893383e+00
RINT4798 nd4798 nd5449 8.224999893383e+00
RINT4799 nd4799 nd5450 8.224999893383e+00
RINT4800 nd4800 nd5451 8.224999893383e+00
RINT4801 nd4801 nd5452 8.224999893383e+00
RINT4802 nd4802 nd5453 8.224999893383e+00
RINT4803 nd4803 nd5454 8.224999893383e+00
RINT4804 nd4804 nd5455 8.224999893383e+00
RINT4805 nd4805 nd5456 1.322170110122e+01
RINT4806 nd4806 nd5457 1.141700390059e+01
RINT4807 nd4807 nd5458 1.141700390059e+01
RINT4808 nd4808 nd5459 6.623989372047e+02
RINT4809 nd4809 nd5460 2.349813476405e+01
RINT4810 nd4810 nd5461 2.366433535758e+01
RINT4811 nd4811 nd5462 2.366433535758e+01
RINT4812 nd4812 nd5463 1.239106136042e+03
RINT4813 nd4813 nd5464 1.373695180523e+02
RINT4814 nd4814 nd5465 2.711285174478e+02
RINT4815 nd4815 nd5466 2.711285174478e+02
RINT4816 nd4816 nd5467 2.711285174478e+02
RINT4817 nd4817 nd5468 2.711285174478e+02
RINT4818 nd4818 nd5469 2.711285174478e+02
RINT4819 nd4819 nd5470 2.711285174478e+02
RINT4820 nd4820 nd5471 2.711285174478e+02
RINT4821 nd4821 nd5472 5.233124497231e+01
RINT4822 nd4822 nd5473 5.390580832121e+01
RINT4823 nd4823 nd5474 1.237294118776e+03
RINT4824 nd4824 nd5475 8.899307866519e+01
RINT4825 nd4825 nd5476 1.973999974412e+03
RINT4826 nd4826 nd5477 8.224999893383e+00
RINT4827 nd4827 nd5478 8.224999893383e+00
RINT4828 nd4828 nd5479 8.224999893383e+00
RINT4829 nd4829 nd5480 8.224999893383e+00
RINT4830 nd4830 nd5481 8.224999893383e+00
RINT4831 nd4831 nd5482 8.224999893383e+00
RINT4832 nd4832 nd5483 8.224999893383e+00
RINT4833 nd4833 nd5484 8.224999893383e+00
RINT4834 nd4834 nd5485 8.224999893383e+00
RINT4835 nd4835 nd5486 8.224999893383e+00
RINT4836 nd4836 nd5487 1.322170110122e+01
RINT4837 nd4837 nd5488 1.141700390059e+01
RINT4838 nd4838 nd5489 1.141700390059e+01
RINT4839 nd4839 nd5490 6.623989372047e+02
RINT4840 nd4840 nd5491 2.349813476405e+01
RINT4841 nd4841 nd5492 2.366433535758e+01
RINT4842 nd4842 nd5493 2.366433535758e+01
RINT4843 nd4843 nd5494 1.239106136042e+03
RINT4844 nd4844 nd5495 1.373695180523e+02
RINT4845 nd4845 nd5496 2.711285174478e+02
RINT4846 nd4846 nd5497 2.711285174478e+02
RINT4847 nd4847 nd5498 2.711285174478e+02
RINT4848 nd4848 nd5499 2.711285174478e+02
RINT4849 nd4849 nd5500 2.711285174478e+02
RINT4850 nd4850 nd5501 2.711285174478e+02
RINT4851 nd4851 nd5502 2.711285174478e+02
RINT4852 nd4852 nd5503 5.233124497231e+01
RINT4853 nd4853 nd5504 5.390580832121e+01
RINT4854 nd4854 nd5505 1.237294118776e+03
RINT4855 nd4855 nd5506 8.899307866519e+01
RINT4856 nd4856 nd5507 1.973999974412e+03
RINT4857 nd4857 nd5508 8.224999893383e+00
RINT4858 nd4858 nd5509 8.224999893383e+00
RINT4859 nd4859 nd5510 8.224999893383e+00
RINT4860 nd4860 nd5511 8.224999893383e+00
RINT4861 nd4861 nd5512 8.224999893383e+00
RINT4862 nd4862 nd5513 8.224999893383e+00
RINT4863 nd4863 nd5514 8.224999893383e+00
RINT4864 nd4864 nd5515 8.224999893383e+00
RINT4865 nd4865 nd5516 8.224999893383e+00
RINT4866 nd4866 nd5517 8.224999893383e+00
RINT4867 nd4867 nd5518 1.265942732753e+02
RINT4868 nd4868 nd5519 1.093147773279e+02
RINT4869 nd4869 nd5520 1.093147773279e+02
RINT4870 nd4870 nd5521 6.342293736017e+03
RINT4871 nd4871 nd5522 2.249883937783e+02
RINT4872 nd4872 nd5523 2.265797202797e+02
RINT4873 nd4873 nd5524 2.265797202797e+02
RINT4874 nd4874 nd5525 5.906414062500e+05
RINT4875 nd4875 nd5526 9.844023437500e+04
RINT4876 nd4876 nd5527 1.687546875000e+05
RINT4877 nd4877 nd5528 1.687546875000e+05
RINT4878 nd4878 nd5529 1.687546875000e+05
RINT4879 nd4879 nd5530 1.687546875000e+05
RINT4880 nd4880 nd5531 1.687546875000e+05
RINT4881 nd4881 nd5532 1.687546875000e+05
RINT4882 nd4882 nd5533 1.687546875000e+05
RINT4883 nd4883 nd5534 3.750104166667e+04
RINT4884 nd4884 nd5535 3.750104166667e+04
RINT4885 nd4885 nd5536 1.184676227326e+04
RINT4886 nd4886 nd5537 8.520850708924e+02
RINT4887 nd4887 nd5538 1.890052500000e+04
RINT4888 nd4888 nd5539 7.875218750000e+01
RINT4889 nd4889 nd5540 7.875218750000e+01
RINT4890 nd4890 nd5541 7.875218750000e+01
RINT4891 nd4891 nd5542 7.875218750000e+01
RINT4892 nd4892 nd5543 7.875218750000e+01
RINT4893 nd4893 nd5544 7.875218750000e+01
RINT4894 nd4894 nd5545 7.875218750000e+01
RINT4895 nd4895 nd5546 7.875218750000e+01
RINT4896 nd4896 nd5547 7.875218750000e+01
RINT4897 nd4897 nd5548 7.875218750000e+01
RINT4898 nd4898 nd5549 1.322170110122e+01
RINT4899 nd4899 nd5550 1.141700390059e+01
RINT4900 nd4900 nd5551 1.141700390059e+01
RINT4901 nd4901 nd5552 6.623989372047e+02
RINT4902 nd4902 nd5553 2.349813476405e+01
RINT4903 nd4903 nd5554 2.366433535758e+01
RINT4904 nd4904 nd5555 2.366433535758e+01
RINT4905 nd4905 nd5556 1.239106136042e+03
RINT4906 nd4906 nd5557 1.373695180523e+02
RINT4907 nd4907 nd5558 2.711285174478e+02
RINT4908 nd4908 nd5559 2.711285174478e+02
RINT4909 nd4909 nd5560 2.711285174478e+02
RINT4910 nd4910 nd5561 2.711285174478e+02
RINT4911 nd4911 nd5562 2.711285174478e+02
RINT4912 nd4912 nd5563 2.711285174478e+02
RINT4913 nd4913 nd5564 2.711285174478e+02
RINT4914 nd4914 nd5565 5.233124497231e+01
RINT4915 nd4915 nd5566 5.390580832121e+01
RINT4916 nd4916 nd5567 1.237294118776e+03
RINT4917 nd4917 nd5568 8.899307866519e+01
RINT4918 nd4918 nd5569 1.973999974412e+03
RINT4919 nd4919 nd5570 8.224999893383e+00
RINT4920 nd4920 nd5571 8.224999893383e+00
RINT4921 nd4921 nd5572 8.224999893383e+00
RINT4922 nd4922 nd5573 8.224999893383e+00
RINT4923 nd4923 nd5574 8.224999893383e+00
RINT4924 nd4924 nd5575 8.224999893383e+00
RINT4925 nd4925 nd5576 8.224999893383e+00
RINT4926 nd4926 nd5577 8.224999893383e+00
RINT4927 nd4927 nd5578 8.224999893383e+00
RINT4928 nd4928 nd5579 8.224999893383e+00
RINT4929 nd4929 nd5580 1.322170110122e+01
RINT4930 nd4930 nd5581 1.141700390059e+01
RINT4931 nd4931 nd5582 1.141700390059e+01
RINT4932 nd4932 nd5583 6.623989372047e+02
RINT4933 nd4933 nd5584 2.349813476405e+01
RINT4934 nd4934 nd5585 2.366433535758e+01
RINT4935 nd4935 nd5586 2.366433535758e+01
RINT4936 nd4936 nd5587 1.239106136042e+03
RINT4937 nd4937 nd5588 1.373695180523e+02
RINT4938 nd4938 nd5589 2.711285174478e+02
RINT4939 nd4939 nd5590 2.711285174478e+02
RINT4940 nd4940 nd5591 2.711285174478e+02
RINT4941 nd4941 nd5592 2.711285174478e+02
RINT4942 nd4942 nd5593 2.711285174478e+02
RINT4943 nd4943 nd5594 2.711285174478e+02
RINT4944 nd4944 nd5595 2.711285174478e+02
RINT4945 nd4945 nd5596 5.233124497231e+01
RINT4946 nd4946 nd5597 5.390580832121e+01
RINT4947 nd4947 nd5598 1.237294118776e+03
RINT4948 nd4948 nd5599 8.899307866519e+01
RINT4949 nd4949 nd5600 1.973999974412e+03
RINT4950 nd4950 nd5601 8.224999893383e+00
RINT4951 nd4951 nd5602 8.224999893383e+00
RINT4952 nd4952 nd5603 8.224999893383e+00
RINT4953 nd4953 nd5604 8.224999893383e+00
RINT4954 nd4954 nd5605 8.224999893383e+00
RINT4955 nd4955 nd5606 8.224999893383e+00
RINT4956 nd4956 nd5607 8.224999893383e+00
RINT4957 nd4957 nd5608 8.224999893383e+00
RINT4958 nd4958 nd5609 8.224999893383e+00
RINT4959 nd4959 nd5610 8.224999893383e+00
RINT4960 nd4960 nd5611 1.322170110122e+01
RINT4961 nd4961 nd5612 1.141700390059e+01
RINT4962 nd4962 nd5613 1.141700390059e+01
RINT4963 nd4963 nd5614 6.623989372047e+02
RINT4964 nd4964 nd5615 2.349813476405e+01
RINT4965 nd4965 nd5616 2.366433535758e+01
RINT4966 nd4966 nd5617 2.366433535758e+01
RINT4967 nd4967 nd5618 1.239106136042e+03
RINT4968 nd4968 nd5619 1.373695180523e+02
RINT4969 nd4969 nd5620 2.711285174478e+02
RINT4970 nd4970 nd5621 2.711285174478e+02
RINT4971 nd4971 nd5622 2.711285174478e+02
RINT4972 nd4972 nd5623 2.711285174478e+02
RINT4973 nd4973 nd5624 2.711285174478e+02
RINT4974 nd4974 nd5625 2.711285174478e+02
RINT4975 nd4975 nd5626 2.711285174478e+02
RINT4976 nd4976 nd5627 5.233124497231e+01
RINT4977 nd4977 nd5628 5.390580832121e+01
RINT4978 nd4978 nd5629 1.237294118776e+03
RINT4979 nd4979 nd5630 8.899307866519e+01
RINT4980 nd4980 nd5631 1.973999974412e+03
RINT4981 nd4981 nd5632 8.224999893383e+00
RINT4982 nd4982 nd5633 8.224999893383e+00
RINT4983 nd4983 nd5634 8.224999893383e+00
RINT4984 nd4984 nd5635 8.224999893383e+00
RINT4985 nd4985 nd5636 8.224999893383e+00
RINT4986 nd4986 nd5637 8.224999893383e+00
RINT4987 nd4987 nd5638 8.224999893383e+00
RINT4988 nd4988 nd5639 8.224999893383e+00
RINT4989 nd4989 nd5640 8.224999893383e+00
RINT4990 nd4990 nd5641 8.224999893383e+00
RINT4991 nd4991 nd5642 1.322170110122e+01
RINT4992 nd4992 nd5643 1.141700390059e+01
RINT4993 nd4993 nd5644 1.141700390059e+01
RINT4994 nd4994 nd5645 6.623989372047e+02
RINT4995 nd4995 nd5646 2.349813476405e+01
RINT4996 nd4996 nd5647 2.366433535758e+01
RINT4997 nd4997 nd5648 2.366433535758e+01
RINT4998 nd4998 nd5649 1.239106136042e+03
RINT4999 nd4999 nd5650 1.373695180523e+02
RINT5000 nd5000 nd5651 2.711285174478e+02
RINT5001 nd5001 nd5652 2.711285174478e+02
RINT5002 nd5002 nd5653 2.711285174478e+02
RINT5003 nd5003 nd5654 2.711285174478e+02
RINT5004 nd5004 nd5655 2.711285174478e+02
RINT5005 nd5005 nd5656 2.711285174478e+02
RINT5006 nd5006 nd5657 2.711285174478e+02
RINT5007 nd5007 nd5658 5.233124497231e+01
RINT5008 nd5008 nd5659 5.390580832121e+01
RINT5009 nd5009 nd5660 1.237294118776e+03
RINT5010 nd5010 nd5661 8.899307866519e+01
RINT5011 nd5011 nd5662 1.973999974412e+03
RINT5012 nd5012 nd5663 8.224999893383e+00
RINT5013 nd5013 nd5664 8.224999893383e+00
RINT5014 nd5014 nd5665 8.224999893383e+00
RINT5015 nd5015 nd5666 8.224999893383e+00
RINT5016 nd5016 nd5667 8.224999893383e+00
RINT5017 nd5017 nd5668 8.224999893383e+00
RINT5018 nd5018 nd5669 8.224999893383e+00
RINT5019 nd5019 nd5670 8.224999893383e+00
RINT5020 nd5020 nd5671 8.224999893383e+00
RINT5021 nd5021 nd5672 8.224999893383e+00
RINT5022 nd5022 nd5673 1.322170110122e+01
RINT5023 nd5023 nd5674 1.141700390059e+01
RINT5024 nd5024 nd5675 1.141700390059e+01
RINT5025 nd5025 nd5676 6.623989372047e+02
RINT5026 nd5026 nd5677 2.349813476405e+01
RINT5027 nd5027 nd5678 2.366433535758e+01
RINT5028 nd5028 nd5679 2.366433535758e+01
RINT5029 nd5029 nd5680 1.239106136042e+03
RINT5030 nd5030 nd5681 1.373695180523e+02
RINT5031 nd5031 nd5682 2.711285174478e+02
RINT5032 nd5032 nd5683 2.711285174478e+02
RINT5033 nd5033 nd5684 2.711285174478e+02
RINT5034 nd5034 nd5685 2.711285174478e+02
RINT5035 nd5035 nd5686 2.711285174478e+02
RINT5036 nd5036 nd5687 2.711285174478e+02
RINT5037 nd5037 nd5688 2.711285174478e+02
RINT5038 nd5038 nd5689 5.233124497231e+01
RINT5039 nd5039 nd5690 5.390580832121e+01
RINT5040 nd5040 nd5691 1.237294118776e+03
RINT5041 nd5041 nd5692 8.899307866519e+01
RINT5042 nd5042 nd5693 1.973999974412e+03
RINT5043 nd5043 nd5694 8.224999893383e+00
RINT5044 nd5044 nd5695 8.224999893383e+00
RINT5045 nd5045 nd5696 8.224999893383e+00
RINT5046 nd5046 nd5697 8.224999893383e+00
RINT5047 nd5047 nd5698 8.224999893383e+00
RINT5048 nd5048 nd5699 8.224999893383e+00
RINT5049 nd5049 nd5700 8.224999893383e+00
RINT5050 nd5050 nd5701 8.224999893383e+00
RINT5051 nd5051 nd5702 8.224999893383e+00
RINT5052 nd5052 nd5703 8.224999893383e+00
RINT5053 nd5053 nd5704 1.322170110122e+01
RINT5054 nd5054 nd5705 1.141700390059e+01
RINT5055 nd5055 nd5706 1.141700390059e+01
RINT5056 nd5056 nd5707 6.623989372047e+02
RINT5057 nd5057 nd5708 2.349813476405e+01
RINT5058 nd5058 nd5709 2.366433535758e+01
RINT5059 nd5059 nd5710 2.366433535758e+01
RINT5060 nd5060 nd5711 1.239106136042e+03
RINT5061 nd5061 nd5712 1.373695180523e+02
RINT5062 nd5062 nd5713 2.711285174478e+02
RINT5063 nd5063 nd5714 2.711285174478e+02
RINT5064 nd5064 nd5715 2.711285174478e+02
RINT5065 nd5065 nd5716 2.711285174478e+02
RINT5066 nd5066 nd5717 2.711285174478e+02
RINT5067 nd5067 nd5718 2.711285174478e+02
RINT5068 nd5068 nd5719 2.711285174478e+02
RINT5069 nd5069 nd5720 5.233124497231e+01
RINT5070 nd5070 nd5721 5.390580832121e+01
RINT5071 nd5071 nd5722 1.237294118776e+03
RINT5072 nd5072 nd5723 8.899307866519e+01
RINT5073 nd5073 nd5724 1.973999974412e+03
RINT5074 nd5074 nd5725 8.224999893383e+00
RINT5075 nd5075 nd5726 8.224999893383e+00
RINT5076 nd5076 nd5727 8.224999893383e+00
RINT5077 nd5077 nd5728 8.224999893383e+00
RINT5078 nd5078 nd5729 8.224999893383e+00
RINT5079 nd5079 nd5730 8.224999893383e+00
RINT5080 nd5080 nd5731 8.224999893383e+00
RINT5081 nd5081 nd5732 8.224999893383e+00
RINT5082 nd5082 nd5733 8.224999893383e+00
RINT5083 nd5083 nd5734 8.224999893383e+00
RINT5084 nd5084 nd5735 1.265942732753e+02
RINT5085 nd5085 nd5736 1.093147773279e+02
RINT5086 nd5086 nd5737 1.093147773279e+02
RINT5087 nd5087 nd5738 6.342293736017e+03
RINT5088 nd5088 nd5739 2.249883937783e+02
RINT5089 nd5089 nd5740 2.265797202797e+02
RINT5090 nd5090 nd5741 2.265797202797e+02
RINT5091 nd5091 nd5742 5.906414062500e+05
RINT5092 nd5092 nd5743 9.844023437500e+04
RINT5093 nd5093 nd5744 1.687546875000e+05
RINT5094 nd5094 nd5745 1.687546875000e+05
RINT5095 nd5095 nd5746 1.687546875000e+05
RINT5096 nd5096 nd5747 1.687546875000e+05
RINT5097 nd5097 nd5748 1.687546875000e+05
RINT5098 nd5098 nd5749 1.687546875000e+05
RINT5099 nd5099 nd5750 1.687546875000e+05
RINT5100 nd5100 nd5751 3.750104166667e+04
RINT5101 nd5101 nd5752 3.750104166667e+04
RINT5102 nd5102 nd5753 1.184676227326e+04
RINT5103 nd5103 nd5754 8.520850708924e+02
RINT5104 nd5104 nd5755 1.890052500000e+04
RINT5105 nd5105 nd5756 7.875218750000e+01
RINT5106 nd5106 nd5757 7.875218750000e+01
RINT5107 nd5107 nd5758 7.875218750000e+01
RINT5108 nd5108 nd5759 7.875218750000e+01
RINT5109 nd5109 nd5760 7.875218750000e+01
RINT5110 nd5110 nd5761 7.875218750000e+01
RINT5111 nd5111 nd5762 7.875218750000e+01
RINT5112 nd5112 nd5763 7.875218750000e+01
RINT5113 nd5113 nd5764 7.875218750000e+01
RINT5114 nd5114 nd5765 7.875218750000e+01
RINT5115 nd5115 nd5766 1.722097716126e+01
RINT5116 nd5116 nd5767 1.487039843942e+01
RINT5117 nd5117 nd5768 1.487039843942e+01
RINT5118 nd5118 nd5769 8.627601608838e+02
RINT5119 nd5119 nd5770 3.060580775545e+01
RINT5120 nd5120 nd5771 3.082228040171e+01
RINT5121 nd5121 nd5772 3.082228040171e+01
RINT5122 nd5122 nd5773 1.224329471512e+03
RINT5123 nd5123 nd5774 2.040549119187e+02
RINT5124 nd5124 nd5775 3.498084204321e+02
RINT5125 nd5125 nd5776 3.498084204321e+02
RINT5126 nd5126 nd5777 3.498084204321e+02
RINT5127 nd5127 nd5778 3.498084204321e+02
RINT5128 nd5128 nd5779 3.498084204321e+02
RINT5129 nd5129 nd5780 3.498084204321e+02
RINT5130 nd5130 nd5781 3.498084204321e+02
RINT5131 nd5131 nd5782 7.773520454047e+01
RINT5132 nd5132 nd5783 7.773520454047e+01
RINT5133 nd5133 nd5784 1.611548589557e+03
RINT5134 nd5134 nd5785 1.159115429604e+02
RINT5135 nd5135 nd5786 2.571091890176e+03
RINT5136 nd5136 nd5787 1.071288287573e+01
RINT5137 nd5137 nd5788 1.071288287573e+01
RINT5138 nd5138 nd5789 1.071288287573e+01
RINT5139 nd5139 nd5790 1.071288287573e+01
RINT5140 nd5140 nd5791 1.071288287573e+01
RINT5141 nd5141 nd5792 1.071288287573e+01
RINT5142 nd5142 nd5793 1.071288287573e+01
RINT5143 nd5143 nd5794 1.071288287573e+01
RINT5144 nd5144 nd5795 1.071288287573e+01
RINT5145 nd5145 nd5796 1.071288287573e+01
RINT5146 nd5146 nd5797 1.722097716126e+01
RINT5147 nd5147 nd5798 1.487039843942e+01
RINT5148 nd5148 nd5799 1.487039843942e+01
RINT5149 nd5149 nd5800 8.627601608838e+02
RINT5150 nd5150 nd5801 3.060580775545e+01
RINT5151 nd5151 nd5802 3.082228040171e+01
RINT5152 nd5152 nd5803 3.082228040171e+01
RINT5153 nd5153 nd5804 1.224329471512e+03
RINT5154 nd5154 nd5805 2.040549119187e+02
RINT5155 nd5155 nd5806 3.498084204321e+02
RINT5156 nd5156 nd5807 3.498084204321e+02
RINT5157 nd5157 nd5808 3.498084204321e+02
RINT5158 nd5158 nd5809 3.498084204321e+02
RINT5159 nd5159 nd5810 3.498084204321e+02
RINT5160 nd5160 nd5811 3.498084204321e+02
RINT5161 nd5161 nd5812 3.498084204321e+02
RINT5162 nd5162 nd5813 7.773520454047e+01
RINT5163 nd5163 nd5814 7.773520454047e+01
RINT5164 nd5164 nd5815 1.611548589557e+03
RINT5165 nd5165 nd5816 1.159115429604e+02
RINT5166 nd5166 nd5817 2.571091890176e+03
RINT5167 nd5167 nd5818 1.071288287573e+01
RINT5168 nd5168 nd5819 1.071288287573e+01
RINT5169 nd5169 nd5820 1.071288287573e+01
RINT5170 nd5170 nd5821 1.071288287573e+01
RINT5171 nd5171 nd5822 1.071288287573e+01
RINT5172 nd5172 nd5823 1.071288287573e+01
RINT5173 nd5173 nd5824 1.071288287573e+01
RINT5174 nd5174 nd5825 1.071288287573e+01
RINT5175 nd5175 nd5826 1.071288287573e+01
RINT5176 nd5176 nd5827 1.071288287573e+01
RINT5177 nd5177 nd5828 1.722097716126e+01
RINT5178 nd5178 nd5829 1.487039843942e+01
RINT5179 nd5179 nd5830 1.487039843942e+01
RINT5180 nd5180 nd5831 8.627601608838e+02
RINT5181 nd5181 nd5832 3.060580775545e+01
RINT5182 nd5182 nd5833 3.082228040171e+01
RINT5183 nd5183 nd5834 3.082228040171e+01
RINT5184 nd5184 nd5835 1.224329471512e+03
RINT5185 nd5185 nd5836 2.040549119187e+02
RINT5186 nd5186 nd5837 3.498084204321e+02
RINT5187 nd5187 nd5838 3.498084204321e+02
RINT5188 nd5188 nd5839 3.498084204321e+02
RINT5189 nd5189 nd5840 3.498084204321e+02
RINT5190 nd5190 nd5841 3.498084204321e+02
RINT5191 nd5191 nd5842 3.498084204321e+02
RINT5192 nd5192 nd5843 3.498084204321e+02
RINT5193 nd5193 nd5844 7.773520454047e+01
RINT5194 nd5194 nd5845 7.773520454047e+01
RINT5195 nd5195 nd5846 1.611548589557e+03
RINT5196 nd5196 nd5847 1.159115429604e+02
RINT5197 nd5197 nd5848 2.571091890176e+03
RINT5198 nd5198 nd5849 1.071288287573e+01
RINT5199 nd5199 nd5850 1.071288287573e+01
RINT5200 nd5200 nd5851 1.071288287573e+01
RINT5201 nd5201 nd5852 1.071288287573e+01
RINT5202 nd5202 nd5853 1.071288287573e+01
RINT5203 nd5203 nd5854 1.071288287573e+01
RINT5204 nd5204 nd5855 1.071288287573e+01
RINT5205 nd5205 nd5856 1.071288287573e+01
RINT5206 nd5206 nd5857 1.071288287573e+01
RINT5207 nd5207 nd5858 1.071288287573e+01
RINT5208 nd5208 nd5859 1.722097716126e+01
RINT5209 nd5209 nd5860 1.487039843942e+01
RINT5210 nd5210 nd5861 1.487039843942e+01
RINT5211 nd5211 nd5862 8.627601608838e+02
RINT5212 nd5212 nd5863 3.060580775545e+01
RINT5213 nd5213 nd5864 3.082228040171e+01
RINT5214 nd5214 nd5865 3.082228040171e+01
RINT5215 nd5215 nd5866 1.224329471512e+03
RINT5216 nd5216 nd5867 2.040549119187e+02
RINT5217 nd5217 nd5868 3.498084204321e+02
RINT5218 nd5218 nd5869 3.498084204321e+02
RINT5219 nd5219 nd5870 3.498084204321e+02
RINT5220 nd5220 nd5871 3.498084204321e+02
RINT5221 nd5221 nd5872 3.498084204321e+02
RINT5222 nd5222 nd5873 3.498084204321e+02
RINT5223 nd5223 nd5874 3.498084204321e+02
RINT5224 nd5224 nd5875 7.773520454047e+01
RINT5225 nd5225 nd5876 7.773520454047e+01
RINT5226 nd5226 nd5877 1.611548589557e+03
RINT5227 nd5227 nd5878 1.159115429604e+02
RINT5228 nd5228 nd5879 2.571091890176e+03
RINT5229 nd5229 nd5880 1.071288287573e+01
RINT5230 nd5230 nd5881 1.071288287573e+01
RINT5231 nd5231 nd5882 1.071288287573e+01
RINT5232 nd5232 nd5883 1.071288287573e+01
RINT5233 nd5233 nd5884 1.071288287573e+01
RINT5234 nd5234 nd5885 1.071288287573e+01
RINT5235 nd5235 nd5886 1.071288287573e+01
RINT5236 nd5236 nd5887 1.071288287573e+01
RINT5237 nd5237 nd5888 1.071288287573e+01
RINT5238 nd5238 nd5889 1.071288287573e+01
RINT5239 nd5239 nd5890 1.722097716126e+01
RINT5240 nd5240 nd5891 1.487039843942e+01
RINT5241 nd5241 nd5892 1.487039843942e+01
RINT5242 nd5242 nd5893 8.627601608838e+02
RINT5243 nd5243 nd5894 3.060580775545e+01
RINT5244 nd5244 nd5895 3.082228040171e+01
RINT5245 nd5245 nd5896 3.082228040171e+01
RINT5246 nd5246 nd5897 1.224329471512e+03
RINT5247 nd5247 nd5898 2.040549119187e+02
RINT5248 nd5248 nd5899 3.498084204321e+02
RINT5249 nd5249 nd5900 3.498084204321e+02
RINT5250 nd5250 nd5901 3.498084204321e+02
RINT5251 nd5251 nd5902 3.498084204321e+02
RINT5252 nd5252 nd5903 3.498084204321e+02
RINT5253 nd5253 nd5904 3.498084204321e+02
RINT5254 nd5254 nd5905 3.498084204321e+02
RINT5255 nd5255 nd5906 7.773520454047e+01
RINT5256 nd5256 nd5907 7.773520454047e+01
RINT5257 nd5257 nd5908 1.611548589557e+03
RINT5258 nd5258 nd5909 1.159115429604e+02
RINT5259 nd5259 nd5910 2.571091890176e+03
RINT5260 nd5260 nd5911 1.071288287573e+01
RINT5261 nd5261 nd5912 1.071288287573e+01
RINT5262 nd5262 nd5913 1.071288287573e+01
RINT5263 nd5263 nd5914 1.071288287573e+01
RINT5264 nd5264 nd5915 1.071288287573e+01
RINT5265 nd5265 nd5916 1.071288287573e+01
RINT5266 nd5266 nd5917 1.071288287573e+01
RINT5267 nd5267 nd5918 1.071288287573e+01
RINT5268 nd5268 nd5919 1.071288287573e+01
RINT5269 nd5269 nd5920 1.071288287573e+01
RINT5270 nd5270 nd5921 1.722097716126e+01
RINT5271 nd5271 nd5922 1.487039843942e+01
RINT5272 nd5272 nd5923 1.487039843942e+01
RINT5273 nd5273 nd5924 8.627601608838e+02
RINT5274 nd5274 nd5925 3.060580775545e+01
RINT5275 nd5275 nd5926 3.082228040171e+01
RINT5276 nd5276 nd5927 3.082228040171e+01
RINT5277 nd5277 nd5928 1.224329471512e+03
RINT5278 nd5278 nd5929 2.040549119187e+02
RINT5279 nd5279 nd5930 3.498084204321e+02
RINT5280 nd5280 nd5931 3.498084204321e+02
RINT5281 nd5281 nd5932 3.498084204321e+02
RINT5282 nd5282 nd5933 3.498084204321e+02
RINT5283 nd5283 nd5934 3.498084204321e+02
RINT5284 nd5284 nd5935 3.498084204321e+02
RINT5285 nd5285 nd5936 3.498084204321e+02
RINT5286 nd5286 nd5937 7.773520454047e+01
RINT5287 nd5287 nd5938 7.773520454047e+01
RINT5288 nd5288 nd5939 1.611548589557e+03
RINT5289 nd5289 nd5940 1.159115429604e+02
RINT5290 nd5290 nd5941 2.571091890176e+03
RINT5291 nd5291 nd5942 1.071288287573e+01
RINT5292 nd5292 nd5943 1.071288287573e+01
RINT5293 nd5293 nd5944 1.071288287573e+01
RINT5294 nd5294 nd5945 1.071288287573e+01
RINT5295 nd5295 nd5946 1.071288287573e+01
RINT5296 nd5296 nd5947 1.071288287573e+01
RINT5297 nd5297 nd5948 1.071288287573e+01
RINT5298 nd5298 nd5949 1.071288287573e+01
RINT5299 nd5299 nd5950 1.071288287573e+01
RINT5300 nd5300 nd5951 1.071288287573e+01
RINT5301 nd5301 nd5952 1.265942732753e+02
RINT5302 nd5302 nd5953 1.093147773279e+02
RINT5303 nd5303 nd5954 1.093147773279e+02
RINT5304 nd5304 nd5955 6.342293736017e+03
RINT5305 nd5305 nd5956 2.249883937783e+02
RINT5306 nd5306 nd5957 2.265797202797e+02
RINT5307 nd5307 nd5958 2.265797202797e+02
RINT5308 nd5308 nd5959 5.906414062500e+05
RINT5309 nd5309 nd5960 9.844023437500e+04
RINT5310 nd5310 nd5961 1.687546875000e+05
RINT5311 nd5311 nd5962 1.687546875000e+05
RINT5312 nd5312 nd5963 1.687546875000e+05
RINT5313 nd5313 nd5964 1.687546875000e+05
RINT5314 nd5314 nd5965 1.687546875000e+05
RINT5315 nd5315 nd5966 1.687546875000e+05
RINT5316 nd5316 nd5967 1.687546875000e+05
RINT5317 nd5317 nd5968 3.750104166667e+04
RINT5318 nd5318 nd5969 3.750104166667e+04
RINT5319 nd5319 nd5970 1.184676227326e+04
RINT5320 nd5320 nd5971 8.520850708924e+02
RINT5321 nd5321 nd5972 1.890052500000e+04
RINT5322 nd5322 nd5973 7.875218750000e+01
RINT5323 nd5323 nd5974 7.875218750000e+01
RINT5324 nd5324 nd5975 7.875218750000e+01
RINT5325 nd5325 nd5976 7.875218750000e+01
RINT5326 nd5326 nd5977 7.875218750000e+01
RINT5327 nd5327 nd5978 7.875218750000e+01
RINT5328 nd5328 nd5979 7.875218750000e+01
RINT5329 nd5329 nd5980 7.875218750000e+01
RINT5330 nd5330 nd5981 7.875218750000e+01
RINT5331 nd5331 nd5982 7.875218750000e+01
RINT5332 nd5332 nd5983 1.322170110122e+01
RINT5333 nd5333 nd5984 1.141700390059e+01
RINT5334 nd5334 nd5985 1.141700390059e+01
RINT5335 nd5335 nd5986 6.623989372047e+02
RINT5336 nd5336 nd5987 2.349813476405e+01
RINT5337 nd5337 nd5988 2.366433535758e+01
RINT5338 nd5338 nd5989 2.366433535758e+01
RINT5339 nd5339 nd5990 1.239106136042e+03
RINT5340 nd5340 nd5991 1.373695180523e+02
RINT5341 nd5341 nd5992 2.711285174478e+02
RINT5342 nd5342 nd5993 2.711285174478e+02
RINT5343 nd5343 nd5994 2.711285174478e+02
RINT5344 nd5344 nd5995 2.711285174478e+02
RINT5345 nd5345 nd5996 2.711285174478e+02
RINT5346 nd5346 nd5997 2.711285174478e+02
RINT5347 nd5347 nd5998 2.711285174478e+02
RINT5348 nd5348 nd5999 5.233124497231e+01
RINT5349 nd5349 nd6000 5.390580832121e+01
RINT5350 nd5350 nd6001 1.237294118776e+03
RINT5351 nd5351 nd6002 8.899307866519e+01
RINT5352 nd5352 nd6003 1.973999974412e+03
RINT5353 nd5353 nd6004 8.224999893383e+00
RINT5354 nd5354 nd6005 8.224999893383e+00
RINT5355 nd5355 nd6006 8.224999893383e+00
RINT5356 nd5356 nd6007 8.224999893383e+00
RINT5357 nd5357 nd6008 8.224999893383e+00
RINT5358 nd5358 nd6009 8.224999893383e+00
RINT5359 nd5359 nd6010 8.224999893383e+00
RINT5360 nd5360 nd6011 8.224999893383e+00
RINT5361 nd5361 nd6012 8.224999893383e+00
RINT5362 nd5362 nd6013 8.224999893383e+00
RINT5363 nd5363 nd6014 1.322170110122e+01
RINT5364 nd5364 nd6015 1.141700390059e+01
RINT5365 nd5365 nd6016 1.141700390059e+01
RINT5366 nd5366 nd6017 6.623989372047e+02
RINT5367 nd5367 nd6018 2.349813476405e+01
RINT5368 nd5368 nd6019 2.366433535758e+01
RINT5369 nd5369 nd6020 2.366433535758e+01
RINT5370 nd5370 nd6021 1.239106136042e+03
RINT5371 nd5371 nd6022 1.373695180523e+02
RINT5372 nd5372 nd6023 2.711285174478e+02
RINT5373 nd5373 nd6024 2.711285174478e+02
RINT5374 nd5374 nd6025 2.711285174478e+02
RINT5375 nd5375 nd6026 2.711285174478e+02
RINT5376 nd5376 nd6027 2.711285174478e+02
RINT5377 nd5377 nd6028 2.711285174478e+02
RINT5378 nd5378 nd6029 2.711285174478e+02
RINT5379 nd5379 nd6030 5.233124497231e+01
RINT5380 nd5380 nd6031 5.390580832121e+01
RINT5381 nd5381 nd6032 1.237294118776e+03
RINT5382 nd5382 nd6033 8.899307866519e+01
RINT5383 nd5383 nd6034 1.973999974412e+03
RINT5384 nd5384 nd6035 8.224999893383e+00
RINT5385 nd5385 nd6036 8.224999893383e+00
RINT5386 nd5386 nd6037 8.224999893383e+00
RINT5387 nd5387 nd6038 8.224999893383e+00
RINT5388 nd5388 nd6039 8.224999893383e+00
RINT5389 nd5389 nd6040 8.224999893383e+00
RINT5390 nd5390 nd6041 8.224999893383e+00
RINT5391 nd5391 nd6042 8.224999893383e+00
RINT5392 nd5392 nd6043 8.224999893383e+00
RINT5393 nd5393 nd6044 8.224999893383e+00
RINT5394 nd5394 nd6045 1.322170110122e+01
RINT5395 nd5395 nd6046 1.141700390059e+01
RINT5396 nd5396 nd6047 1.141700390059e+01
RINT5397 nd5397 nd6048 6.623989372047e+02
RINT5398 nd5398 nd6049 2.349813476405e+01
RINT5399 nd5399 nd6050 2.366433535758e+01
RINT5400 nd5400 nd6051 2.366433535758e+01
RINT5401 nd5401 nd6052 1.239106136042e+03
RINT5402 nd5402 nd6053 1.373695180523e+02
RINT5403 nd5403 nd6054 2.711285174478e+02
RINT5404 nd5404 nd6055 2.711285174478e+02
RINT5405 nd5405 nd6056 2.711285174478e+02
RINT5406 nd5406 nd6057 2.711285174478e+02
RINT5407 nd5407 nd6058 2.711285174478e+02
RINT5408 nd5408 nd6059 2.711285174478e+02
RINT5409 nd5409 nd6060 2.711285174478e+02
RINT5410 nd5410 nd6061 5.233124497231e+01
RINT5411 nd5411 nd6062 5.390580832121e+01
RINT5412 nd5412 nd6063 1.237294118776e+03
RINT5413 nd5413 nd6064 8.899307866519e+01
RINT5414 nd5414 nd6065 1.973999974412e+03
RINT5415 nd5415 nd6066 8.224999893383e+00
RINT5416 nd5416 nd6067 8.224999893383e+00
RINT5417 nd5417 nd6068 8.224999893383e+00
RINT5418 nd5418 nd6069 8.224999893383e+00
RINT5419 nd5419 nd6070 8.224999893383e+00
RINT5420 nd5420 nd6071 8.224999893383e+00
RINT5421 nd5421 nd6072 8.224999893383e+00
RINT5422 nd5422 nd6073 8.224999893383e+00
RINT5423 nd5423 nd6074 8.224999893383e+00
RINT5424 nd5424 nd6075 8.224999893383e+00
RINT5425 nd5425 nd6076 1.322170110122e+01
RINT5426 nd5426 nd6077 1.141700390059e+01
RINT5427 nd5427 nd6078 1.141700390059e+01
RINT5428 nd5428 nd6079 6.623989372047e+02
RINT5429 nd5429 nd6080 2.349813476405e+01
RINT5430 nd5430 nd6081 2.366433535758e+01
RINT5431 nd5431 nd6082 2.366433535758e+01
RINT5432 nd5432 nd6083 1.239106136042e+03
RINT5433 nd5433 nd6084 1.373695180523e+02
RINT5434 nd5434 nd6085 2.711285174478e+02
RINT5435 nd5435 nd6086 2.711285174478e+02
RINT5436 nd5436 nd6087 2.711285174478e+02
RINT5437 nd5437 nd6088 2.711285174478e+02
RINT5438 nd5438 nd6089 2.711285174478e+02
RINT5439 nd5439 nd6090 2.711285174478e+02
RINT5440 nd5440 nd6091 2.711285174478e+02
RINT5441 nd5441 nd6092 5.233124497231e+01
RINT5442 nd5442 nd6093 5.390580832121e+01
RINT5443 nd5443 nd6094 1.237294118776e+03
RINT5444 nd5444 nd6095 8.899307866519e+01
RINT5445 nd5445 nd6096 1.973999974412e+03
RINT5446 nd5446 nd6097 8.224999893383e+00
RINT5447 nd5447 nd6098 8.224999893383e+00
RINT5448 nd5448 nd6099 8.224999893383e+00
RINT5449 nd5449 nd6100 8.224999893383e+00
RINT5450 nd5450 nd6101 8.224999893383e+00
RINT5451 nd5451 nd6102 8.224999893383e+00
RINT5452 nd5452 nd6103 8.224999893383e+00
RINT5453 nd5453 nd6104 8.224999893383e+00
RINT5454 nd5454 nd6105 8.224999893383e+00
RINT5455 nd5455 nd6106 8.224999893383e+00
RINT5456 nd5456 nd6107 1.322170110122e+01
RINT5457 nd5457 nd6108 1.141700390059e+01
RINT5458 nd5458 nd6109 1.141700390059e+01
RINT5459 nd5459 nd6110 6.623989372047e+02
RINT5460 nd5460 nd6111 2.349813476405e+01
RINT5461 nd5461 nd6112 2.366433535758e+01
RINT5462 nd5462 nd6113 2.366433535758e+01
RINT5463 nd5463 nd6114 1.239106136042e+03
RINT5464 nd5464 nd6115 1.373695180523e+02
RINT5465 nd5465 nd6116 2.711285174478e+02
RINT5466 nd5466 nd6117 2.711285174478e+02
RINT5467 nd5467 nd6118 2.711285174478e+02
RINT5468 nd5468 nd6119 2.711285174478e+02
RINT5469 nd5469 nd6120 2.711285174478e+02
RINT5470 nd5470 nd6121 2.711285174478e+02
RINT5471 nd5471 nd6122 2.711285174478e+02
RINT5472 nd5472 nd6123 5.233124497231e+01
RINT5473 nd5473 nd6124 5.390580832121e+01
RINT5474 nd5474 nd6125 1.237294118776e+03
RINT5475 nd5475 nd6126 8.899307866519e+01
RINT5476 nd5476 nd6127 1.973999974412e+03
RINT5477 nd5477 nd6128 8.224999893383e+00
RINT5478 nd5478 nd6129 8.224999893383e+00
RINT5479 nd5479 nd6130 8.224999893383e+00
RINT5480 nd5480 nd6131 8.224999893383e+00
RINT5481 nd5481 nd6132 8.224999893383e+00
RINT5482 nd5482 nd6133 8.224999893383e+00
RINT5483 nd5483 nd6134 8.224999893383e+00
RINT5484 nd5484 nd6135 8.224999893383e+00
RINT5485 nd5485 nd6136 8.224999893383e+00
RINT5486 nd5486 nd6137 8.224999893383e+00
RINT5487 nd5487 nd6138 1.322170110122e+01
RINT5488 nd5488 nd6139 1.141700390059e+01
RINT5489 nd5489 nd6140 1.141700390059e+01
RINT5490 nd5490 nd6141 6.623989372047e+02
RINT5491 nd5491 nd6142 2.349813476405e+01
RINT5492 nd5492 nd6143 2.366433535758e+01
RINT5493 nd5493 nd6144 2.366433535758e+01
RINT5494 nd5494 nd6145 1.239106136042e+03
RINT5495 nd5495 nd6146 1.373695180523e+02
RINT5496 nd5496 nd6147 2.711285174478e+02
RINT5497 nd5497 nd6148 2.711285174478e+02
RINT5498 nd5498 nd6149 2.711285174478e+02
RINT5499 nd5499 nd6150 2.711285174478e+02
RINT5500 nd5500 nd6151 2.711285174478e+02
RINT5501 nd5501 nd6152 2.711285174478e+02
RINT5502 nd5502 nd6153 2.711285174478e+02
RINT5503 nd5503 nd6154 5.233124497231e+01
RINT5504 nd5504 nd6155 5.390580832121e+01
RINT5505 nd5505 nd6156 1.237294118776e+03
RINT5506 nd5506 nd6157 8.899307866519e+01
RINT5507 nd5507 nd6158 1.973999974412e+03
RINT5508 nd5508 nd6159 8.224999893383e+00
RINT5509 nd5509 nd6160 8.224999893383e+00
RINT5510 nd5510 nd6161 8.224999893383e+00
RINT5511 nd5511 nd6162 8.224999893383e+00
RINT5512 nd5512 nd6163 8.224999893383e+00
RINT5513 nd5513 nd6164 8.224999893383e+00
RINT5514 nd5514 nd6165 8.224999893383e+00
RINT5515 nd5515 nd6166 8.224999893383e+00
RINT5516 nd5516 nd6167 8.224999893383e+00
RINT5517 nd5517 nd6168 8.224999893383e+00
RINT5518 nd5518 nd6169 1.265942732753e+02
RINT5519 nd5519 nd6170 1.093147773279e+02
RINT5520 nd5520 nd6171 1.093147773279e+02
RINT5521 nd5521 nd6172 6.342293736017e+03
RINT5522 nd5522 nd6173 2.249883937783e+02
RINT5523 nd5523 nd6174 2.265797202797e+02
RINT5524 nd5524 nd6175 2.265797202797e+02
RINT5525 nd5525 nd6176 5.906414062500e+05
RINT5526 nd5526 nd6177 9.844023437500e+04
RINT5527 nd5527 nd6178 1.687546875000e+05
RINT5528 nd5528 nd6179 1.687546875000e+05
RINT5529 nd5529 nd6180 1.687546875000e+05
RINT5530 nd5530 nd6181 1.687546875000e+05
RINT5531 nd5531 nd6182 1.687546875000e+05
RINT5532 nd5532 nd6183 1.687546875000e+05
RINT5533 nd5533 nd6184 1.687546875000e+05
RINT5534 nd5534 nd6185 3.750104166667e+04
RINT5535 nd5535 nd6186 3.750104166667e+04
RINT5536 nd5536 nd6187 1.184676227326e+04
RINT5537 nd5537 nd6188 8.520850708924e+02
RINT5538 nd5538 nd6189 1.890052500000e+04
RINT5539 nd5539 nd6190 7.875218750000e+01
RINT5540 nd5540 nd6191 7.875218750000e+01
RINT5541 nd5541 nd6192 7.875218750000e+01
RINT5542 nd5542 nd6193 7.875218750000e+01
RINT5543 nd5543 nd6194 7.875218750000e+01
RINT5544 nd5544 nd6195 7.875218750000e+01
RINT5545 nd5545 nd6196 7.875218750000e+01
RINT5546 nd5546 nd6197 7.875218750000e+01
RINT5547 nd5547 nd6198 7.875218750000e+01
RINT5548 nd5548 nd6199 7.875218750000e+01
RINT5549 nd5549 nd6200 1.322170110122e+01
RINT5550 nd5550 nd6201 1.141700390059e+01
RINT5551 nd5551 nd6202 1.141700390059e+01
RINT5552 nd5552 nd6203 6.623989372047e+02
RINT5553 nd5553 nd6204 2.349813476405e+01
RINT5554 nd5554 nd6205 2.366433535758e+01
RINT5555 nd5555 nd6206 2.366433535758e+01
RINT5556 nd5556 nd6207 1.239106136042e+03
RINT5557 nd5557 nd6208 1.373695180523e+02
RINT5558 nd5558 nd6209 2.711285174478e+02
RINT5559 nd5559 nd6210 2.711285174478e+02
RINT5560 nd5560 nd6211 2.711285174478e+02
RINT5561 nd5561 nd6212 2.711285174478e+02
RINT5562 nd5562 nd6213 2.711285174478e+02
RINT5563 nd5563 nd6214 2.711285174478e+02
RINT5564 nd5564 nd6215 2.711285174478e+02
RINT5565 nd5565 nd6216 5.233124497231e+01
RINT5566 nd5566 nd6217 5.390580832121e+01
RINT5567 nd5567 nd6218 1.237294118776e+03
RINT5568 nd5568 nd6219 8.899307866519e+01
RINT5569 nd5569 nd6220 1.973999974412e+03
RINT5570 nd5570 nd6221 8.224999893383e+00
RINT5571 nd5571 nd6222 8.224999893383e+00
RINT5572 nd5572 nd6223 8.224999893383e+00
RINT5573 nd5573 nd6224 8.224999893383e+00
RINT5574 nd5574 nd6225 8.224999893383e+00
RINT5575 nd5575 nd6226 8.224999893383e+00
RINT5576 nd5576 nd6227 8.224999893383e+00
RINT5577 nd5577 nd6228 8.224999893383e+00
RINT5578 nd5578 nd6229 8.224999893383e+00
RINT5579 nd5579 nd6230 8.224999893383e+00
RINT5580 nd5580 nd6231 1.322170110122e+01
RINT5581 nd5581 nd6232 1.141700390059e+01
RINT5582 nd5582 nd6233 1.141700390059e+01
RINT5583 nd5583 nd6234 6.623989372047e+02
RINT5584 nd5584 nd6235 2.349813476405e+01
RINT5585 nd5585 nd6236 2.366433535758e+01
RINT5586 nd5586 nd6237 2.366433535758e+01
RINT5587 nd5587 nd6238 1.239106136042e+03
RINT5588 nd5588 nd6239 1.373695180523e+02
RINT5589 nd5589 nd6240 2.711285174478e+02
RINT5590 nd5590 nd6241 2.711285174478e+02
RINT5591 nd5591 nd6242 2.711285174478e+02
RINT5592 nd5592 nd6243 2.711285174478e+02
RINT5593 nd5593 nd6244 2.711285174478e+02
RINT5594 nd5594 nd6245 2.711285174478e+02
RINT5595 nd5595 nd6246 2.711285174478e+02
RINT5596 nd5596 nd6247 5.233124497231e+01
RINT5597 nd5597 nd6248 5.390580832121e+01
RINT5598 nd5598 nd6249 1.237294118776e+03
RINT5599 nd5599 nd6250 8.899307866519e+01
RINT5600 nd5600 nd6251 1.973999974412e+03
RINT5601 nd5601 nd6252 8.224999893383e+00
RINT5602 nd5602 nd6253 8.224999893383e+00
RINT5603 nd5603 nd6254 8.224999893383e+00
RINT5604 nd5604 nd6255 8.224999893383e+00
RINT5605 nd5605 nd6256 8.224999893383e+00
RINT5606 nd5606 nd6257 8.224999893383e+00
RINT5607 nd5607 nd6258 8.224999893383e+00
RINT5608 nd5608 nd6259 8.224999893383e+00
RINT5609 nd5609 nd6260 8.224999893383e+00
RINT5610 nd5610 nd6261 8.224999893383e+00
RINT5611 nd5611 nd6262 1.322170110122e+01
RINT5612 nd5612 nd6263 1.141700390059e+01
RINT5613 nd5613 nd6264 1.141700390059e+01
RINT5614 nd5614 nd6265 6.623989372047e+02
RINT5615 nd5615 nd6266 2.349813476405e+01
RINT5616 nd5616 nd6267 2.366433535758e+01
RINT5617 nd5617 nd6268 2.366433535758e+01
RINT5618 nd5618 nd6269 1.239106136042e+03
RINT5619 nd5619 nd6270 1.373695180523e+02
RINT5620 nd5620 nd6271 2.711285174478e+02
RINT5621 nd5621 nd6272 2.711285174478e+02
RINT5622 nd5622 nd6273 2.711285174478e+02
RINT5623 nd5623 nd6274 2.711285174478e+02
RINT5624 nd5624 nd6275 2.711285174478e+02
RINT5625 nd5625 nd6276 2.711285174478e+02
RINT5626 nd5626 nd6277 2.711285174478e+02
RINT5627 nd5627 nd6278 5.233124497231e+01
RINT5628 nd5628 nd6279 5.390580832121e+01
RINT5629 nd5629 nd6280 1.237294118776e+03
RINT5630 nd5630 nd6281 8.899307866519e+01
RINT5631 nd5631 nd6282 1.973999974412e+03
RINT5632 nd5632 nd6283 8.224999893383e+00
RINT5633 nd5633 nd6284 8.224999893383e+00
RINT5634 nd5634 nd6285 8.224999893383e+00
RINT5635 nd5635 nd6286 8.224999893383e+00
RINT5636 nd5636 nd6287 8.224999893383e+00
RINT5637 nd5637 nd6288 8.224999893383e+00
RINT5638 nd5638 nd6289 8.224999893383e+00
RINT5639 nd5639 nd6290 8.224999893383e+00
RINT5640 nd5640 nd6291 8.224999893383e+00
RINT5641 nd5641 nd6292 8.224999893383e+00
RINT5642 nd5642 nd6293 1.322170110122e+01
RINT5643 nd5643 nd6294 1.141700390059e+01
RINT5644 nd5644 nd6295 1.141700390059e+01
RINT5645 nd5645 nd6296 6.623989372047e+02
RINT5646 nd5646 nd6297 2.349813476405e+01
RINT5647 nd5647 nd6298 2.366433535758e+01
RINT5648 nd5648 nd6299 2.366433535758e+01
RINT5649 nd5649 nd6300 1.239106136042e+03
RINT5650 nd5650 nd6301 1.373695180523e+02
RINT5651 nd5651 nd6302 2.711285174478e+02
RINT5652 nd5652 nd6303 2.711285174478e+02
RINT5653 nd5653 nd6304 2.711285174478e+02
RINT5654 nd5654 nd6305 2.711285174478e+02
RINT5655 nd5655 nd6306 2.711285174478e+02
RINT5656 nd5656 nd6307 2.711285174478e+02
RINT5657 nd5657 nd6308 2.711285174478e+02
RINT5658 nd5658 nd6309 5.233124497231e+01
RINT5659 nd5659 nd6310 5.390580832121e+01
RINT5660 nd5660 nd6311 1.237294118776e+03
RINT5661 nd5661 nd6312 8.899307866519e+01
RINT5662 nd5662 nd6313 1.973999974412e+03
RINT5663 nd5663 nd6314 8.224999893383e+00
RINT5664 nd5664 nd6315 8.224999893383e+00
RINT5665 nd5665 nd6316 8.224999893383e+00
RINT5666 nd5666 nd6317 8.224999893383e+00
RINT5667 nd5667 nd6318 8.224999893383e+00
RINT5668 nd5668 nd6319 8.224999893383e+00
RINT5669 nd5669 nd6320 8.224999893383e+00
RINT5670 nd5670 nd6321 8.224999893383e+00
RINT5671 nd5671 nd6322 8.224999893383e+00
RINT5672 nd5672 nd6323 8.224999893383e+00
RINT5673 nd5673 nd6324 1.322170110122e+01
RINT5674 nd5674 nd6325 1.141700390059e+01
RINT5675 nd5675 nd6326 1.141700390059e+01
RINT5676 nd5676 nd6327 6.623989372047e+02
RINT5677 nd5677 nd6328 2.349813476405e+01
RINT5678 nd5678 nd6329 2.366433535758e+01
RINT5679 nd5679 nd6330 2.366433535758e+01
RINT5680 nd5680 nd6331 1.239106136042e+03
RINT5681 nd5681 nd6332 1.373695180523e+02
RINT5682 nd5682 nd6333 2.711285174478e+02
RINT5683 nd5683 nd6334 2.711285174478e+02
RINT5684 nd5684 nd6335 2.711285174478e+02
RINT5685 nd5685 nd6336 2.711285174478e+02
RINT5686 nd5686 nd6337 2.711285174478e+02
RINT5687 nd5687 nd6338 2.711285174478e+02
RINT5688 nd5688 nd6339 2.711285174478e+02
RINT5689 nd5689 nd6340 5.233124497231e+01
RINT5690 nd5690 nd6341 5.390580832121e+01
RINT5691 nd5691 nd6342 1.237294118776e+03
RINT5692 nd5692 nd6343 8.899307866519e+01
RINT5693 nd5693 nd6344 1.973999974412e+03
RINT5694 nd5694 nd6345 8.224999893383e+00
RINT5695 nd5695 nd6346 8.224999893383e+00
RINT5696 nd5696 nd6347 8.224999893383e+00
RINT5697 nd5697 nd6348 8.224999893383e+00
RINT5698 nd5698 nd6349 8.224999893383e+00
RINT5699 nd5699 nd6350 8.224999893383e+00
RINT5700 nd5700 nd6351 8.224999893383e+00
RINT5701 nd5701 nd6352 8.224999893383e+00
RINT5702 nd5702 nd6353 8.224999893383e+00
RINT5703 nd5703 nd6354 8.224999893383e+00
RINT5704 nd5704 nd6355 1.322170110122e+01
RINT5705 nd5705 nd6356 1.141700390059e+01
RINT5706 nd5706 nd6357 1.141700390059e+01
RINT5707 nd5707 nd6358 6.623989372047e+02
RINT5708 nd5708 nd6359 2.349813476405e+01
RINT5709 nd5709 nd6360 2.366433535758e+01
RINT5710 nd5710 nd6361 2.366433535758e+01
RINT5711 nd5711 nd6362 1.239106136042e+03
RINT5712 nd5712 nd6363 1.373695180523e+02
RINT5713 nd5713 nd6364 2.711285174478e+02
RINT5714 nd5714 nd6365 2.711285174478e+02
RINT5715 nd5715 nd6366 2.711285174478e+02
RINT5716 nd5716 nd6367 2.711285174478e+02
RINT5717 nd5717 nd6368 2.711285174478e+02
RINT5718 nd5718 nd6369 2.711285174478e+02
RINT5719 nd5719 nd6370 2.711285174478e+02
RINT5720 nd5720 nd6371 5.233124497231e+01
RINT5721 nd5721 nd6372 5.390580832121e+01
RINT5722 nd5722 nd6373 1.237294118776e+03
RINT5723 nd5723 nd6374 8.899307866519e+01
RINT5724 nd5724 nd6375 1.973999974412e+03
RINT5725 nd5725 nd6376 8.224999893383e+00
RINT5726 nd5726 nd6377 8.224999893383e+00
RINT5727 nd5727 nd6378 8.224999893383e+00
RINT5728 nd5728 nd6379 8.224999893383e+00
RINT5729 nd5729 nd6380 8.224999893383e+00
RINT5730 nd5730 nd6381 8.224999893383e+00
RINT5731 nd5731 nd6382 8.224999893383e+00
RINT5732 nd5732 nd6383 8.224999893383e+00
RINT5733 nd5733 nd6384 8.224999893383e+00
RINT5734 nd5734 nd6385 8.224999893383e+00
RINT5735 nd5735 nd6386 1.265942732753e+02
RINT5736 nd5736 nd6387 1.093147773279e+02
RINT5737 nd5737 nd6388 1.093147773279e+02
RINT5738 nd5738 nd6389 6.342293736017e+03
RINT5739 nd5739 nd6390 2.249883937783e+02
RINT5740 nd5740 nd6391 2.265797202797e+02
RINT5741 nd5741 nd6392 2.265797202797e+02
RINT5742 nd5742 nd6393 5.906414062500e+05
RINT5743 nd5743 nd6394 9.844023437500e+04
RINT5744 nd5744 nd6395 1.687546875000e+05
RINT5745 nd5745 nd6396 1.687546875000e+05
RINT5746 nd5746 nd6397 1.687546875000e+05
RINT5747 nd5747 nd6398 1.687546875000e+05
RINT5748 nd5748 nd6399 1.687546875000e+05
RINT5749 nd5749 nd6400 1.687546875000e+05
RINT5750 nd5750 nd6401 1.687546875000e+05
RINT5751 nd5751 nd6402 3.750104166667e+04
RINT5752 nd5752 nd6403 3.750104166667e+04
RINT5753 nd5753 nd6404 1.184676227326e+04
RINT5754 nd5754 nd6405 8.520850708924e+02
RINT5755 nd5755 nd6406 1.890052500000e+04
RINT5756 nd5756 nd6407 7.875218750000e+01
RINT5757 nd5757 nd6408 7.875218750000e+01
RINT5758 nd5758 nd6409 7.875218750000e+01
RINT5759 nd5759 nd6410 7.875218750000e+01
RINT5760 nd5760 nd6411 7.875218750000e+01
RINT5761 nd5761 nd6412 7.875218750000e+01
RINT5762 nd5762 nd6413 7.875218750000e+01
RINT5763 nd5763 nd6414 7.875218750000e+01
RINT5764 nd5764 nd6415 7.875218750000e+01
RINT5765 nd5765 nd6416 7.875218750000e+01
RINT5766 nd5766 nd6417 1.722097716126e+01
RINT5767 nd5767 nd6418 1.487039843942e+01
RINT5768 nd5768 nd6419 1.487039843942e+01
RINT5769 nd5769 nd6420 8.627601608838e+02
RINT5770 nd5770 nd6421 3.060580775545e+01
RINT5771 nd5771 nd6422 3.082228040171e+01
RINT5772 nd5772 nd6423 3.082228040171e+01
RINT5773 nd5773 nd6424 1.224329471512e+03
RINT5774 nd5774 nd6425 2.040549119187e+02
RINT5775 nd5775 nd6426 3.498084204321e+02
RINT5776 nd5776 nd6427 3.498084204321e+02
RINT5777 nd5777 nd6428 3.498084204321e+02
RINT5778 nd5778 nd6429 3.498084204321e+02
RINT5779 nd5779 nd6430 3.498084204321e+02
RINT5780 nd5780 nd6431 3.498084204321e+02
RINT5781 nd5781 nd6432 3.498084204321e+02
RINT5782 nd5782 nd6433 7.773520454047e+01
RINT5783 nd5783 nd6434 7.773520454047e+01
RINT5784 nd5784 nd6435 1.611548589557e+03
RINT5785 nd5785 nd6436 1.159115429604e+02
RINT5786 nd5786 nd6437 2.571091890176e+03
RINT5787 nd5787 nd6438 1.071288287573e+01
RINT5788 nd5788 nd6439 1.071288287573e+01
RINT5789 nd5789 nd6440 1.071288287573e+01
RINT5790 nd5790 nd6441 1.071288287573e+01
RINT5791 nd5791 nd6442 1.071288287573e+01
RINT5792 nd5792 nd6443 1.071288287573e+01
RINT5793 nd5793 nd6444 1.071288287573e+01
RINT5794 nd5794 nd6445 1.071288287573e+01
RINT5795 nd5795 nd6446 1.071288287573e+01
RINT5796 nd5796 nd6447 1.071288287573e+01
RINT5797 nd5797 nd6448 1.722097716126e+01
RINT5798 nd5798 nd6449 1.487039843942e+01
RINT5799 nd5799 nd6450 1.487039843942e+01
RINT5800 nd5800 nd6451 8.627601608838e+02
RINT5801 nd5801 nd6452 3.060580775545e+01
RINT5802 nd5802 nd6453 3.082228040171e+01
RINT5803 nd5803 nd6454 3.082228040171e+01
RINT5804 nd5804 nd6455 1.224329471512e+03
RINT5805 nd5805 nd6456 2.040549119187e+02
RINT5806 nd5806 nd6457 3.498084204321e+02
RINT5807 nd5807 nd6458 3.498084204321e+02
RINT5808 nd5808 nd6459 3.498084204321e+02
RINT5809 nd5809 nd6460 3.498084204321e+02
RINT5810 nd5810 nd6461 3.498084204321e+02
RINT5811 nd5811 nd6462 3.498084204321e+02
RINT5812 nd5812 nd6463 3.498084204321e+02
RINT5813 nd5813 nd6464 7.773520454047e+01
RINT5814 nd5814 nd6465 7.773520454047e+01
RINT5815 nd5815 nd6466 1.611548589557e+03
RINT5816 nd5816 nd6467 1.159115429604e+02
RINT5817 nd5817 nd6468 2.571091890176e+03
RINT5818 nd5818 nd6469 1.071288287573e+01
RINT5819 nd5819 nd6470 1.071288287573e+01
RINT5820 nd5820 nd6471 1.071288287573e+01
RINT5821 nd5821 nd6472 1.071288287573e+01
RINT5822 nd5822 nd6473 1.071288287573e+01
RINT5823 nd5823 nd6474 1.071288287573e+01
RINT5824 nd5824 nd6475 1.071288287573e+01
RINT5825 nd5825 nd6476 1.071288287573e+01
RINT5826 nd5826 nd6477 1.071288287573e+01
RINT5827 nd5827 nd6478 1.071288287573e+01
RINT5828 nd5828 nd6479 1.722097716126e+01
RINT5829 nd5829 nd6480 1.487039843942e+01
RINT5830 nd5830 nd6481 1.487039843942e+01
RINT5831 nd5831 nd6482 8.627601608838e+02
RINT5832 nd5832 nd6483 3.060580775545e+01
RINT5833 nd5833 nd6484 3.082228040171e+01
RINT5834 nd5834 nd6485 3.082228040171e+01
RINT5835 nd5835 nd6486 1.224329471512e+03
RINT5836 nd5836 nd6487 2.040549119187e+02
RINT5837 nd5837 nd6488 3.498084204321e+02
RINT5838 nd5838 nd6489 3.498084204321e+02
RINT5839 nd5839 nd6490 3.498084204321e+02
RINT5840 nd5840 nd6491 3.498084204321e+02
RINT5841 nd5841 nd6492 3.498084204321e+02
RINT5842 nd5842 nd6493 3.498084204321e+02
RINT5843 nd5843 nd6494 3.498084204321e+02
RINT5844 nd5844 nd6495 7.773520454047e+01
RINT5845 nd5845 nd6496 7.773520454047e+01
RINT5846 nd5846 nd6497 1.611548589557e+03
RINT5847 nd5847 nd6498 1.159115429604e+02
RINT5848 nd5848 nd6499 2.571091890176e+03
RINT5849 nd5849 nd6500 1.071288287573e+01
RINT5850 nd5850 nd6501 1.071288287573e+01
RINT5851 nd5851 nd6502 1.071288287573e+01
RINT5852 nd5852 nd6503 1.071288287573e+01
RINT5853 nd5853 nd6504 1.071288287573e+01
RINT5854 nd5854 nd6505 1.071288287573e+01
RINT5855 nd5855 nd6506 1.071288287573e+01
RINT5856 nd5856 nd6507 1.071288287573e+01
RINT5857 nd5857 nd6508 1.071288287573e+01
RINT5858 nd5858 nd6509 1.071288287573e+01
RINT5859 nd5859 nd6510 1.722097716126e+01
RINT5860 nd5860 nd6511 1.487039843942e+01
RINT5861 nd5861 nd6512 1.487039843942e+01
RINT5862 nd5862 nd6513 8.627601608838e+02
RINT5863 nd5863 nd6514 3.060580775545e+01
RINT5864 nd5864 nd6515 3.082228040171e+01
RINT5865 nd5865 nd6516 3.082228040171e+01
RINT5866 nd5866 nd6517 1.224329471512e+03
RINT5867 nd5867 nd6518 2.040549119187e+02
RINT5868 nd5868 nd6519 3.498084204321e+02
RINT5869 nd5869 nd6520 3.498084204321e+02
RINT5870 nd5870 nd6521 3.498084204321e+02
RINT5871 nd5871 nd6522 3.498084204321e+02
RINT5872 nd5872 nd6523 3.498084204321e+02
RINT5873 nd5873 nd6524 3.498084204321e+02
RINT5874 nd5874 nd6525 3.498084204321e+02
RINT5875 nd5875 nd6526 7.773520454047e+01
RINT5876 nd5876 nd6527 7.773520454047e+01
RINT5877 nd5877 nd6528 1.611548589557e+03
RINT5878 nd5878 nd6529 1.159115429604e+02
RINT5879 nd5879 nd6530 2.571091890176e+03
RINT5880 nd5880 nd6531 1.071288287573e+01
RINT5881 nd5881 nd6532 1.071288287573e+01
RINT5882 nd5882 nd6533 1.071288287573e+01
RINT5883 nd5883 nd6534 1.071288287573e+01
RINT5884 nd5884 nd6535 1.071288287573e+01
RINT5885 nd5885 nd6536 1.071288287573e+01
RINT5886 nd5886 nd6537 1.071288287573e+01
RINT5887 nd5887 nd6538 1.071288287573e+01
RINT5888 nd5888 nd6539 1.071288287573e+01
RINT5889 nd5889 nd6540 1.071288287573e+01
RINT5890 nd5890 nd6541 1.722097716126e+01
RINT5891 nd5891 nd6542 1.487039843942e+01
RINT5892 nd5892 nd6543 1.487039843942e+01
RINT5893 nd5893 nd6544 8.627601608838e+02
RINT5894 nd5894 nd6545 3.060580775545e+01
RINT5895 nd5895 nd6546 3.082228040171e+01
RINT5896 nd5896 nd6547 3.082228040171e+01
RINT5897 nd5897 nd6548 1.224329471512e+03
RINT5898 nd5898 nd6549 2.040549119187e+02
RINT5899 nd5899 nd6550 3.498084204321e+02
RINT5900 nd5900 nd6551 3.498084204321e+02
RINT5901 nd5901 nd6552 3.498084204321e+02
RINT5902 nd5902 nd6553 3.498084204321e+02
RINT5903 nd5903 nd6554 3.498084204321e+02
RINT5904 nd5904 nd6555 3.498084204321e+02
RINT5905 nd5905 nd6556 3.498084204321e+02
RINT5906 nd5906 nd6557 7.773520454047e+01
RINT5907 nd5907 nd6558 7.773520454047e+01
RINT5908 nd5908 nd6559 1.611548589557e+03
RINT5909 nd5909 nd6560 1.159115429604e+02
RINT5910 nd5910 nd6561 2.571091890176e+03
RINT5911 nd5911 nd6562 1.071288287573e+01
RINT5912 nd5912 nd6563 1.071288287573e+01
RINT5913 nd5913 nd6564 1.071288287573e+01
RINT5914 nd5914 nd6565 1.071288287573e+01
RINT5915 nd5915 nd6566 1.071288287573e+01
RINT5916 nd5916 nd6567 1.071288287573e+01
RINT5917 nd5917 nd6568 1.071288287573e+01
RINT5918 nd5918 nd6569 1.071288287573e+01
RINT5919 nd5919 nd6570 1.071288287573e+01
RINT5920 nd5920 nd6571 1.071288287573e+01
RINT5921 nd5921 nd6572 1.722097716126e+01
RINT5922 nd5922 nd6573 1.487039843942e+01
RINT5923 nd5923 nd6574 1.487039843942e+01
RINT5924 nd5924 nd6575 8.627601608838e+02
RINT5925 nd5925 nd6576 3.060580775545e+01
RINT5926 nd5926 nd6577 3.082228040171e+01
RINT5927 nd5927 nd6578 3.082228040171e+01
RINT5928 nd5928 nd6579 1.224329471512e+03
RINT5929 nd5929 nd6580 2.040549119187e+02
RINT5930 nd5930 nd6581 3.498084204321e+02
RINT5931 nd5931 nd6582 3.498084204321e+02
RINT5932 nd5932 nd6583 3.498084204321e+02
RINT5933 nd5933 nd6584 3.498084204321e+02
RINT5934 nd5934 nd6585 3.498084204321e+02
RINT5935 nd5935 nd6586 3.498084204321e+02
RINT5936 nd5936 nd6587 3.498084204321e+02
RINT5937 nd5937 nd6588 7.773520454047e+01
RINT5938 nd5938 nd6589 7.773520454047e+01
RINT5939 nd5939 nd6590 1.611548589557e+03
RINT5940 nd5940 nd6591 1.159115429604e+02
RINT5941 nd5941 nd6592 2.571091890176e+03
RINT5942 nd5942 nd6593 1.071288287573e+01
RINT5943 nd5943 nd6594 1.071288287573e+01
RINT5944 nd5944 nd6595 1.071288287573e+01
RINT5945 nd5945 nd6596 1.071288287573e+01
RINT5946 nd5946 nd6597 1.071288287573e+01
RINT5947 nd5947 nd6598 1.071288287573e+01
RINT5948 nd5948 nd6599 1.071288287573e+01
RINT5949 nd5949 nd6600 1.071288287573e+01
RINT5950 nd5950 nd6601 1.071288287573e+01
RINT5951 nd5951 nd6602 1.071288287573e+01
RINT5952 nd5952 nd6603 1.265942732753e+02
RINT5953 nd5953 nd6604 1.093147773279e+02
RINT5954 nd5954 nd6605 1.093147773279e+02
RINT5955 nd5955 nd6606 6.342293736017e+03
RINT5956 nd5956 nd6607 2.249883937783e+02
RINT5957 nd5957 nd6608 2.265797202797e+02
RINT5958 nd5958 nd6609 2.265797202797e+02
RINT5959 nd5959 nd6610 5.906414062500e+05
RINT5960 nd5960 nd6611 9.844023437500e+04
RINT5961 nd5961 nd6612 1.687546875000e+05
RINT5962 nd5962 nd6613 1.687546875000e+05
RINT5963 nd5963 nd6614 1.687546875000e+05
RINT5964 nd5964 nd6615 1.687546875000e+05
RINT5965 nd5965 nd6616 1.687546875000e+05
RINT5966 nd5966 nd6617 1.687546875000e+05
RINT5967 nd5967 nd6618 1.687546875000e+05
RINT5968 nd5968 nd6619 3.750104166667e+04
RINT5969 nd5969 nd6620 3.750104166667e+04
RINT5970 nd5970 nd6621 1.184676227326e+04
RINT5971 nd5971 nd6622 8.520850708924e+02
RINT5972 nd5972 nd6623 1.890052500000e+04
RINT5973 nd5973 nd6624 7.875218750000e+01
RINT5974 nd5974 nd6625 7.875218750000e+01
RINT5975 nd5975 nd6626 7.875218750000e+01
RINT5976 nd5976 nd6627 7.875218750000e+01
RINT5977 nd5977 nd6628 7.875218750000e+01
RINT5978 nd5978 nd6629 7.875218750000e+01
RINT5979 nd5979 nd6630 7.875218750000e+01
RINT5980 nd5980 nd6631 7.875218750000e+01
RINT5981 nd5981 nd6632 7.875218750000e+01
RINT5982 nd5982 nd6633 7.875218750000e+01
RINT5983 nd5983 nd6634 1.322170110122e+01
RINT5984 nd5984 nd6635 1.141700390059e+01
RINT5985 nd5985 nd6636 1.141700390059e+01
RINT5986 nd5986 nd6637 6.623989372047e+02
RINT5987 nd5987 nd6638 2.349813476405e+01
RINT5988 nd5988 nd6639 2.366433535758e+01
RINT5989 nd5989 nd6640 2.366433535758e+01
RINT5990 nd5990 nd6641 1.239106136042e+03
RINT5991 nd5991 nd6642 1.373695180523e+02
RINT5992 nd5992 nd6643 2.711285174478e+02
RINT5993 nd5993 nd6644 2.711285174478e+02
RINT5994 nd5994 nd6645 2.711285174478e+02
RINT5995 nd5995 nd6646 2.711285174478e+02
RINT5996 nd5996 nd6647 2.711285174478e+02
RINT5997 nd5997 nd6648 2.711285174478e+02
RINT5998 nd5998 nd6649 2.711285174478e+02
RINT5999 nd5999 nd6650 5.233124497231e+01
RINT6000 nd6000 nd6651 5.390580832121e+01
RINT6001 nd6001 nd6652 1.237294118776e+03
RINT6002 nd6002 nd6653 8.899307866519e+01
RINT6003 nd6003 nd6654 1.973999974412e+03
RINT6004 nd6004 nd6655 8.224999893383e+00
RINT6005 nd6005 nd6656 8.224999893383e+00
RINT6006 nd6006 nd6657 8.224999893383e+00
RINT6007 nd6007 nd6658 8.224999893383e+00
RINT6008 nd6008 nd6659 8.224999893383e+00
RINT6009 nd6009 nd6660 8.224999893383e+00
RINT6010 nd6010 nd6661 8.224999893383e+00
RINT6011 nd6011 nd6662 8.224999893383e+00
RINT6012 nd6012 nd6663 8.224999893383e+00
RINT6013 nd6013 nd6664 8.224999893383e+00
RINT6014 nd6014 nd6665 1.322170110122e+01
RINT6015 nd6015 nd6666 1.141700390059e+01
RINT6016 nd6016 nd6667 1.141700390059e+01
RINT6017 nd6017 nd6668 6.623989372047e+02
RINT6018 nd6018 nd6669 2.349813476405e+01
RINT6019 nd6019 nd6670 2.366433535758e+01
RINT6020 nd6020 nd6671 2.366433535758e+01
RINT6021 nd6021 nd6672 1.239106136042e+03
RINT6022 nd6022 nd6673 1.373695180523e+02
RINT6023 nd6023 nd6674 2.711285174478e+02
RINT6024 nd6024 nd6675 2.711285174478e+02
RINT6025 nd6025 nd6676 2.711285174478e+02
RINT6026 nd6026 nd6677 2.711285174478e+02
RINT6027 nd6027 nd6678 2.711285174478e+02
RINT6028 nd6028 nd6679 2.711285174478e+02
RINT6029 nd6029 nd6680 2.711285174478e+02
RINT6030 nd6030 nd6681 5.233124497231e+01
RINT6031 nd6031 nd6682 5.390580832121e+01
RINT6032 nd6032 nd6683 1.237294118776e+03
RINT6033 nd6033 nd6684 8.899307866519e+01
RINT6034 nd6034 nd6685 1.973999974412e+03
RINT6035 nd6035 nd6686 8.224999893383e+00
RINT6036 nd6036 nd6687 8.224999893383e+00
RINT6037 nd6037 nd6688 8.224999893383e+00
RINT6038 nd6038 nd6689 8.224999893383e+00
RINT6039 nd6039 nd6690 8.224999893383e+00
RINT6040 nd6040 nd6691 8.224999893383e+00
RINT6041 nd6041 nd6692 8.224999893383e+00
RINT6042 nd6042 nd6693 8.224999893383e+00
RINT6043 nd6043 nd6694 8.224999893383e+00
RINT6044 nd6044 nd6695 8.224999893383e+00
RINT6045 nd6045 nd6696 1.322170110122e+01
RINT6046 nd6046 nd6697 1.141700390059e+01
RINT6047 nd6047 nd6698 1.141700390059e+01
RINT6048 nd6048 nd6699 6.623989372047e+02
RINT6049 nd6049 nd6700 2.349813476405e+01
RINT6050 nd6050 nd6701 2.366433535758e+01
RINT6051 nd6051 nd6702 2.366433535758e+01
RINT6052 nd6052 nd6703 1.239106136042e+03
RINT6053 nd6053 nd6704 1.373695180523e+02
RINT6054 nd6054 nd6705 2.711285174478e+02
RINT6055 nd6055 nd6706 2.711285174478e+02
RINT6056 nd6056 nd6707 2.711285174478e+02
RINT6057 nd6057 nd6708 2.711285174478e+02
RINT6058 nd6058 nd6709 2.711285174478e+02
RINT6059 nd6059 nd6710 2.711285174478e+02
RINT6060 nd6060 nd6711 2.711285174478e+02
RINT6061 nd6061 nd6712 5.233124497231e+01
RINT6062 nd6062 nd6713 5.390580832121e+01
RINT6063 nd6063 nd6714 1.237294118776e+03
RINT6064 nd6064 nd6715 8.899307866519e+01
RINT6065 nd6065 nd6716 1.973999974412e+03
RINT6066 nd6066 nd6717 8.224999893383e+00
RINT6067 nd6067 nd6718 8.224999893383e+00
RINT6068 nd6068 nd6719 8.224999893383e+00
RINT6069 nd6069 nd6720 8.224999893383e+00
RINT6070 nd6070 nd6721 8.224999893383e+00
RINT6071 nd6071 nd6722 8.224999893383e+00
RINT6072 nd6072 nd6723 8.224999893383e+00
RINT6073 nd6073 nd6724 8.224999893383e+00
RINT6074 nd6074 nd6725 8.224999893383e+00
RINT6075 nd6075 nd6726 8.224999893383e+00
RINT6076 nd6076 nd6727 1.322170110122e+01
RINT6077 nd6077 nd6728 1.141700390059e+01
RINT6078 nd6078 nd6729 1.141700390059e+01
RINT6079 nd6079 nd6730 6.623989372047e+02
RINT6080 nd6080 nd6731 2.349813476405e+01
RINT6081 nd6081 nd6732 2.366433535758e+01
RINT6082 nd6082 nd6733 2.366433535758e+01
RINT6083 nd6083 nd6734 1.239106136042e+03
RINT6084 nd6084 nd6735 1.373695180523e+02
RINT6085 nd6085 nd6736 2.711285174478e+02
RINT6086 nd6086 nd6737 2.711285174478e+02
RINT6087 nd6087 nd6738 2.711285174478e+02
RINT6088 nd6088 nd6739 2.711285174478e+02
RINT6089 nd6089 nd6740 2.711285174478e+02
RINT6090 nd6090 nd6741 2.711285174478e+02
RINT6091 nd6091 nd6742 2.711285174478e+02
RINT6092 nd6092 nd6743 5.233124497231e+01
RINT6093 nd6093 nd6744 5.390580832121e+01
RINT6094 nd6094 nd6745 1.237294118776e+03
RINT6095 nd6095 nd6746 8.899307866519e+01
RINT6096 nd6096 nd6747 1.973999974412e+03
RINT6097 nd6097 nd6748 8.224999893383e+00
RINT6098 nd6098 nd6749 8.224999893383e+00
RINT6099 nd6099 nd6750 8.224999893383e+00
RINT6100 nd6100 nd6751 8.224999893383e+00
RINT6101 nd6101 nd6752 8.224999893383e+00
RINT6102 nd6102 nd6753 8.224999893383e+00
RINT6103 nd6103 nd6754 8.224999893383e+00
RINT6104 nd6104 nd6755 8.224999893383e+00
RINT6105 nd6105 nd6756 8.224999893383e+00
RINT6106 nd6106 nd6757 8.224999893383e+00
RINT6107 nd6107 nd6758 1.322170110122e+01
RINT6108 nd6108 nd6759 1.141700390059e+01
RINT6109 nd6109 nd6760 1.141700390059e+01
RINT6110 nd6110 nd6761 6.623989372047e+02
RINT6111 nd6111 nd6762 2.349813476405e+01
RINT6112 nd6112 nd6763 2.366433535758e+01
RINT6113 nd6113 nd6764 2.366433535758e+01
RINT6114 nd6114 nd6765 1.239106136042e+03
RINT6115 nd6115 nd6766 1.373695180523e+02
RINT6116 nd6116 nd6767 2.711285174478e+02
RINT6117 nd6117 nd6768 2.711285174478e+02
RINT6118 nd6118 nd6769 2.711285174478e+02
RINT6119 nd6119 nd6770 2.711285174478e+02
RINT6120 nd6120 nd6771 2.711285174478e+02
RINT6121 nd6121 nd6772 2.711285174478e+02
RINT6122 nd6122 nd6773 2.711285174478e+02
RINT6123 nd6123 nd6774 5.233124497231e+01
RINT6124 nd6124 nd6775 5.390580832121e+01
RINT6125 nd6125 nd6776 1.237294118776e+03
RINT6126 nd6126 nd6777 8.899307866519e+01
RINT6127 nd6127 nd6778 1.973999974412e+03
RINT6128 nd6128 nd6779 8.224999893383e+00
RINT6129 nd6129 nd6780 8.224999893383e+00
RINT6130 nd6130 nd6781 8.224999893383e+00
RINT6131 nd6131 nd6782 8.224999893383e+00
RINT6132 nd6132 nd6783 8.224999893383e+00
RINT6133 nd6133 nd6784 8.224999893383e+00
RINT6134 nd6134 nd6785 8.224999893383e+00
RINT6135 nd6135 nd6786 8.224999893383e+00
RINT6136 nd6136 nd6787 8.224999893383e+00
RINT6137 nd6137 nd6788 8.224999893383e+00
RINT6138 nd6138 nd6789 1.322170110122e+01
RINT6139 nd6139 nd6790 1.141700390059e+01
RINT6140 nd6140 nd6791 1.141700390059e+01
RINT6141 nd6141 nd6792 6.623989372047e+02
RINT6142 nd6142 nd6793 2.349813476405e+01
RINT6143 nd6143 nd6794 2.366433535758e+01
RINT6144 nd6144 nd6795 2.366433535758e+01
RINT6145 nd6145 nd6796 1.239106136042e+03
RINT6146 nd6146 nd6797 1.373695180523e+02
RINT6147 nd6147 nd6798 2.711285174478e+02
RINT6148 nd6148 nd6799 2.711285174478e+02
RINT6149 nd6149 nd6800 2.711285174478e+02
RINT6150 nd6150 nd6801 2.711285174478e+02
RINT6151 nd6151 nd6802 2.711285174478e+02
RINT6152 nd6152 nd6803 2.711285174478e+02
RINT6153 nd6153 nd6804 2.711285174478e+02
RINT6154 nd6154 nd6805 5.233124497231e+01
RINT6155 nd6155 nd6806 5.390580832121e+01
RINT6156 nd6156 nd6807 1.237294118776e+03
RINT6157 nd6157 nd6808 8.899307866519e+01
RINT6158 nd6158 nd6809 1.973999974412e+03
RINT6159 nd6159 nd6810 8.224999893383e+00
RINT6160 nd6160 nd6811 8.224999893383e+00
RINT6161 nd6161 nd6812 8.224999893383e+00
RINT6162 nd6162 nd6813 8.224999893383e+00
RINT6163 nd6163 nd6814 8.224999893383e+00
RINT6164 nd6164 nd6815 8.224999893383e+00
RINT6165 nd6165 nd6816 8.224999893383e+00
RINT6166 nd6166 nd6817 8.224999893383e+00
RINT6167 nd6167 nd6818 8.224999893383e+00
RINT6168 nd6168 nd6819 8.224999893383e+00
RINT6169 nd6169 nd6820 1.265942732753e+02
RINT6170 nd6170 nd6821 1.093147773279e+02
RINT6171 nd6171 nd6822 1.093147773279e+02
RINT6172 nd6172 nd6823 6.342293736017e+03
RINT6173 nd6173 nd6824 2.249883937783e+02
RINT6174 nd6174 nd6825 2.265797202797e+02
RINT6175 nd6175 nd6826 2.265797202797e+02
RINT6176 nd6176 nd6827 5.906414062500e+05
RINT6177 nd6177 nd6828 9.844023437500e+04
RINT6178 nd6178 nd6829 1.687546875000e+05
RINT6179 nd6179 nd6830 1.687546875000e+05
RINT6180 nd6180 nd6831 1.687546875000e+05
RINT6181 nd6181 nd6832 1.687546875000e+05
RINT6182 nd6182 nd6833 1.687546875000e+05
RINT6183 nd6183 nd6834 1.687546875000e+05
RINT6184 nd6184 nd6835 1.687546875000e+05
RINT6185 nd6185 nd6836 3.750104166667e+04
RINT6186 nd6186 nd6837 3.750104166667e+04
RINT6187 nd6187 nd6838 1.184676227326e+04
RINT6188 nd6188 nd6839 8.520850708924e+02
RINT6189 nd6189 nd6840 1.890052500000e+04
RINT6190 nd6190 nd6841 7.875218750000e+01
RINT6191 nd6191 nd6842 7.875218750000e+01
RINT6192 nd6192 nd6843 7.875218750000e+01
RINT6193 nd6193 nd6844 7.875218750000e+01
RINT6194 nd6194 nd6845 7.875218750000e+01
RINT6195 nd6195 nd6846 7.875218750000e+01
RINT6196 nd6196 nd6847 7.875218750000e+01
RINT6197 nd6197 nd6848 7.875218750000e+01
RINT6198 nd6198 nd6849 7.875218750000e+01
RINT6199 nd6199 nd6850 7.875218750000e+01
RINT6200 nd6200 nd6851 1.322170110122e+01
RINT6201 nd6201 nd6852 1.141700390059e+01
RINT6202 nd6202 nd6853 1.141700390059e+01
RINT6203 nd6203 nd6854 6.623989372047e+02
RINT6204 nd6204 nd6855 2.349813476405e+01
RINT6205 nd6205 nd6856 2.366433535758e+01
RINT6206 nd6206 nd6857 2.366433535758e+01
RINT6207 nd6207 nd6858 1.239106136042e+03
RINT6208 nd6208 nd6859 1.373695180523e+02
RINT6209 nd6209 nd6860 2.711285174478e+02
RINT6210 nd6210 nd6861 2.711285174478e+02
RINT6211 nd6211 nd6862 2.711285174478e+02
RINT6212 nd6212 nd6863 2.711285174478e+02
RINT6213 nd6213 nd6864 2.711285174478e+02
RINT6214 nd6214 nd6865 2.711285174478e+02
RINT6215 nd6215 nd6866 2.711285174478e+02
RINT6216 nd6216 nd6867 5.233124497231e+01
RINT6217 nd6217 nd6868 5.390580832121e+01
RINT6218 nd6218 nd6869 1.237294118776e+03
RINT6219 nd6219 nd6870 8.899307866519e+01
RINT6220 nd6220 nd6871 1.973999974412e+03
RINT6221 nd6221 nd6872 8.224999893383e+00
RINT6222 nd6222 nd6873 8.224999893383e+00
RINT6223 nd6223 nd6874 8.224999893383e+00
RINT6224 nd6224 nd6875 8.224999893383e+00
RINT6225 nd6225 nd6876 8.224999893383e+00
RINT6226 nd6226 nd6877 8.224999893383e+00
RINT6227 nd6227 nd6878 8.224999893383e+00
RINT6228 nd6228 nd6879 8.224999893383e+00
RINT6229 nd6229 nd6880 8.224999893383e+00
RINT6230 nd6230 nd6881 8.224999893383e+00
RINT6231 nd6231 nd6882 1.322170110122e+01
RINT6232 nd6232 nd6883 1.141700390059e+01
RINT6233 nd6233 nd6884 1.141700390059e+01
RINT6234 nd6234 nd6885 6.623989372047e+02
RINT6235 nd6235 nd6886 2.349813476405e+01
RINT6236 nd6236 nd6887 2.366433535758e+01
RINT6237 nd6237 nd6888 2.366433535758e+01
RINT6238 nd6238 nd6889 1.239106136042e+03
RINT6239 nd6239 nd6890 1.373695180523e+02
RINT6240 nd6240 nd6891 2.711285174478e+02
RINT6241 nd6241 nd6892 2.711285174478e+02
RINT6242 nd6242 nd6893 2.711285174478e+02
RINT6243 nd6243 nd6894 2.711285174478e+02
RINT6244 nd6244 nd6895 2.711285174478e+02
RINT6245 nd6245 nd6896 2.711285174478e+02
RINT6246 nd6246 nd6897 2.711285174478e+02
RINT6247 nd6247 nd6898 5.233124497231e+01
RINT6248 nd6248 nd6899 5.390580832121e+01
RINT6249 nd6249 nd6900 1.237294118776e+03
RINT6250 nd6250 nd6901 8.899307866519e+01
RINT6251 nd6251 nd6902 1.973999974412e+03
RINT6252 nd6252 nd6903 8.224999893383e+00
RINT6253 nd6253 nd6904 8.224999893383e+00
RINT6254 nd6254 nd6905 8.224999893383e+00
RINT6255 nd6255 nd6906 8.224999893383e+00
RINT6256 nd6256 nd6907 8.224999893383e+00
RINT6257 nd6257 nd6908 8.224999893383e+00
RINT6258 nd6258 nd6909 8.224999893383e+00
RINT6259 nd6259 nd6910 8.224999893383e+00
RINT6260 nd6260 nd6911 8.224999893383e+00
RINT6261 nd6261 nd6912 8.224999893383e+00
RINT6262 nd6262 nd6913 1.322170110122e+01
RINT6263 nd6263 nd6914 1.141700390059e+01
RINT6264 nd6264 nd6915 1.141700390059e+01
RINT6265 nd6265 nd6916 6.623989372047e+02
RINT6266 nd6266 nd6917 2.349813476405e+01
RINT6267 nd6267 nd6918 2.366433535758e+01
RINT6268 nd6268 nd6919 2.366433535758e+01
RINT6269 nd6269 nd6920 1.239106136042e+03
RINT6270 nd6270 nd6921 1.373695180523e+02
RINT6271 nd6271 nd6922 2.711285174478e+02
RINT6272 nd6272 nd6923 2.711285174478e+02
RINT6273 nd6273 nd6924 2.711285174478e+02
RINT6274 nd6274 nd6925 2.711285174478e+02
RINT6275 nd6275 nd6926 2.711285174478e+02
RINT6276 nd6276 nd6927 2.711285174478e+02
RINT6277 nd6277 nd6928 2.711285174478e+02
RINT6278 nd6278 nd6929 5.233124497231e+01
RINT6279 nd6279 nd6930 5.390580832121e+01
RINT6280 nd6280 nd6931 1.237294118776e+03
RINT6281 nd6281 nd6932 8.899307866519e+01
RINT6282 nd6282 nd6933 1.973999974412e+03
RINT6283 nd6283 nd6934 8.224999893383e+00
RINT6284 nd6284 nd6935 8.224999893383e+00
RINT6285 nd6285 nd6936 8.224999893383e+00
RINT6286 nd6286 nd6937 8.224999893383e+00
RINT6287 nd6287 nd6938 8.224999893383e+00
RINT6288 nd6288 nd6939 8.224999893383e+00
RINT6289 nd6289 nd6940 8.224999893383e+00
RINT6290 nd6290 nd6941 8.224999893383e+00
RINT6291 nd6291 nd6942 8.224999893383e+00
RINT6292 nd6292 nd6943 8.224999893383e+00
RINT6293 nd6293 nd6944 1.322170110122e+01
RINT6294 nd6294 nd6945 1.141700390059e+01
RINT6295 nd6295 nd6946 1.141700390059e+01
RINT6296 nd6296 nd6947 6.623989372047e+02
RINT6297 nd6297 nd6948 2.349813476405e+01
RINT6298 nd6298 nd6949 2.366433535758e+01
RINT6299 nd6299 nd6950 2.366433535758e+01
RINT6300 nd6300 nd6951 1.239106136042e+03
RINT6301 nd6301 nd6952 1.373695180523e+02
RINT6302 nd6302 nd6953 2.711285174478e+02
RINT6303 nd6303 nd6954 2.711285174478e+02
RINT6304 nd6304 nd6955 2.711285174478e+02
RINT6305 nd6305 nd6956 2.711285174478e+02
RINT6306 nd6306 nd6957 2.711285174478e+02
RINT6307 nd6307 nd6958 2.711285174478e+02
RINT6308 nd6308 nd6959 2.711285174478e+02
RINT6309 nd6309 nd6960 5.233124497231e+01
RINT6310 nd6310 nd6961 5.390580832121e+01
RINT6311 nd6311 nd6962 1.237294118776e+03
RINT6312 nd6312 nd6963 8.899307866519e+01
RINT6313 nd6313 nd6964 1.973999974412e+03
RINT6314 nd6314 nd6965 8.224999893383e+00
RINT6315 nd6315 nd6966 8.224999893383e+00
RINT6316 nd6316 nd6967 8.224999893383e+00
RINT6317 nd6317 nd6968 8.224999893383e+00
RINT6318 nd6318 nd6969 8.224999893383e+00
RINT6319 nd6319 nd6970 8.224999893383e+00
RINT6320 nd6320 nd6971 8.224999893383e+00
RINT6321 nd6321 nd6972 8.224999893383e+00
RINT6322 nd6322 nd6973 8.224999893383e+00
RINT6323 nd6323 nd6974 8.224999893383e+00
RINT6324 nd6324 nd6975 1.322170110122e+01
RINT6325 nd6325 nd6976 1.141700390059e+01
RINT6326 nd6326 nd6977 1.141700390059e+01
RINT6327 nd6327 nd6978 6.623989372047e+02
RINT6328 nd6328 nd6979 2.349813476405e+01
RINT6329 nd6329 nd6980 2.366433535758e+01
RINT6330 nd6330 nd6981 2.366433535758e+01
RINT6331 nd6331 nd6982 1.239106136042e+03
RINT6332 nd6332 nd6983 1.373695180523e+02
RINT6333 nd6333 nd6984 2.711285174478e+02
RINT6334 nd6334 nd6985 2.711285174478e+02
RINT6335 nd6335 nd6986 2.711285174478e+02
RINT6336 nd6336 nd6987 2.711285174478e+02
RINT6337 nd6337 nd6988 2.711285174478e+02
RINT6338 nd6338 nd6989 2.711285174478e+02
RINT6339 nd6339 nd6990 2.711285174478e+02
RINT6340 nd6340 nd6991 5.233124497231e+01
RINT6341 nd6341 nd6992 5.390580832121e+01
RINT6342 nd6342 nd6993 1.237294118776e+03
RINT6343 nd6343 nd6994 8.899307866519e+01
RINT6344 nd6344 nd6995 1.973999974412e+03
RINT6345 nd6345 nd6996 8.224999893383e+00
RINT6346 nd6346 nd6997 8.224999893383e+00
RINT6347 nd6347 nd6998 8.224999893383e+00
RINT6348 nd6348 nd6999 8.224999893383e+00
RINT6349 nd6349 nd7000 8.224999893383e+00
RINT6350 nd6350 nd7001 8.224999893383e+00
RINT6351 nd6351 nd7002 8.224999893383e+00
RINT6352 nd6352 nd7003 8.224999893383e+00
RINT6353 nd6353 nd7004 8.224999893383e+00
RINT6354 nd6354 nd7005 8.224999893383e+00
RINT6355 nd6355 nd7006 1.322170110122e+01
RINT6356 nd6356 nd7007 1.141700390059e+01
RINT6357 nd6357 nd7008 1.141700390059e+01
RINT6358 nd6358 nd7009 6.623989372047e+02
RINT6359 nd6359 nd7010 2.349813476405e+01
RINT6360 nd6360 nd7011 2.366433535758e+01
RINT6361 nd6361 nd7012 2.366433535758e+01
RINT6362 nd6362 nd7013 1.239106136042e+03
RINT6363 nd6363 nd7014 1.373695180523e+02
RINT6364 nd6364 nd7015 2.711285174478e+02
RINT6365 nd6365 nd7016 2.711285174478e+02
RINT6366 nd6366 nd7017 2.711285174478e+02
RINT6367 nd6367 nd7018 2.711285174478e+02
RINT6368 nd6368 nd7019 2.711285174478e+02
RINT6369 nd6369 nd7020 2.711285174478e+02
RINT6370 nd6370 nd7021 2.711285174478e+02
RINT6371 nd6371 nd7022 5.233124497231e+01
RINT6372 nd6372 nd7023 5.390580832121e+01
RINT6373 nd6373 nd7024 1.237294118776e+03
RINT6374 nd6374 nd7025 8.899307866519e+01
RINT6375 nd6375 nd7026 1.973999974412e+03
RINT6376 nd6376 nd7027 8.224999893383e+00
RINT6377 nd6377 nd7028 8.224999893383e+00
RINT6378 nd6378 nd7029 8.224999893383e+00
RINT6379 nd6379 nd7030 8.224999893383e+00
RINT6380 nd6380 nd7031 8.224999893383e+00
RINT6381 nd6381 nd7032 8.224999893383e+00
RINT6382 nd6382 nd7033 8.224999893383e+00
RINT6383 nd6383 nd7034 8.224999893383e+00
RINT6384 nd6384 nd7035 8.224999893383e+00
RINT6385 nd6385 nd7036 8.224999893383e+00
RINT6386 nd6386 nd7037 1.265942732753e+02
RINT6387 nd6387 nd7038 1.093147773279e+02
RINT6388 nd6388 nd7039 1.093147773279e+02
RINT6389 nd6389 nd7040 6.342293736017e+03
RINT6390 nd6390 nd7041 2.249883937783e+02
RINT6391 nd6391 nd7042 2.265797202797e+02
RINT6392 nd6392 nd7043 2.265797202797e+02
RINT6393 nd6393 nd7044 5.906414062500e+05
RINT6394 nd6394 nd7045 9.844023437500e+04
RINT6395 nd6395 nd7046 1.687546875000e+05
RINT6396 nd6396 nd7047 1.687546875000e+05
RINT6397 nd6397 nd7048 1.687546875000e+05
RINT6398 nd6398 nd7049 1.687546875000e+05
RINT6399 nd6399 nd7050 1.687546875000e+05
RINT6400 nd6400 nd7051 1.687546875000e+05
RINT6401 nd6401 nd7052 1.687546875000e+05
RINT6402 nd6402 nd7053 3.750104166667e+04
RINT6403 nd6403 nd7054 3.750104166667e+04
RINT6404 nd6404 nd7055 1.184676227326e+04
RINT6405 nd6405 nd7056 8.520850708924e+02
RINT6406 nd6406 nd7057 1.890052500000e+04
RINT6407 nd6407 nd7058 7.875218750000e+01
RINT6408 nd6408 nd7059 7.875218750000e+01
RINT6409 nd6409 nd7060 7.875218750000e+01
RINT6410 nd6410 nd7061 7.875218750000e+01
RINT6411 nd6411 nd7062 7.875218750000e+01
RINT6412 nd6412 nd7063 7.875218750000e+01
RINT6413 nd6413 nd7064 7.875218750000e+01
RINT6414 nd6414 nd7065 7.875218750000e+01
RINT6415 nd6415 nd7066 7.875218750000e+01
RINT6416 nd6416 nd7067 7.875218750000e+01
RINT6417 nd6417 nd7068 1.722097716126e+01
RINT6418 nd6418 nd7069 1.487039843942e+01
RINT6419 nd6419 nd7070 1.487039843942e+01
RINT6420 nd6420 nd7071 8.627601608838e+02
RINT6421 nd6421 nd7072 3.060580775545e+01
RINT6422 nd6422 nd7073 3.082228040171e+01
RINT6423 nd6423 nd7074 3.082228040171e+01
RINT6424 nd6424 nd7075 1.224329471512e+03
RINT6425 nd6425 nd7076 2.040549119187e+02
RINT6426 nd6426 nd7077 3.498084204321e+02
RINT6427 nd6427 nd7078 3.498084204321e+02
RINT6428 nd6428 nd7079 3.498084204321e+02
RINT6429 nd6429 nd7080 3.498084204321e+02
RINT6430 nd6430 nd7081 3.498084204321e+02
RINT6431 nd6431 nd7082 3.498084204321e+02
RINT6432 nd6432 nd7083 3.498084204321e+02
RINT6433 nd6433 nd7084 7.773520454047e+01
RINT6434 nd6434 nd7085 7.773520454047e+01
RINT6435 nd6435 nd7086 1.611548589557e+03
RINT6436 nd6436 nd7087 1.159115429604e+02
RINT6437 nd6437 nd7088 2.571091890176e+03
RINT6438 nd6438 nd7089 1.071288287573e+01
RINT6439 nd6439 nd7090 1.071288287573e+01
RINT6440 nd6440 nd7091 1.071288287573e+01
RINT6441 nd6441 nd7092 1.071288287573e+01
RINT6442 nd6442 nd7093 1.071288287573e+01
RINT6443 nd6443 nd7094 1.071288287573e+01
RINT6444 nd6444 nd7095 1.071288287573e+01
RINT6445 nd6445 nd7096 1.071288287573e+01
RINT6446 nd6446 nd7097 1.071288287573e+01
RINT6447 nd6447 nd7098 1.071288287573e+01
RINT6448 nd6448 nd7099 1.722097716126e+01
RINT6449 nd6449 nd7100 1.487039843942e+01
RINT6450 nd6450 nd7101 1.487039843942e+01
RINT6451 nd6451 nd7102 8.627601608838e+02
RINT6452 nd6452 nd7103 3.060580775545e+01
RINT6453 nd6453 nd7104 3.082228040171e+01
RINT6454 nd6454 nd7105 3.082228040171e+01
RINT6455 nd6455 nd7106 1.224329471512e+03
RINT6456 nd6456 nd7107 2.040549119187e+02
RINT6457 nd6457 nd7108 3.498084204321e+02
RINT6458 nd6458 nd7109 3.498084204321e+02
RINT6459 nd6459 nd7110 3.498084204321e+02
RINT6460 nd6460 nd7111 3.498084204321e+02
RINT6461 nd6461 nd7112 3.498084204321e+02
RINT6462 nd6462 nd7113 3.498084204321e+02
RINT6463 nd6463 nd7114 3.498084204321e+02
RINT6464 nd6464 nd7115 7.773520454047e+01
RINT6465 nd6465 nd7116 7.773520454047e+01
RINT6466 nd6466 nd7117 1.611548589557e+03
RINT6467 nd6467 nd7118 1.159115429604e+02
RINT6468 nd6468 nd7119 2.571091890176e+03
RINT6469 nd6469 nd7120 1.071288287573e+01
RINT6470 nd6470 nd7121 1.071288287573e+01
RINT6471 nd6471 nd7122 1.071288287573e+01
RINT6472 nd6472 nd7123 1.071288287573e+01
RINT6473 nd6473 nd7124 1.071288287573e+01
RINT6474 nd6474 nd7125 1.071288287573e+01
RINT6475 nd6475 nd7126 1.071288287573e+01
RINT6476 nd6476 nd7127 1.071288287573e+01
RINT6477 nd6477 nd7128 1.071288287573e+01
RINT6478 nd6478 nd7129 1.071288287573e+01
RINT6479 nd6479 nd7130 1.722097716126e+01
RINT6480 nd6480 nd7131 1.487039843942e+01
RINT6481 nd6481 nd7132 1.487039843942e+01
RINT6482 nd6482 nd7133 8.627601608838e+02
RINT6483 nd6483 nd7134 3.060580775545e+01
RINT6484 nd6484 nd7135 3.082228040171e+01
RINT6485 nd6485 nd7136 3.082228040171e+01
RINT6486 nd6486 nd7137 1.224329471512e+03
RINT6487 nd6487 nd7138 2.040549119187e+02
RINT6488 nd6488 nd7139 3.498084204321e+02
RINT6489 nd6489 nd7140 3.498084204321e+02
RINT6490 nd6490 nd7141 3.498084204321e+02
RINT6491 nd6491 nd7142 3.498084204321e+02
RINT6492 nd6492 nd7143 3.498084204321e+02
RINT6493 nd6493 nd7144 3.498084204321e+02
RINT6494 nd6494 nd7145 3.498084204321e+02
RINT6495 nd6495 nd7146 7.773520454047e+01
RINT6496 nd6496 nd7147 7.773520454047e+01
RINT6497 nd6497 nd7148 1.611548589557e+03
RINT6498 nd6498 nd7149 1.159115429604e+02
RINT6499 nd6499 nd7150 2.571091890176e+03
RINT6500 nd6500 nd7151 1.071288287573e+01
RINT6501 nd6501 nd7152 1.071288287573e+01
RINT6502 nd6502 nd7153 1.071288287573e+01
RINT6503 nd6503 nd7154 1.071288287573e+01
RINT6504 nd6504 nd7155 1.071288287573e+01
RINT6505 nd6505 nd7156 1.071288287573e+01
RINT6506 nd6506 nd7157 1.071288287573e+01
RINT6507 nd6507 nd7158 1.071288287573e+01
RINT6508 nd6508 nd7159 1.071288287573e+01
RINT6509 nd6509 nd7160 1.071288287573e+01
RINT6510 nd6510 nd7161 9.521626084020e+00
RINT6511 nd6511 nd7162 8.221970933165e+00
RINT6512 nd6512 nd7163 8.221970933165e+00
RINT6513 nd6513 nd7164 4.770274982191e+02
RINT6514 nd6514 nd7165 1.692221380459e+01
RINT6515 nd6515 nd7166 1.704190338874e+01
RINT6516 nd6516 nd7167 1.704190338874e+01
RINT6517 nd6517 nd7168 6.769422734972e+02
RINT6518 nd6518 nd7169 1.128237122495e+02
RINT6519 nd6519 nd7170 1.934120781421e+02
RINT6520 nd6520 nd7171 1.934120781421e+02
RINT6521 nd6521 nd7172 1.934120781421e+02
RINT6522 nd6522 nd7173 1.934120781421e+02
RINT6523 nd6523 nd7174 1.934120781421e+02
RINT6524 nd6524 nd7175 1.934120781421e+02
RINT6525 nd6525 nd7176 1.934120781421e+02
RINT6526 nd6526 nd7177 4.298046180935e+01
RINT6527 nd6527 nd7178 4.298046180935e+01
RINT6528 nd6528 nd7179 8.910390474536e+02
RINT6529 nd6529 nd7180 6.408848699791e+01
RINT6530 nd6530 nd7181 1.421578774344e+03
RINT6531 nd6531 nd7182 5.923244893101e+00
RINT6532 nd6532 nd7183 5.923244893101e+00
RINT6533 nd6533 nd7184 5.923244893101e+00
RINT6534 nd6534 nd7185 5.923244893101e+00
RINT6535 nd6535 nd7186 5.923244893101e+00
RINT6536 nd6536 nd7187 5.923244893101e+00
RINT6537 nd6537 nd7188 5.923244893101e+00
RINT6538 nd6538 nd7189 5.923244893101e+00
RINT6539 nd6539 nd7190 5.923244893101e+00
RINT6540 nd6540 nd7191 5.923244893101e+00
RINT6541 nd6541 nd7192 9.521626084020e+00
RINT6542 nd6542 nd7193 8.221970933165e+00
RINT6543 nd6543 nd7194 8.221970933165e+00
RINT6544 nd6544 nd7195 4.770274982191e+02
RINT6545 nd6545 nd7196 1.692221380459e+01
RINT6546 nd6546 nd7197 1.704190338874e+01
RINT6547 nd6547 nd7198 1.704190338874e+01
RINT6548 nd6548 nd7199 6.769422734972e+02
RINT6549 nd6549 nd7200 1.128237122495e+02
RINT6550 nd6550 nd7201 1.934120781421e+02
RINT6551 nd6551 nd7202 1.934120781421e+02
RINT6552 nd6552 nd7203 1.934120781421e+02
RINT6553 nd6553 nd7204 1.934120781421e+02
RINT6554 nd6554 nd7205 1.934120781421e+02
RINT6555 nd6555 nd7206 1.934120781421e+02
RINT6556 nd6556 nd7207 1.934120781421e+02
RINT6557 nd6557 nd7208 4.298046180935e+01
RINT6558 nd6558 nd7209 4.298046180935e+01
RINT6559 nd6559 nd7210 8.910390474536e+02
RINT6560 nd6560 nd7211 6.408848699791e+01
RINT6561 nd6561 nd7212 1.421578774344e+03
RINT6562 nd6562 nd7213 5.923244893101e+00
RINT6563 nd6563 nd7214 5.923244893101e+00
RINT6564 nd6564 nd7215 5.923244893101e+00
RINT6565 nd6565 nd7216 5.923244893101e+00
RINT6566 nd6566 nd7217 5.923244893101e+00
RINT6567 nd6567 nd7218 5.923244893101e+00
RINT6568 nd6568 nd7219 5.923244893101e+00
RINT6569 nd6569 nd7220 5.923244893101e+00
RINT6570 nd6570 nd7221 5.923244893101e+00
RINT6571 nd6571 nd7222 5.923244893101e+00
RINT6572 nd6572 nd7223 9.521626084020e+00
RINT6573 nd6573 nd7224 8.221970933165e+00
RINT6574 nd6574 nd7225 8.221970933165e+00
RINT6575 nd6575 nd7226 4.770274982191e+02
RINT6576 nd6576 nd7227 1.692221380459e+01
RINT6577 nd6577 nd7228 1.704190338874e+01
RINT6578 nd6578 nd7229 1.704190338874e+01
RINT6579 nd6579 nd7230 6.769422734972e+02
RINT6580 nd6580 nd7231 1.128237122495e+02
RINT6581 nd6581 nd7232 1.934120781421e+02
RINT6582 nd6582 nd7233 1.934120781421e+02
RINT6583 nd6583 nd7234 1.934120781421e+02
RINT6584 nd6584 nd7235 1.934120781421e+02
RINT6585 nd6585 nd7236 1.934120781421e+02
RINT6586 nd6586 nd7237 1.934120781421e+02
RINT6587 nd6587 nd7238 1.934120781421e+02
RINT6588 nd6588 nd7239 4.298046180935e+01
RINT6589 nd6589 nd7240 4.298046180935e+01
RINT6590 nd6590 nd7241 8.910390474536e+02
RINT6591 nd6591 nd7242 6.408848699791e+01
RINT6592 nd6592 nd7243 1.421578774344e+03
RINT6593 nd6593 nd7244 5.923244893101e+00
RINT6594 nd6594 nd7245 5.923244893101e+00
RINT6595 nd6595 nd7246 5.923244893101e+00
RINT6596 nd6596 nd7247 5.923244893101e+00
RINT6597 nd6597 nd7248 5.923244893101e+00
RINT6598 nd6598 nd7249 5.923244893101e+00
RINT6599 nd6599 nd7250 5.923244893101e+00
RINT6600 nd6600 nd7251 5.923244893101e+00
RINT6601 nd6601 nd7252 5.923244893101e+00
RINT6602 nd6602 nd7253 5.923244893101e+00
RINT6603 nd6603 nd7254 6.999506028131e+01
RINT6604 nd6604 nd7255 6.044107865818e+01
RINT6605 nd6605 nd7256 6.044107865818e+01
RINT6606 nd6606 nd7257 3.506708643992e+03
RINT6607 nd6607 nd7258 1.243980140465e+02
RINT6608 nd6608 nd7259 1.252778721279e+02
RINT6609 nd6609 nd7260 1.252778721279e+02
RINT6610 nd6610 nd7261 3.265707031250e+05
RINT6611 nd6611 nd7262 5.442845052083e+04
RINT6612 nd6612 nd7263 9.330591517857e+04
RINT6613 nd6613 nd7264 9.330591517857e+04
RINT6614 nd6614 nd7265 9.330591517857e+04
RINT6615 nd6615 nd7266 9.330591517857e+04
RINT6616 nd6616 nd7267 9.330591517857e+04
RINT6617 nd6617 nd7268 9.330591517857e+04
RINT6618 nd6618 nd7269 9.330591517857e+04
RINT6619 nd6619 nd7270 2.073464781746e+04
RINT6620 nd6620 nd7271 2.073464781746e+04
RINT6621 nd6621 nd7272 6.550176544339e+03
RINT6622 nd6622 nd7273 4.711251493362e+02
RINT6623 nd6623 nd7274 1.045026250000e+04
RINT6624 nd6624 nd7275 4.354276041667e+01
RINT6625 nd6625 nd7276 4.354276041667e+01
RINT6626 nd6626 nd7277 4.354276041667e+01
RINT6627 nd6627 nd7278 4.354276041667e+01
RINT6628 nd6628 nd7279 4.354276041667e+01
RINT6629 nd6629 nd7280 4.354276041667e+01
RINT6630 nd6630 nd7281 4.354276041667e+01
RINT6631 nd6631 nd7282 4.354276041667e+01
RINT6632 nd6632 nd7283 4.354276041667e+01
RINT6633 nd6633 nd7284 4.354276041667e+01
RINT6634 nd6634 nd7285 7.310392023728e+00
RINT6635 nd6635 nd7286 6.312559451374e+00
RINT6636 nd6636 nd7287 6.312559451374e+00
RINT6637 nd6637 nd7288 3.662460579010e+02
RINT6638 nd6638 nd7289 1.299232040087e+01
RINT6639 nd6639 nd7290 1.308421413557e+01
RINT6640 nd6640 nd7291 1.308421413557e+01
RINT6641 nd6641 nd7292 3.883351253541e+03
RINT6642 nd6642 nd7293 6.126511232794e+02
RINT6643 nd6643 nd7294 1.068078026015e+03
RINT6644 nd6644 nd7295 1.068078026015e+03
RINT6645 nd6645 nd7296 1.068078026015e+03
RINT6646 nd6646 nd7297 1.068078026015e+03
RINT6647 nd6647 nd7298 1.068078026015e+03
RINT6648 nd6648 nd7299 1.068078026015e+03
RINT6649 nd6649 nd7300 1.068078026015e+03
RINT6650 nd6650 nd7301 2.333909041065e+02
RINT6651 nd6651 nd7302 2.341781857809e+02
RINT6652 nd6652 nd7303 6.841105382479e+02
RINT6653 nd6653 nd7304 4.920503704179e+01
RINT6654 nd6654 nd7305 1.091441529143e+03
RINT6655 nd6655 nd7306 4.547673038094e+00
RINT6656 nd6656 nd7307 4.547673038094e+00
RINT6657 nd6657 nd7308 4.547673038094e+00
RINT6658 nd6658 nd7309 4.547673038094e+00
RINT6659 nd6659 nd7310 4.547673038094e+00
RINT6660 nd6660 nd7311 4.547673038094e+00
RINT6661 nd6661 nd7312 4.547673038094e+00
RINT6662 nd6662 nd7313 4.547673038094e+00
RINT6663 nd6663 nd7314 4.547673038094e+00
RINT6664 nd6664 nd7315 4.547673038094e+00
RINT6665 nd6665 nd7316 7.310392023728e+00
RINT6666 nd6666 nd7317 6.312559451374e+00
RINT6667 nd6667 nd7318 6.312559451374e+00
RINT6668 nd6668 nd7319 3.662460579010e+02
RINT6669 nd6669 nd7320 1.299232040087e+01
RINT6670 nd6670 nd7321 1.308421413557e+01
RINT6671 nd6671 nd7322 1.308421413557e+01
RINT6672 nd6672 nd7323 3.883351253541e+03
RINT6673 nd6673 nd7324 6.126511232794e+02
RINT6674 nd6674 nd7325 1.068078026015e+03
RINT6675 nd6675 nd7326 1.068078026015e+03
RINT6676 nd6676 nd7327 1.068078026015e+03
RINT6677 nd6677 nd7328 1.068078026015e+03
RINT6678 nd6678 nd7329 1.068078026015e+03
RINT6679 nd6679 nd7330 1.068078026015e+03
RINT6680 nd6680 nd7331 1.068078026015e+03
RINT6681 nd6681 nd7332 2.333909041065e+02
RINT6682 nd6682 nd7333 2.341781857809e+02
RINT6683 nd6683 nd7334 6.841105382479e+02
RINT6684 nd6684 nd7335 4.920503704179e+01
RINT6685 nd6685 nd7336 1.091441529143e+03
RINT6686 nd6686 nd7337 4.547673038094e+00
RINT6687 nd6687 nd7338 4.547673038094e+00
RINT6688 nd6688 nd7339 4.547673038094e+00
RINT6689 nd6689 nd7340 4.547673038094e+00
RINT6690 nd6690 nd7341 4.547673038094e+00
RINT6691 nd6691 nd7342 4.547673038094e+00
RINT6692 nd6692 nd7343 4.547673038094e+00
RINT6693 nd6693 nd7344 4.547673038094e+00
RINT6694 nd6694 nd7345 4.547673038094e+00
RINT6695 nd6695 nd7346 4.547673038094e+00
RINT6696 nd6696 nd7347 7.310392023728e+00
RINT6697 nd6697 nd7348 6.312559451374e+00
RINT6698 nd6698 nd7349 6.312559451374e+00
RINT6699 nd6699 nd7350 3.662460579010e+02
RINT6700 nd6700 nd7351 1.299232040087e+01
RINT6701 nd6701 nd7352 1.308421413557e+01
RINT6702 nd6702 nd7353 1.308421413557e+01
RINT6703 nd6703 nd7354 3.883351253541e+03
RINT6704 nd6704 nd7355 6.126511232794e+02
RINT6705 nd6705 nd7356 1.068078026015e+03
RINT6706 nd6706 nd7357 1.068078026015e+03
RINT6707 nd6707 nd7358 1.068078026015e+03
RINT6708 nd6708 nd7359 1.068078026015e+03
RINT6709 nd6709 nd7360 1.068078026015e+03
RINT6710 nd6710 nd7361 1.068078026015e+03
RINT6711 nd6711 nd7362 1.068078026015e+03
RINT6712 nd6712 nd7363 2.333909041065e+02
RINT6713 nd6713 nd7364 2.341781857809e+02
RINT6714 nd6714 nd7365 6.841105382479e+02
RINT6715 nd6715 nd7366 4.920503704179e+01
RINT6716 nd6716 nd7367 1.091441529143e+03
RINT6717 nd6717 nd7368 4.547673038094e+00
RINT6718 nd6718 nd7369 4.547673038094e+00
RINT6719 nd6719 nd7370 4.547673038094e+00
RINT6720 nd6720 nd7371 4.547673038094e+00
RINT6721 nd6721 nd7372 4.547673038094e+00
RINT6722 nd6722 nd7373 4.547673038094e+00
RINT6723 nd6723 nd7374 4.547673038094e+00
RINT6724 nd6724 nd7375 4.547673038094e+00
RINT6725 nd6725 nd7376 4.547673038094e+00
RINT6726 nd6726 nd7377 4.547673038094e+00
RINT6727 nd6727 nd7378 7.310392023728e+00
RINT6728 nd6728 nd7379 6.312559451374e+00
RINT6729 nd6729 nd7380 6.312559451374e+00
RINT6730 nd6730 nd7381 3.662460579010e+02
RINT6731 nd6731 nd7382 1.299232040087e+01
RINT6732 nd6732 nd7383 1.308421413557e+01
RINT6733 nd6733 nd7384 1.308421413557e+01
RINT6734 nd6734 nd7385 3.883351253541e+03
RINT6735 nd6735 nd7386 6.126511232794e+02
RINT6736 nd6736 nd7387 1.068078026015e+03
RINT6737 nd6737 nd7388 1.068078026015e+03
RINT6738 nd6738 nd7389 1.068078026015e+03
RINT6739 nd6739 nd7390 1.068078026015e+03
RINT6740 nd6740 nd7391 1.068078026015e+03
RINT6741 nd6741 nd7392 1.068078026015e+03
RINT6742 nd6742 nd7393 1.068078026015e+03
RINT6743 nd6743 nd7394 2.333909041065e+02
RINT6744 nd6744 nd7395 2.341781857809e+02
RINT6745 nd6745 nd7396 6.841105382479e+02
RINT6746 nd6746 nd7397 4.920503704179e+01
RINT6747 nd6747 nd7398 1.091441529143e+03
RINT6748 nd6748 nd7399 4.547673038094e+00
RINT6749 nd6749 nd7400 4.547673038094e+00
RINT6750 nd6750 nd7401 4.547673038094e+00
RINT6751 nd6751 nd7402 4.547673038094e+00
RINT6752 nd6752 nd7403 4.547673038094e+00
RINT6753 nd6753 nd7404 4.547673038094e+00
RINT6754 nd6754 nd7405 4.547673038094e+00
RINT6755 nd6755 nd7406 4.547673038094e+00
RINT6756 nd6756 nd7407 4.547673038094e+00
RINT6757 nd6757 nd7408 4.547673038094e+00
RINT6758 nd6758 nd7409 7.310392023728e+00
RINT6759 nd6759 nd7410 6.312559451374e+00
RINT6760 nd6760 nd7411 6.312559451374e+00
RINT6761 nd6761 nd7412 3.662460579010e+02
RINT6762 nd6762 nd7413 1.299232040087e+01
RINT6763 nd6763 nd7414 1.308421413557e+01
RINT6764 nd6764 nd7415 1.308421413557e+01
RINT6765 nd6765 nd7416 3.883351253541e+03
RINT6766 nd6766 nd7417 6.126511232794e+02
RINT6767 nd6767 nd7418 1.068078026015e+03
RINT6768 nd6768 nd7419 1.068078026015e+03
RINT6769 nd6769 nd7420 1.068078026015e+03
RINT6770 nd6770 nd7421 1.068078026015e+03
RINT6771 nd6771 nd7422 1.068078026015e+03
RINT6772 nd6772 nd7423 1.068078026015e+03
RINT6773 nd6773 nd7424 1.068078026015e+03
RINT6774 nd6774 nd7425 2.333909041065e+02
RINT6775 nd6775 nd7426 2.341781857809e+02
RINT6776 nd6776 nd7427 6.841105382479e+02
RINT6777 nd6777 nd7428 4.920503704179e+01
RINT6778 nd6778 nd7429 1.091441529143e+03
RINT6779 nd6779 nd7430 4.547673038094e+00
RINT6780 nd6780 nd7431 4.547673038094e+00
RINT6781 nd6781 nd7432 4.547673038094e+00
RINT6782 nd6782 nd7433 4.547673038094e+00
RINT6783 nd6783 nd7434 4.547673038094e+00
RINT6784 nd6784 nd7435 4.547673038094e+00
RINT6785 nd6785 nd7436 4.547673038094e+00
RINT6786 nd6786 nd7437 4.547673038094e+00
RINT6787 nd6787 nd7438 4.547673038094e+00
RINT6788 nd6788 nd7439 4.547673038094e+00
RINT6789 nd6789 nd7440 7.310392023728e+00
RINT6790 nd6790 nd7441 6.312559451374e+00
RINT6791 nd6791 nd7442 6.312559451374e+00
RINT6792 nd6792 nd7443 3.662460579010e+02
RINT6793 nd6793 nd7444 1.299232040087e+01
RINT6794 nd6794 nd7445 1.308421413557e+01
RINT6795 nd6795 nd7446 1.308421413557e+01
RINT6796 nd6796 nd7447 3.883351253541e+03
RINT6797 nd6797 nd7448 6.126511232794e+02
RINT6798 nd6798 nd7449 1.068078026015e+03
RINT6799 nd6799 nd7450 1.068078026015e+03
RINT6800 nd6800 nd7451 1.068078026015e+03
RINT6801 nd6801 nd7452 1.068078026015e+03
RINT6802 nd6802 nd7453 1.068078026015e+03
RINT6803 nd6803 nd7454 1.068078026015e+03
RINT6804 nd6804 nd7455 1.068078026015e+03
RINT6805 nd6805 nd7456 2.333909041065e+02
RINT6806 nd6806 nd7457 2.341781857809e+02
RINT6807 nd6807 nd7458 6.841105382479e+02
RINT6808 nd6808 nd7459 4.920503704179e+01
RINT6809 nd6809 nd7460 1.091441529143e+03
RINT6810 nd6810 nd7461 4.547673038094e+00
RINT6811 nd6811 nd7462 4.547673038094e+00
RINT6812 nd6812 nd7463 4.547673038094e+00
RINT6813 nd6813 nd7464 4.547673038094e+00
RINT6814 nd6814 nd7465 4.547673038094e+00
RINT6815 nd6815 nd7466 4.547673038094e+00
RINT6816 nd6816 nd7467 4.547673038094e+00
RINT6817 nd6817 nd7468 4.547673038094e+00
RINT6818 nd6818 nd7469 4.547673038094e+00
RINT6819 nd6819 nd7470 4.547673038094e+00
RINT6820 nd6820 nd7471 6.999506028131e+01
RINT6821 nd6821 nd7472 6.044107865818e+01
RINT6822 nd6822 nd7473 6.044107865818e+01
RINT6823 nd6823 nd7474 3.506708643992e+03
RINT6824 nd6824 nd7475 1.243980140465e+02
RINT6825 nd6825 nd7476 1.252778721279e+02
RINT6826 nd6826 nd7477 1.252778721279e+02
RINT6827 nd6827 nd7478 3.265707031250e+05
RINT6828 nd6828 nd7479 5.442845052083e+04
RINT6829 nd6829 nd7480 9.330591517857e+04
RINT6830 nd6830 nd7481 9.330591517857e+04
RINT6831 nd6831 nd7482 9.330591517857e+04
RINT6832 nd6832 nd7483 9.330591517857e+04
RINT6833 nd6833 nd7484 9.330591517857e+04
RINT6834 nd6834 nd7485 9.330591517857e+04
RINT6835 nd6835 nd7486 9.330591517857e+04
RINT6836 nd6836 nd7487 2.073464781746e+04
RINT6837 nd6837 nd7488 2.073464781746e+04
RINT6838 nd6838 nd7489 6.550176544339e+03
RINT6839 nd6839 nd7490 4.711251493362e+02
RINT6840 nd6840 nd7491 1.045026250000e+04
RINT6841 nd6841 nd7492 4.354276041667e+01
RINT6842 nd6842 nd7493 4.354276041667e+01
RINT6843 nd6843 nd7494 4.354276041667e+01
RINT6844 nd6844 nd7495 4.354276041667e+01
RINT6845 nd6845 nd7496 4.354276041667e+01
RINT6846 nd6846 nd7497 4.354276041667e+01
RINT6847 nd6847 nd7498 4.354276041667e+01
RINT6848 nd6848 nd7499 4.354276041667e+01
RINT6849 nd6849 nd7500 4.354276041667e+01
RINT6850 nd6850 nd7501 4.354276041667e+01
RINT6851 nd6851 nd7502 7.310392023728e+00
RINT6852 nd6852 nd7503 6.312559451374e+00
RINT6853 nd6853 nd7504 6.312559451374e+00
RINT6854 nd6854 nd7505 3.662460579010e+02
RINT6855 nd6855 nd7506 1.299232040087e+01
RINT6856 nd6856 nd7507 1.308421413557e+01
RINT6857 nd6857 nd7508 1.308421413557e+01
RINT6858 nd6858 nd7509 3.883351253541e+03
RINT6859 nd6859 nd7510 6.126511232794e+02
RINT6860 nd6860 nd7511 1.068078026015e+03
RINT6861 nd6861 nd7512 1.068078026015e+03
RINT6862 nd6862 nd7513 1.068078026015e+03
RINT6863 nd6863 nd7514 1.068078026015e+03
RINT6864 nd6864 nd7515 1.068078026015e+03
RINT6865 nd6865 nd7516 1.068078026015e+03
RINT6866 nd6866 nd7517 1.068078026015e+03
RINT6867 nd6867 nd7518 2.333909041065e+02
RINT6868 nd6868 nd7519 2.341781857809e+02
RINT6869 nd6869 nd7520 6.841105382479e+02
RINT6870 nd6870 nd7521 4.920503704179e+01
RINT6871 nd6871 nd7522 1.091441529143e+03
RINT6872 nd6872 nd7523 4.547673038094e+00
RINT6873 nd6873 nd7524 4.547673038094e+00
RINT6874 nd6874 nd7525 4.547673038094e+00
RINT6875 nd6875 nd7526 4.547673038094e+00
RINT6876 nd6876 nd7527 4.547673038094e+00
RINT6877 nd6877 nd7528 4.547673038094e+00
RINT6878 nd6878 nd7529 4.547673038094e+00
RINT6879 nd6879 nd7530 4.547673038094e+00
RINT6880 nd6880 nd7531 4.547673038094e+00
RINT6881 nd6881 nd7532 4.547673038094e+00
RINT6882 nd6882 nd7533 7.310392023728e+00
RINT6883 nd6883 nd7534 6.312559451374e+00
RINT6884 nd6884 nd7535 6.312559451374e+00
RINT6885 nd6885 nd7536 3.662460579010e+02
RINT6886 nd6886 nd7537 1.299232040087e+01
RINT6887 nd6887 nd7538 1.308421413557e+01
RINT6888 nd6888 nd7539 1.308421413557e+01
RINT6889 nd6889 nd7540 3.883351253541e+03
RINT6890 nd6890 nd7541 6.126511232794e+02
RINT6891 nd6891 nd7542 1.068078026015e+03
RINT6892 nd6892 nd7543 1.068078026015e+03
RINT6893 nd6893 nd7544 1.068078026015e+03
RINT6894 nd6894 nd7545 1.068078026015e+03
RINT6895 nd6895 nd7546 1.068078026015e+03
RINT6896 nd6896 nd7547 1.068078026015e+03
RINT6897 nd6897 nd7548 1.068078026015e+03
RINT6898 nd6898 nd7549 2.333909041065e+02
RINT6899 nd6899 nd7550 2.341781857809e+02
RINT6900 nd6900 nd7551 6.841105382479e+02
RINT6901 nd6901 nd7552 4.920503704179e+01
RINT6902 nd6902 nd7553 1.091441529143e+03
RINT6903 nd6903 nd7554 4.547673038094e+00
RINT6904 nd6904 nd7555 4.547673038094e+00
RINT6905 nd6905 nd7556 4.547673038094e+00
RINT6906 nd6906 nd7557 4.547673038094e+00
RINT6907 nd6907 nd7558 4.547673038094e+00
RINT6908 nd6908 nd7559 4.547673038094e+00
RINT6909 nd6909 nd7560 4.547673038094e+00
RINT6910 nd6910 nd7561 4.547673038094e+00
RINT6911 nd6911 nd7562 4.547673038094e+00
RINT6912 nd6912 nd7563 4.547673038094e+00
RINT6913 nd6913 nd7564 7.310392023728e+00
RINT6914 nd6914 nd7565 6.312559451374e+00
RINT6915 nd6915 nd7566 6.312559451374e+00
RINT6916 nd6916 nd7567 3.662460579010e+02
RINT6917 nd6917 nd7568 1.299232040087e+01
RINT6918 nd6918 nd7569 1.308421413557e+01
RINT6919 nd6919 nd7570 1.308421413557e+01
RINT6920 nd6920 nd7571 3.883351253541e+03
RINT6921 nd6921 nd7572 6.126511232794e+02
RINT6922 nd6922 nd7573 1.068078026015e+03
RINT6923 nd6923 nd7574 1.068078026015e+03
RINT6924 nd6924 nd7575 1.068078026015e+03
RINT6925 nd6925 nd7576 1.068078026015e+03
RINT6926 nd6926 nd7577 1.068078026015e+03
RINT6927 nd6927 nd7578 1.068078026015e+03
RINT6928 nd6928 nd7579 1.068078026015e+03
RINT6929 nd6929 nd7580 2.333909041065e+02
RINT6930 nd6930 nd7581 2.341781857809e+02
RINT6931 nd6931 nd7582 6.841105382479e+02
RINT6932 nd6932 nd7583 4.920503704179e+01
RINT6933 nd6933 nd7584 1.091441529143e+03
RINT6934 nd6934 nd7585 4.547673038094e+00
RINT6935 nd6935 nd7586 4.547673038094e+00
RINT6936 nd6936 nd7587 4.547673038094e+00
RINT6937 nd6937 nd7588 4.547673038094e+00
RINT6938 nd6938 nd7589 4.547673038094e+00
RINT6939 nd6939 nd7590 4.547673038094e+00
RINT6940 nd6940 nd7591 4.547673038094e+00
RINT6941 nd6941 nd7592 4.547673038094e+00
RINT6942 nd6942 nd7593 4.547673038094e+00
RINT6943 nd6943 nd7594 4.547673038094e+00
RINT6944 nd6944 nd7595 7.310392023728e+00
RINT6945 nd6945 nd7596 6.312559451374e+00
RINT6946 nd6946 nd7597 6.312559451374e+00
RINT6947 nd6947 nd7598 3.662460579010e+02
RINT6948 nd6948 nd7599 1.299232040087e+01
RINT6949 nd6949 nd7600 1.308421413557e+01
RINT6950 nd6950 nd7601 1.308421413557e+01
RINT6951 nd6951 nd7602 3.883351253541e+03
RINT6952 nd6952 nd7603 6.126511232794e+02
RINT6953 nd6953 nd7604 1.068078026015e+03
RINT6954 nd6954 nd7605 1.068078026015e+03
RINT6955 nd6955 nd7606 1.068078026015e+03
RINT6956 nd6956 nd7607 1.068078026015e+03
RINT6957 nd6957 nd7608 1.068078026015e+03
RINT6958 nd6958 nd7609 1.068078026015e+03
RINT6959 nd6959 nd7610 1.068078026015e+03
RINT6960 nd6960 nd7611 2.333909041065e+02
RINT6961 nd6961 nd7612 2.341781857809e+02
RINT6962 nd6962 nd7613 6.841105382479e+02
RINT6963 nd6963 nd7614 4.920503704179e+01
RINT6964 nd6964 nd7615 1.091441529143e+03
RINT6965 nd6965 nd7616 4.547673038094e+00
RINT6966 nd6966 nd7617 4.547673038094e+00
RINT6967 nd6967 nd7618 4.547673038094e+00
RINT6968 nd6968 nd7619 4.547673038094e+00
RINT6969 nd6969 nd7620 4.547673038094e+00
RINT6970 nd6970 nd7621 4.547673038094e+00
RINT6971 nd6971 nd7622 4.547673038094e+00
RINT6972 nd6972 nd7623 4.547673038094e+00
RINT6973 nd6973 nd7624 4.547673038094e+00
RINT6974 nd6974 nd7625 4.547673038094e+00
RINT6975 nd6975 nd7626 7.310392023728e+00
RINT6976 nd6976 nd7627 6.312559451374e+00
RINT6977 nd6977 nd7628 6.312559451374e+00
RINT6978 nd6978 nd7629 3.662460579010e+02
RINT6979 nd6979 nd7630 1.299232040087e+01
RINT6980 nd6980 nd7631 1.308421413557e+01
RINT6981 nd6981 nd7632 1.308421413557e+01
RINT6982 nd6982 nd7633 3.883351253541e+03
RINT6983 nd6983 nd7634 6.126511232794e+02
RINT6984 nd6984 nd7635 1.068078026015e+03
RINT6985 nd6985 nd7636 1.068078026015e+03
RINT6986 nd6986 nd7637 1.068078026015e+03
RINT6987 nd6987 nd7638 1.068078026015e+03
RINT6988 nd6988 nd7639 1.068078026015e+03
RINT6989 nd6989 nd7640 1.068078026015e+03
RINT6990 nd6990 nd7641 1.068078026015e+03
RINT6991 nd6991 nd7642 2.333909041065e+02
RINT6992 nd6992 nd7643 2.341781857809e+02
RINT6993 nd6993 nd7644 6.841105382479e+02
RINT6994 nd6994 nd7645 4.920503704179e+01
RINT6995 nd6995 nd7646 1.091441529143e+03
RINT6996 nd6996 nd7647 4.547673038094e+00
RINT6997 nd6997 nd7648 4.547673038094e+00
RINT6998 nd6998 nd7649 4.547673038094e+00
RINT6999 nd6999 nd7650 4.547673038094e+00
RINT7000 nd7000 nd7651 4.547673038094e+00
RINT7001 nd7001 nd7652 4.547673038094e+00
RINT7002 nd7002 nd7653 4.547673038094e+00
RINT7003 nd7003 nd7654 4.547673038094e+00
RINT7004 nd7004 nd7655 4.547673038094e+00
RINT7005 nd7005 nd7656 4.547673038094e+00
RINT7006 nd7006 nd7657 7.310392023728e+00
RINT7007 nd7007 nd7658 6.312559451374e+00
RINT7008 nd7008 nd7659 6.312559451374e+00
RINT7009 nd7009 nd7660 3.662460579010e+02
RINT7010 nd7010 nd7661 1.299232040087e+01
RINT7011 nd7011 nd7662 1.308421413557e+01
RINT7012 nd7012 nd7663 1.308421413557e+01
RINT7013 nd7013 nd7664 3.883351253541e+03
RINT7014 nd7014 nd7665 6.126511232794e+02
RINT7015 nd7015 nd7666 1.068078026015e+03
RINT7016 nd7016 nd7667 1.068078026015e+03
RINT7017 nd7017 nd7668 1.068078026015e+03
RINT7018 nd7018 nd7669 1.068078026015e+03
RINT7019 nd7019 nd7670 1.068078026015e+03
RINT7020 nd7020 nd7671 1.068078026015e+03
RINT7021 nd7021 nd7672 1.068078026015e+03
RINT7022 nd7022 nd7673 2.333909041065e+02
RINT7023 nd7023 nd7674 2.341781857809e+02
RINT7024 nd7024 nd7675 6.841105382479e+02
RINT7025 nd7025 nd7676 4.920503704179e+01
RINT7026 nd7026 nd7677 1.091441529143e+03
RINT7027 nd7027 nd7678 4.547673038094e+00
RINT7028 nd7028 nd7679 4.547673038094e+00
RINT7029 nd7029 nd7680 4.547673038094e+00
RINT7030 nd7030 nd7681 4.547673038094e+00
RINT7031 nd7031 nd7682 4.547673038094e+00
RINT7032 nd7032 nd7683 4.547673038094e+00
RINT7033 nd7033 nd7684 4.547673038094e+00
RINT7034 nd7034 nd7685 4.547673038094e+00
RINT7035 nd7035 nd7686 4.547673038094e+00
RINT7036 nd7036 nd7687 4.547673038094e+00
RINT7037 nd7037 nd7688 6.999506028131e+01
RINT7038 nd7038 nd7689 6.044107865818e+01
RINT7039 nd7039 nd7690 6.044107865818e+01
RINT7040 nd7040 nd7691 3.506708643992e+03
RINT7041 nd7041 nd7692 1.243980140465e+02
RINT7042 nd7042 nd7693 1.252778721279e+02
RINT7043 nd7043 nd7694 1.252778721279e+02
RINT7044 nd7044 nd7695 3.265707031250e+05
RINT7045 nd7045 nd7696 5.442845052083e+04
RINT7046 nd7046 nd7697 9.330591517857e+04
RINT7047 nd7047 nd7698 9.330591517857e+04
RINT7048 nd7048 nd7699 9.330591517857e+04
RINT7049 nd7049 nd7700 9.330591517857e+04
RINT7050 nd7050 nd7701 9.330591517857e+04
RINT7051 nd7051 nd7702 9.330591517857e+04
RINT7052 nd7052 nd7703 9.330591517857e+04
RINT7053 nd7053 nd7704 2.073464781746e+04
RINT7054 nd7054 nd7705 2.073464781746e+04
RINT7055 nd7055 nd7706 6.550176544339e+03
RINT7056 nd7056 nd7707 4.711251493362e+02
RINT7057 nd7057 nd7708 1.045026250000e+04
RINT7058 nd7058 nd7709 4.354276041667e+01
RINT7059 nd7059 nd7710 4.354276041667e+01
RINT7060 nd7060 nd7711 4.354276041667e+01
RINT7061 nd7061 nd7712 4.354276041667e+01
RINT7062 nd7062 nd7713 4.354276041667e+01
RINT7063 nd7063 nd7714 4.354276041667e+01
RINT7064 nd7064 nd7715 4.354276041667e+01
RINT7065 nd7065 nd7716 4.354276041667e+01
RINT7066 nd7066 nd7717 4.354276041667e+01
RINT7067 nd7067 nd7718 4.354276041667e+01
RINT7068 nd7068 nd7719 9.521626084020e+00
RINT7069 nd7069 nd7720 8.221970933165e+00
RINT7070 nd7070 nd7721 8.221970933165e+00
RINT7071 nd7071 nd7722 4.770274982191e+02
RINT7072 nd7072 nd7723 1.692221380459e+01
RINT7073 nd7073 nd7724 1.704190338874e+01
RINT7074 nd7074 nd7725 1.704190338874e+01
RINT7075 nd7075 nd7726 6.769422734972e+02
RINT7076 nd7076 nd7727 1.128237122495e+02
RINT7077 nd7077 nd7728 1.934120781421e+02
RINT7078 nd7078 nd7729 1.934120781421e+02
RINT7079 nd7079 nd7730 1.934120781421e+02
RINT7080 nd7080 nd7731 1.934120781421e+02
RINT7081 nd7081 nd7732 1.934120781421e+02
RINT7082 nd7082 nd7733 1.934120781421e+02
RINT7083 nd7083 nd7734 1.934120781421e+02
RINT7084 nd7084 nd7735 4.298046180935e+01
RINT7085 nd7085 nd7736 4.298046180935e+01
RINT7086 nd7086 nd7737 8.910390474536e+02
RINT7087 nd7087 nd7738 6.408848699791e+01
RINT7088 nd7088 nd7739 1.421578774344e+03
RINT7089 nd7089 nd7740 5.923244893101e+00
RINT7090 nd7090 nd7741 5.923244893101e+00
RINT7091 nd7091 nd7742 5.923244893101e+00
RINT7092 nd7092 nd7743 5.923244893101e+00
RINT7093 nd7093 nd7744 5.923244893101e+00
RINT7094 nd7094 nd7745 5.923244893101e+00
RINT7095 nd7095 nd7746 5.923244893101e+00
RINT7096 nd7096 nd7747 5.923244893101e+00
RINT7097 nd7097 nd7748 5.923244893101e+00
RINT7098 nd7098 nd7749 5.923244893101e+00
RINT7099 nd7099 nd7750 9.521626084020e+00
RINT7100 nd7100 nd7751 8.221970933165e+00
RINT7101 nd7101 nd7752 8.221970933165e+00
RINT7102 nd7102 nd7753 4.770274982191e+02
RINT7103 nd7103 nd7754 1.692221380459e+01
RINT7104 nd7104 nd7755 1.704190338874e+01
RINT7105 nd7105 nd7756 1.704190338874e+01
RINT7106 nd7106 nd7757 6.769422734972e+02
RINT7107 nd7107 nd7758 1.128237122495e+02
RINT7108 nd7108 nd7759 1.934120781421e+02
RINT7109 nd7109 nd7760 1.934120781421e+02
RINT7110 nd7110 nd7761 1.934120781421e+02
RINT7111 nd7111 nd7762 1.934120781421e+02
RINT7112 nd7112 nd7763 1.934120781421e+02
RINT7113 nd7113 nd7764 1.934120781421e+02
RINT7114 nd7114 nd7765 1.934120781421e+02
RINT7115 nd7115 nd7766 4.298046180935e+01
RINT7116 nd7116 nd7767 4.298046180935e+01
RINT7117 nd7117 nd7768 8.910390474536e+02
RINT7118 nd7118 nd7769 6.408848699791e+01
RINT7119 nd7119 nd7770 1.421578774344e+03
RINT7120 nd7120 nd7771 5.923244893101e+00
RINT7121 nd7121 nd7772 5.923244893101e+00
RINT7122 nd7122 nd7773 5.923244893101e+00
RINT7123 nd7123 nd7774 5.923244893101e+00
RINT7124 nd7124 nd7775 5.923244893101e+00
RINT7125 nd7125 nd7776 5.923244893101e+00
RINT7126 nd7126 nd7777 5.923244893101e+00
RINT7127 nd7127 nd7778 5.923244893101e+00
RINT7128 nd7128 nd7779 5.923244893101e+00
RINT7129 nd7129 nd7780 5.923244893101e+00
RINT7130 nd7130 nd7781 9.521626084020e+00
RINT7131 nd7131 nd7782 8.221970933165e+00
RINT7132 nd7132 nd7783 8.221970933165e+00
RINT7133 nd7133 nd7784 4.770274982191e+02
RINT7134 nd7134 nd7785 1.692221380459e+01
RINT7135 nd7135 nd7786 1.704190338874e+01
RINT7136 nd7136 nd7787 1.704190338874e+01
RINT7137 nd7137 nd7788 6.769422734972e+02
RINT7138 nd7138 nd7789 1.128237122495e+02
RINT7139 nd7139 nd7790 1.934120781421e+02
RINT7140 nd7140 nd7791 1.934120781421e+02
RINT7141 nd7141 nd7792 1.934120781421e+02
RINT7142 nd7142 nd7793 1.934120781421e+02
RINT7143 nd7143 nd7794 1.934120781421e+02
RINT7144 nd7144 nd7795 1.934120781421e+02
RINT7145 nd7145 nd7796 1.934120781421e+02
RINT7146 nd7146 nd7797 4.298046180935e+01
RINT7147 nd7147 nd7798 4.298046180935e+01
RINT7148 nd7148 nd7799 8.910390474536e+02
RINT7149 nd7149 nd7800 6.408848699791e+01
RINT7150 nd7150 nd7801 1.421578774344e+03
RINT7151 nd7151 nd7802 5.923244893101e+00
RINT7152 nd7152 nd7803 5.923244893101e+00
RINT7153 nd7153 nd7804 5.923244893101e+00
RINT7154 nd7154 nd7805 5.923244893101e+00
RINT7155 nd7155 nd7806 5.923244893101e+00
RINT7156 nd7156 nd7807 5.923244893101e+00
RINT7157 nd7157 nd7808 5.923244893101e+00
RINT7158 nd7158 nd7809 5.923244893101e+00
RINT7159 nd7159 nd7810 5.923244893101e+00
RINT7160 nd7160 nd7811 5.923244893101e+00
RINT7161 nd7161 nd7812 9.521626084020e+00
RINT7162 nd7162 nd7813 8.221970933165e+00
RINT7163 nd7163 nd7814 8.221970933165e+00
RINT7164 nd7164 nd7815 4.770274982191e+02
RINT7165 nd7165 nd7816 1.692221380459e+01
RINT7166 nd7166 nd7817 1.704190338874e+01
RINT7167 nd7167 nd7818 1.704190338874e+01
RINT7168 nd7168 nd7819 6.769422734972e+02
RINT7169 nd7169 nd7820 1.128237122495e+02
RINT7170 nd7170 nd7821 1.934120781421e+02
RINT7171 nd7171 nd7822 1.934120781421e+02
RINT7172 nd7172 nd7823 1.934120781421e+02
RINT7173 nd7173 nd7824 1.934120781421e+02
RINT7174 nd7174 nd7825 1.934120781421e+02
RINT7175 nd7175 nd7826 1.934120781421e+02
RINT7176 nd7176 nd7827 1.934120781421e+02
RINT7177 nd7177 nd7828 4.298046180935e+01
RINT7178 nd7178 nd7829 4.298046180935e+01
RINT7179 nd7179 nd7830 8.910390474536e+02
RINT7180 nd7180 nd7831 6.408848699791e+01
RINT7181 nd7181 nd7832 1.421578774344e+03
RINT7182 nd7182 nd7833 5.923244893101e+00
RINT7183 nd7183 nd7834 5.923244893101e+00
RINT7184 nd7184 nd7835 5.923244893101e+00
RINT7185 nd7185 nd7836 5.923244893101e+00
RINT7186 nd7186 nd7837 5.923244893101e+00
RINT7187 nd7187 nd7838 5.923244893101e+00
RINT7188 nd7188 nd7839 5.923244893101e+00
RINT7189 nd7189 nd7840 5.923244893101e+00
RINT7190 nd7190 nd7841 5.923244893101e+00
RINT7191 nd7191 nd7842 5.923244893101e+00
RINT7192 nd7192 nd7843 9.521626084020e+00
RINT7193 nd7193 nd7844 8.221970933165e+00
RINT7194 nd7194 nd7845 8.221970933165e+00
RINT7195 nd7195 nd7846 4.770274982191e+02
RINT7196 nd7196 nd7847 1.692221380459e+01
RINT7197 nd7197 nd7848 1.704190338874e+01
RINT7198 nd7198 nd7849 1.704190338874e+01
RINT7199 nd7199 nd7850 6.769422734972e+02
RINT7200 nd7200 nd7851 1.128237122495e+02
RINT7201 nd7201 nd7852 1.934120781421e+02
RINT7202 nd7202 nd7853 1.934120781421e+02
RINT7203 nd7203 nd7854 1.934120781421e+02
RINT7204 nd7204 nd7855 1.934120781421e+02
RINT7205 nd7205 nd7856 1.934120781421e+02
RINT7206 nd7206 nd7857 1.934120781421e+02
RINT7207 nd7207 nd7858 1.934120781421e+02
RINT7208 nd7208 nd7859 4.298046180935e+01
RINT7209 nd7209 nd7860 4.298046180935e+01
RINT7210 nd7210 nd7861 8.910390474536e+02
RINT7211 nd7211 nd7862 6.408848699791e+01
RINT7212 nd7212 nd7863 1.421578774344e+03
RINT7213 nd7213 nd7864 5.923244893101e+00
RINT7214 nd7214 nd7865 5.923244893101e+00
RINT7215 nd7215 nd7866 5.923244893101e+00
RINT7216 nd7216 nd7867 5.923244893101e+00
RINT7217 nd7217 nd7868 5.923244893101e+00
RINT7218 nd7218 nd7869 5.923244893101e+00
RINT7219 nd7219 nd7870 5.923244893101e+00
RINT7220 nd7220 nd7871 5.923244893101e+00
RINT7221 nd7221 nd7872 5.923244893101e+00
RINT7222 nd7222 nd7873 5.923244893101e+00
RINT7223 nd7223 nd7874 9.521626084020e+00
RINT7224 nd7224 nd7875 8.221970933165e+00
RINT7225 nd7225 nd7876 8.221970933165e+00
RINT7226 nd7226 nd7877 4.770274982191e+02
RINT7227 nd7227 nd7878 1.692221380459e+01
RINT7228 nd7228 nd7879 1.704190338874e+01
RINT7229 nd7229 nd7880 1.704190338874e+01
RINT7230 nd7230 nd7881 6.769422734972e+02
RINT7231 nd7231 nd7882 1.128237122495e+02
RINT7232 nd7232 nd7883 1.934120781421e+02
RINT7233 nd7233 nd7884 1.934120781421e+02
RINT7234 nd7234 nd7885 1.934120781421e+02
RINT7235 nd7235 nd7886 1.934120781421e+02
RINT7236 nd7236 nd7887 1.934120781421e+02
RINT7237 nd7237 nd7888 1.934120781421e+02
RINT7238 nd7238 nd7889 1.934120781421e+02
RINT7239 nd7239 nd7890 4.298046180935e+01
RINT7240 nd7240 nd7891 4.298046180935e+01
RINT7241 nd7241 nd7892 8.910390474536e+02
RINT7242 nd7242 nd7893 6.408848699791e+01
RINT7243 nd7243 nd7894 1.421578774344e+03
RINT7244 nd7244 nd7895 5.923244893101e+00
RINT7245 nd7245 nd7896 5.923244893101e+00
RINT7246 nd7246 nd7897 5.923244893101e+00
RINT7247 nd7247 nd7898 5.923244893101e+00
RINT7248 nd7248 nd7899 5.923244893101e+00
RINT7249 nd7249 nd7900 5.923244893101e+00
RINT7250 nd7250 nd7901 5.923244893101e+00
RINT7251 nd7251 nd7902 5.923244893101e+00
RINT7252 nd7252 nd7903 5.923244893101e+00
RINT7253 nd7253 nd7904 5.923244893101e+00
RINT7254 nd7254 nd7905 6.999506028131e+01
RINT7255 nd7255 nd7906 6.044107865818e+01
RINT7256 nd7256 nd7907 6.044107865818e+01
RINT7257 nd7257 nd7908 3.506708643992e+03
RINT7258 nd7258 nd7909 1.243980140465e+02
RINT7259 nd7259 nd7910 1.252778721279e+02
RINT7260 nd7260 nd7911 1.252778721279e+02
RINT7261 nd7261 nd7912 3.265707031250e+05
RINT7262 nd7262 nd7913 5.442845052083e+04
RINT7263 nd7263 nd7914 9.330591517857e+04
RINT7264 nd7264 nd7915 9.330591517857e+04
RINT7265 nd7265 nd7916 9.330591517857e+04
RINT7266 nd7266 nd7917 9.330591517857e+04
RINT7267 nd7267 nd7918 9.330591517857e+04
RINT7268 nd7268 nd7919 9.330591517857e+04
RINT7269 nd7269 nd7920 9.330591517857e+04
RINT7270 nd7270 nd7921 2.073464781746e+04
RINT7271 nd7271 nd7922 2.073464781746e+04
RINT7272 nd7272 nd7923 6.550176544339e+03
RINT7273 nd7273 nd7924 4.711251493362e+02
RINT7274 nd7274 nd7925 1.045026250000e+04
RINT7275 nd7275 nd7926 4.354276041667e+01
RINT7276 nd7276 nd7927 4.354276041667e+01
RINT7277 nd7277 nd7928 4.354276041667e+01
RINT7278 nd7278 nd7929 4.354276041667e+01
RINT7279 nd7279 nd7930 4.354276041667e+01
RINT7280 nd7280 nd7931 4.354276041667e+01
RINT7281 nd7281 nd7932 4.354276041667e+01
RINT7282 nd7282 nd7933 4.354276041667e+01
RINT7283 nd7283 nd7934 4.354276041667e+01
RINT7284 nd7284 nd7935 4.354276041667e+01
RINT7285 nd7285 nd7936 7.310392023728e+00
RINT7286 nd7286 nd7937 6.312559451374e+00
RINT7287 nd7287 nd7938 6.312559451374e+00
RINT7288 nd7288 nd7939 3.662460579010e+02
RINT7289 nd7289 nd7940 1.299232040087e+01
RINT7290 nd7290 nd7941 1.308421413557e+01
RINT7291 nd7291 nd7942 1.308421413557e+01
RINT7292 nd7292 nd7943 3.883351253541e+03
RINT7293 nd7293 nd7944 6.126511232794e+02
RINT7294 nd7294 nd7945 1.068078026015e+03
RINT7295 nd7295 nd7946 1.068078026015e+03
RINT7296 nd7296 nd7947 1.068078026015e+03
RINT7297 nd7297 nd7948 1.068078026015e+03
RINT7298 nd7298 nd7949 1.068078026015e+03
RINT7299 nd7299 nd7950 1.068078026015e+03
RINT7300 nd7300 nd7951 1.068078026015e+03
RINT7301 nd7301 nd7952 2.333909041065e+02
RINT7302 nd7302 nd7953 2.341781857809e+02
RINT7303 nd7303 nd7954 6.841105382479e+02
RINT7304 nd7304 nd7955 4.920503704179e+01
RINT7305 nd7305 nd7956 1.091441529143e+03
RINT7306 nd7306 nd7957 4.547673038094e+00
RINT7307 nd7307 nd7958 4.547673038094e+00
RINT7308 nd7308 nd7959 4.547673038094e+00
RINT7309 nd7309 nd7960 4.547673038094e+00
RINT7310 nd7310 nd7961 4.547673038094e+00
RINT7311 nd7311 nd7962 4.547673038094e+00
RINT7312 nd7312 nd7963 4.547673038094e+00
RINT7313 nd7313 nd7964 4.547673038094e+00
RINT7314 nd7314 nd7965 4.547673038094e+00
RINT7315 nd7315 nd7966 4.547673038094e+00
RINT7316 nd7316 nd7967 7.310392023728e+00
RINT7317 nd7317 nd7968 6.312559451374e+00
RINT7318 nd7318 nd7969 6.312559451374e+00
RINT7319 nd7319 nd7970 3.662460579010e+02
RINT7320 nd7320 nd7971 1.299232040087e+01
RINT7321 nd7321 nd7972 1.308421413557e+01
RINT7322 nd7322 nd7973 1.308421413557e+01
RINT7323 nd7323 nd7974 3.883351253541e+03
RINT7324 nd7324 nd7975 6.126511232794e+02
RINT7325 nd7325 nd7976 1.068078026015e+03
RINT7326 nd7326 nd7977 1.068078026015e+03
RINT7327 nd7327 nd7978 1.068078026015e+03
RINT7328 nd7328 nd7979 1.068078026015e+03
RINT7329 nd7329 nd7980 1.068078026015e+03
RINT7330 nd7330 nd7981 1.068078026015e+03
RINT7331 nd7331 nd7982 1.068078026015e+03
RINT7332 nd7332 nd7983 2.333909041065e+02
RINT7333 nd7333 nd7984 2.341781857809e+02
RINT7334 nd7334 nd7985 6.841105382479e+02
RINT7335 nd7335 nd7986 4.920503704179e+01
RINT7336 nd7336 nd7987 1.091441529143e+03
RINT7337 nd7337 nd7988 4.547673038094e+00
RINT7338 nd7338 nd7989 4.547673038094e+00
RINT7339 nd7339 nd7990 4.547673038094e+00
RINT7340 nd7340 nd7991 4.547673038094e+00
RINT7341 nd7341 nd7992 4.547673038094e+00
RINT7342 nd7342 nd7993 4.547673038094e+00
RINT7343 nd7343 nd7994 4.547673038094e+00
RINT7344 nd7344 nd7995 4.547673038094e+00
RINT7345 nd7345 nd7996 4.547673038094e+00
RINT7346 nd7346 nd7997 4.547673038094e+00
RINT7347 nd7347 nd7998 7.310392023728e+00
RINT7348 nd7348 nd7999 6.312559451374e+00
RINT7349 nd7349 nd8000 6.312559451374e+00
RINT7350 nd7350 nd8001 3.662460579010e+02
RINT7351 nd7351 nd8002 1.299232040087e+01
RINT7352 nd7352 nd8003 1.308421413557e+01
RINT7353 nd7353 nd8004 1.308421413557e+01
RINT7354 nd7354 nd8005 3.883351253541e+03
RINT7355 nd7355 nd8006 6.126511232794e+02
RINT7356 nd7356 nd8007 1.068078026015e+03
RINT7357 nd7357 nd8008 1.068078026015e+03
RINT7358 nd7358 nd8009 1.068078026015e+03
RINT7359 nd7359 nd8010 1.068078026015e+03
RINT7360 nd7360 nd8011 1.068078026015e+03
RINT7361 nd7361 nd8012 1.068078026015e+03
RINT7362 nd7362 nd8013 1.068078026015e+03
RINT7363 nd7363 nd8014 2.333909041065e+02
RINT7364 nd7364 nd8015 2.341781857809e+02
RINT7365 nd7365 nd8016 6.841105382479e+02
RINT7366 nd7366 nd8017 4.920503704179e+01
RINT7367 nd7367 nd8018 1.091441529143e+03
RINT7368 nd7368 nd8019 4.547673038094e+00
RINT7369 nd7369 nd8020 4.547673038094e+00
RINT7370 nd7370 nd8021 4.547673038094e+00
RINT7371 nd7371 nd8022 4.547673038094e+00
RINT7372 nd7372 nd8023 4.547673038094e+00
RINT7373 nd7373 nd8024 4.547673038094e+00
RINT7374 nd7374 nd8025 4.547673038094e+00
RINT7375 nd7375 nd8026 4.547673038094e+00
RINT7376 nd7376 nd8027 4.547673038094e+00
RINT7377 nd7377 nd8028 4.547673038094e+00
RINT7378 nd7378 nd8029 7.310392023728e+00
RINT7379 nd7379 nd8030 6.312559451374e+00
RINT7380 nd7380 nd8031 6.312559451374e+00
RINT7381 nd7381 nd8032 3.662460579010e+02
RINT7382 nd7382 nd8033 1.299232040087e+01
RINT7383 nd7383 nd8034 1.308421413557e+01
RINT7384 nd7384 nd8035 1.308421413557e+01
RINT7385 nd7385 nd8036 3.883351253541e+03
RINT7386 nd7386 nd8037 6.126511232794e+02
RINT7387 nd7387 nd8038 1.068078026015e+03
RINT7388 nd7388 nd8039 1.068078026015e+03
RINT7389 nd7389 nd8040 1.068078026015e+03
RINT7390 nd7390 nd8041 1.068078026015e+03
RINT7391 nd7391 nd8042 1.068078026015e+03
RINT7392 nd7392 nd8043 1.068078026015e+03
RINT7393 nd7393 nd8044 1.068078026015e+03
RINT7394 nd7394 nd8045 2.333909041065e+02
RINT7395 nd7395 nd8046 2.341781857809e+02
RINT7396 nd7396 nd8047 6.841105382479e+02
RINT7397 nd7397 nd8048 4.920503704179e+01
RINT7398 nd7398 nd8049 1.091441529143e+03
RINT7399 nd7399 nd8050 4.547673038094e+00
RINT7400 nd7400 nd8051 4.547673038094e+00
RINT7401 nd7401 nd8052 4.547673038094e+00
RINT7402 nd7402 nd8053 4.547673038094e+00
RINT7403 nd7403 nd8054 4.547673038094e+00
RINT7404 nd7404 nd8055 4.547673038094e+00
RINT7405 nd7405 nd8056 4.547673038094e+00
RINT7406 nd7406 nd8057 4.547673038094e+00
RINT7407 nd7407 nd8058 4.547673038094e+00
RINT7408 nd7408 nd8059 4.547673038094e+00
RINT7409 nd7409 nd8060 7.310392023728e+00
RINT7410 nd7410 nd8061 6.312559451374e+00
RINT7411 nd7411 nd8062 6.312559451374e+00
RINT7412 nd7412 nd8063 3.662460579010e+02
RINT7413 nd7413 nd8064 1.299232040087e+01
RINT7414 nd7414 nd8065 1.308421413557e+01
RINT7415 nd7415 nd8066 1.308421413557e+01
RINT7416 nd7416 nd8067 3.883351253541e+03
RINT7417 nd7417 nd8068 6.126511232794e+02
RINT7418 nd7418 nd8069 1.068078026015e+03
RINT7419 nd7419 nd8070 1.068078026015e+03
RINT7420 nd7420 nd8071 1.068078026015e+03
RINT7421 nd7421 nd8072 1.068078026015e+03
RINT7422 nd7422 nd8073 1.068078026015e+03
RINT7423 nd7423 nd8074 1.068078026015e+03
RINT7424 nd7424 nd8075 1.068078026015e+03
RINT7425 nd7425 nd8076 2.333909041065e+02
RINT7426 nd7426 nd8077 2.341781857809e+02
RINT7427 nd7427 nd8078 6.841105382479e+02
RINT7428 nd7428 nd8079 4.920503704179e+01
RINT7429 nd7429 nd8080 1.091441529143e+03
RINT7430 nd7430 nd8081 4.547673038094e+00
RINT7431 nd7431 nd8082 4.547673038094e+00
RINT7432 nd7432 nd8083 4.547673038094e+00
RINT7433 nd7433 nd8084 4.547673038094e+00
RINT7434 nd7434 nd8085 4.547673038094e+00
RINT7435 nd7435 nd8086 4.547673038094e+00
RINT7436 nd7436 nd8087 4.547673038094e+00
RINT7437 nd7437 nd8088 4.547673038094e+00
RINT7438 nd7438 nd8089 4.547673038094e+00
RINT7439 nd7439 nd8090 4.547673038094e+00
RINT7440 nd7440 nd8091 7.310392023728e+00
RINT7441 nd7441 nd8092 6.312559451374e+00
RINT7442 nd7442 nd8093 6.312559451374e+00
RINT7443 nd7443 nd8094 3.662460579010e+02
RINT7444 nd7444 nd8095 1.299232040087e+01
RINT7445 nd7445 nd8096 1.308421413557e+01
RINT7446 nd7446 nd8097 1.308421413557e+01
RINT7447 nd7447 nd8098 3.883351253541e+03
RINT7448 nd7448 nd8099 6.126511232794e+02
RINT7449 nd7449 nd8100 1.068078026015e+03
RINT7450 nd7450 nd8101 1.068078026015e+03
RINT7451 nd7451 nd8102 1.068078026015e+03
RINT7452 nd7452 nd8103 1.068078026015e+03
RINT7453 nd7453 nd8104 1.068078026015e+03
RINT7454 nd7454 nd8105 1.068078026015e+03
RINT7455 nd7455 nd8106 1.068078026015e+03
RINT7456 nd7456 nd8107 2.333909041065e+02
RINT7457 nd7457 nd8108 2.341781857809e+02
RINT7458 nd7458 nd8109 6.841105382479e+02
RINT7459 nd7459 nd8110 4.920503704179e+01
RINT7460 nd7460 nd8111 1.091441529143e+03
RINT7461 nd7461 nd8112 4.547673038094e+00
RINT7462 nd7462 nd8113 4.547673038094e+00
RINT7463 nd7463 nd8114 4.547673038094e+00
RINT7464 nd7464 nd8115 4.547673038094e+00
RINT7465 nd7465 nd8116 4.547673038094e+00
RINT7466 nd7466 nd8117 4.547673038094e+00
RINT7467 nd7467 nd8118 4.547673038094e+00
RINT7468 nd7468 nd8119 4.547673038094e+00
RINT7469 nd7469 nd8120 4.547673038094e+00
RINT7470 nd7470 nd8121 4.547673038094e+00
RINT7471 nd7471 nd8122 6.999506028131e+01
RINT7472 nd7472 nd8123 6.044107865818e+01
RINT7473 nd7473 nd8124 6.044107865818e+01
RINT7474 nd7474 nd8125 3.506708643992e+03
RINT7475 nd7475 nd8126 1.243980140465e+02
RINT7476 nd7476 nd8127 1.252778721279e+02
RINT7477 nd7477 nd8128 1.252778721279e+02
RINT7478 nd7478 nd8129 3.265707031250e+05
RINT7479 nd7479 nd8130 5.442845052083e+04
RINT7480 nd7480 nd8131 9.330591517857e+04
RINT7481 nd7481 nd8132 9.330591517857e+04
RINT7482 nd7482 nd8133 9.330591517857e+04
RINT7483 nd7483 nd8134 9.330591517857e+04
RINT7484 nd7484 nd8135 9.330591517857e+04
RINT7485 nd7485 nd8136 9.330591517857e+04
RINT7486 nd7486 nd8137 9.330591517857e+04
RINT7487 nd7487 nd8138 2.073464781746e+04
RINT7488 nd7488 nd8139 2.073464781746e+04
RINT7489 nd7489 nd8140 6.550176544339e+03
RINT7490 nd7490 nd8141 4.711251493362e+02
RINT7491 nd7491 nd8142 1.045026250000e+04
RINT7492 nd7492 nd8143 4.354276041667e+01
RINT7493 nd7493 nd8144 4.354276041667e+01
RINT7494 nd7494 nd8145 4.354276041667e+01
RINT7495 nd7495 nd8146 4.354276041667e+01
RINT7496 nd7496 nd8147 4.354276041667e+01
RINT7497 nd7497 nd8148 4.354276041667e+01
RINT7498 nd7498 nd8149 4.354276041667e+01
RINT7499 nd7499 nd8150 4.354276041667e+01
RINT7500 nd7500 nd8151 4.354276041667e+01
RINT7501 nd7501 nd8152 4.354276041667e+01
RINT7502 nd7502 nd8153 7.310392023728e+00
RINT7503 nd7503 nd8154 6.312559451374e+00
RINT7504 nd7504 nd8155 6.312559451374e+00
RINT7505 nd7505 nd8156 3.662460579010e+02
RINT7506 nd7506 nd8157 1.299232040087e+01
RINT7507 nd7507 nd8158 1.308421413557e+01
RINT7508 nd7508 nd8159 1.308421413557e+01
RINT7509 nd7509 nd8160 3.883351253541e+03
RINT7510 nd7510 nd8161 6.126511232794e+02
RINT7511 nd7511 nd8162 1.068078026015e+03
RINT7512 nd7512 nd8163 1.068078026015e+03
RINT7513 nd7513 nd8164 1.068078026015e+03
RINT7514 nd7514 nd8165 1.068078026015e+03
RINT7515 nd7515 nd8166 1.068078026015e+03
RINT7516 nd7516 nd8167 1.068078026015e+03
RINT7517 nd7517 nd8168 1.068078026015e+03
RINT7518 nd7518 nd8169 2.333909041065e+02
RINT7519 nd7519 nd8170 2.341781857809e+02
RINT7520 nd7520 nd8171 6.841105382479e+02
RINT7521 nd7521 nd8172 4.920503704179e+01
RINT7522 nd7522 nd8173 1.091441529143e+03
RINT7523 nd7523 nd8174 4.547673038094e+00
RINT7524 nd7524 nd8175 4.547673038094e+00
RINT7525 nd7525 nd8176 4.547673038094e+00
RINT7526 nd7526 nd8177 4.547673038094e+00
RINT7527 nd7527 nd8178 4.547673038094e+00
RINT7528 nd7528 nd8179 4.547673038094e+00
RINT7529 nd7529 nd8180 4.547673038094e+00
RINT7530 nd7530 nd8181 4.547673038094e+00
RINT7531 nd7531 nd8182 4.547673038094e+00
RINT7532 nd7532 nd8183 4.547673038094e+00
RINT7533 nd7533 nd8184 7.310392023728e+00
RINT7534 nd7534 nd8185 6.312559451374e+00
RINT7535 nd7535 nd8186 6.312559451374e+00
RINT7536 nd7536 nd8187 3.662460579010e+02
RINT7537 nd7537 nd8188 1.299232040087e+01
RINT7538 nd7538 nd8189 1.308421413557e+01
RINT7539 nd7539 nd8190 1.308421413557e+01
RINT7540 nd7540 nd8191 3.883351253541e+03
RINT7541 nd7541 nd8192 6.126511232794e+02
RINT7542 nd7542 nd8193 1.068078026015e+03
RINT7543 nd7543 nd8194 1.068078026015e+03
RINT7544 nd7544 nd8195 1.068078026015e+03
RINT7545 nd7545 nd8196 1.068078026015e+03
RINT7546 nd7546 nd8197 1.068078026015e+03
RINT7547 nd7547 nd8198 1.068078026015e+03
RINT7548 nd7548 nd8199 1.068078026015e+03
RINT7549 nd7549 nd8200 2.333909041065e+02
RINT7550 nd7550 nd8201 2.341781857809e+02
RINT7551 nd7551 nd8202 6.841105382479e+02
RINT7552 nd7552 nd8203 4.920503704179e+01
RINT7553 nd7553 nd8204 1.091441529143e+03
RINT7554 nd7554 nd8205 4.547673038094e+00
RINT7555 nd7555 nd8206 4.547673038094e+00
RINT7556 nd7556 nd8207 4.547673038094e+00
RINT7557 nd7557 nd8208 4.547673038094e+00
RINT7558 nd7558 nd8209 4.547673038094e+00
RINT7559 nd7559 nd8210 4.547673038094e+00
RINT7560 nd7560 nd8211 4.547673038094e+00
RINT7561 nd7561 nd8212 4.547673038094e+00
RINT7562 nd7562 nd8213 4.547673038094e+00
RINT7563 nd7563 nd8214 4.547673038094e+00
RINT7564 nd7564 nd8215 7.310392023728e+00
RINT7565 nd7565 nd8216 6.312559451374e+00
RINT7566 nd7566 nd8217 6.312559451374e+00
RINT7567 nd7567 nd8218 3.662460579010e+02
RINT7568 nd7568 nd8219 1.299232040087e+01
RINT7569 nd7569 nd8220 1.308421413557e+01
RINT7570 nd7570 nd8221 1.308421413557e+01
RINT7571 nd7571 nd8222 3.883351253541e+03
RINT7572 nd7572 nd8223 6.126511232794e+02
RINT7573 nd7573 nd8224 1.068078026015e+03
RINT7574 nd7574 nd8225 1.068078026015e+03
RINT7575 nd7575 nd8226 1.068078026015e+03
RINT7576 nd7576 nd8227 1.068078026015e+03
RINT7577 nd7577 nd8228 1.068078026015e+03
RINT7578 nd7578 nd8229 1.068078026015e+03
RINT7579 nd7579 nd8230 1.068078026015e+03
RINT7580 nd7580 nd8231 2.333909041065e+02
RINT7581 nd7581 nd8232 2.341781857809e+02
RINT7582 nd7582 nd8233 6.841105382479e+02
RINT7583 nd7583 nd8234 4.920503704179e+01
RINT7584 nd7584 nd8235 1.091441529143e+03
RINT7585 nd7585 nd8236 4.547673038094e+00
RINT7586 nd7586 nd8237 4.547673038094e+00
RINT7587 nd7587 nd8238 4.547673038094e+00
RINT7588 nd7588 nd8239 4.547673038094e+00
RINT7589 nd7589 nd8240 4.547673038094e+00
RINT7590 nd7590 nd8241 4.547673038094e+00
RINT7591 nd7591 nd8242 4.547673038094e+00
RINT7592 nd7592 nd8243 4.547673038094e+00
RINT7593 nd7593 nd8244 4.547673038094e+00
RINT7594 nd7594 nd8245 4.547673038094e+00
RINT7595 nd7595 nd8246 7.310392023728e+00
RINT7596 nd7596 nd8247 6.312559451374e+00
RINT7597 nd7597 nd8248 6.312559451374e+00
RINT7598 nd7598 nd8249 3.662460579010e+02
RINT7599 nd7599 nd8250 1.299232040087e+01
RINT7600 nd7600 nd8251 1.308421413557e+01
RINT7601 nd7601 nd8252 1.308421413557e+01
RINT7602 nd7602 nd8253 3.883351253541e+03
RINT7603 nd7603 nd8254 6.126511232794e+02
RINT7604 nd7604 nd8255 1.068078026015e+03
RINT7605 nd7605 nd8256 1.068078026015e+03
RINT7606 nd7606 nd8257 1.068078026015e+03
RINT7607 nd7607 nd8258 1.068078026015e+03
RINT7608 nd7608 nd8259 1.068078026015e+03
RINT7609 nd7609 nd8260 1.068078026015e+03
RINT7610 nd7610 nd8261 1.068078026015e+03
RINT7611 nd7611 nd8262 2.333909041065e+02
RINT7612 nd7612 nd8263 2.341781857809e+02
RINT7613 nd7613 nd8264 6.841105382479e+02
RINT7614 nd7614 nd8265 4.920503704179e+01
RINT7615 nd7615 nd8266 1.091441529143e+03
RINT7616 nd7616 nd8267 4.547673038094e+00
RINT7617 nd7617 nd8268 4.547673038094e+00
RINT7618 nd7618 nd8269 4.547673038094e+00
RINT7619 nd7619 nd8270 4.547673038094e+00
RINT7620 nd7620 nd8271 4.547673038094e+00
RINT7621 nd7621 nd8272 4.547673038094e+00
RINT7622 nd7622 nd8273 4.547673038094e+00
RINT7623 nd7623 nd8274 4.547673038094e+00
RINT7624 nd7624 nd8275 4.547673038094e+00
RINT7625 nd7625 nd8276 4.547673038094e+00
RINT7626 nd7626 nd8277 7.310392023728e+00
RINT7627 nd7627 nd8278 6.312559451374e+00
RINT7628 nd7628 nd8279 6.312559451374e+00
RINT7629 nd7629 nd8280 3.662460579010e+02
RINT7630 nd7630 nd8281 1.299232040087e+01
RINT7631 nd7631 nd8282 1.308421413557e+01
RINT7632 nd7632 nd8283 1.308421413557e+01
RINT7633 nd7633 nd8284 3.883351253541e+03
RINT7634 nd7634 nd8285 6.126511232794e+02
RINT7635 nd7635 nd8286 1.068078026015e+03
RINT7636 nd7636 nd8287 1.068078026015e+03
RINT7637 nd7637 nd8288 1.068078026015e+03
RINT7638 nd7638 nd8289 1.068078026015e+03
RINT7639 nd7639 nd8290 1.068078026015e+03
RINT7640 nd7640 nd8291 1.068078026015e+03
RINT7641 nd7641 nd8292 1.068078026015e+03
RINT7642 nd7642 nd8293 2.333909041065e+02
RINT7643 nd7643 nd8294 2.341781857809e+02
RINT7644 nd7644 nd8295 6.841105382479e+02
RINT7645 nd7645 nd8296 4.920503704179e+01
RINT7646 nd7646 nd8297 1.091441529143e+03
RINT7647 nd7647 nd8298 4.547673038094e+00
RINT7648 nd7648 nd8299 4.547673038094e+00
RINT7649 nd7649 nd8300 4.547673038094e+00
RINT7650 nd7650 nd8301 4.547673038094e+00
RINT7651 nd7651 nd8302 4.547673038094e+00
RINT7652 nd7652 nd8303 4.547673038094e+00
RINT7653 nd7653 nd8304 4.547673038094e+00
RINT7654 nd7654 nd8305 4.547673038094e+00
RINT7655 nd7655 nd8306 4.547673038094e+00
RINT7656 nd7656 nd8307 4.547673038094e+00
RINT7657 nd7657 nd8308 7.310392023728e+00
RINT7658 nd7658 nd8309 6.312559451374e+00
RINT7659 nd7659 nd8310 6.312559451374e+00
RINT7660 nd7660 nd8311 3.662460579010e+02
RINT7661 nd7661 nd8312 1.299232040087e+01
RINT7662 nd7662 nd8313 1.308421413557e+01
RINT7663 nd7663 nd8314 1.308421413557e+01
RINT7664 nd7664 nd8315 3.883351253541e+03
RINT7665 nd7665 nd8316 6.126511232794e+02
RINT7666 nd7666 nd8317 1.068078026015e+03
RINT7667 nd7667 nd8318 1.068078026015e+03
RINT7668 nd7668 nd8319 1.068078026015e+03
RINT7669 nd7669 nd8320 1.068078026015e+03
RINT7670 nd7670 nd8321 1.068078026015e+03
RINT7671 nd7671 nd8322 1.068078026015e+03
RINT7672 nd7672 nd8323 1.068078026015e+03
RINT7673 nd7673 nd8324 2.333909041065e+02
RINT7674 nd7674 nd8325 2.341781857809e+02
RINT7675 nd7675 nd8326 6.841105382479e+02
RINT7676 nd7676 nd8327 4.920503704179e+01
RINT7677 nd7677 nd8328 1.091441529143e+03
RINT7678 nd7678 nd8329 4.547673038094e+00
RINT7679 nd7679 nd8330 4.547673038094e+00
RINT7680 nd7680 nd8331 4.547673038094e+00
RINT7681 nd7681 nd8332 4.547673038094e+00
RINT7682 nd7682 nd8333 4.547673038094e+00
RINT7683 nd7683 nd8334 4.547673038094e+00
RINT7684 nd7684 nd8335 4.547673038094e+00
RINT7685 nd7685 nd8336 4.547673038094e+00
RINT7686 nd7686 nd8337 4.547673038094e+00
RINT7687 nd7687 nd8338 4.547673038094e+00
RINT7688 nd7688 nd8339 6.999506028131e+01
RINT7689 nd7689 nd8340 6.044107865818e+01
RINT7690 nd7690 nd8341 6.044107865818e+01
RINT7691 nd7691 nd8342 3.506708643992e+03
RINT7692 nd7692 nd8343 1.243980140465e+02
RINT7693 nd7693 nd8344 1.252778721279e+02
RINT7694 nd7694 nd8345 1.252778721279e+02
RINT7695 nd7695 nd8346 3.265707031250e+05
RINT7696 nd7696 nd8347 5.442845052083e+04
RINT7697 nd7697 nd8348 9.330591517857e+04
RINT7698 nd7698 nd8349 9.330591517857e+04
RINT7699 nd7699 nd8350 9.330591517857e+04
RINT7700 nd7700 nd8351 9.330591517857e+04
RINT7701 nd7701 nd8352 9.330591517857e+04
RINT7702 nd7702 nd8353 9.330591517857e+04
RINT7703 nd7703 nd8354 9.330591517857e+04
RINT7704 nd7704 nd8355 2.073464781746e+04
RINT7705 nd7705 nd8356 2.073464781746e+04
RINT7706 nd7706 nd8357 6.550176544339e+03
RINT7707 nd7707 nd8358 4.711251493362e+02
RINT7708 nd7708 nd8359 1.045026250000e+04
RINT7709 nd7709 nd8360 4.354276041667e+01
RINT7710 nd7710 nd8361 4.354276041667e+01
RINT7711 nd7711 nd8362 4.354276041667e+01
RINT7712 nd7712 nd8363 4.354276041667e+01
RINT7713 nd7713 nd8364 4.354276041667e+01
RINT7714 nd7714 nd8365 4.354276041667e+01
RINT7715 nd7715 nd8366 4.354276041667e+01
RINT7716 nd7716 nd8367 4.354276041667e+01
RINT7717 nd7717 nd8368 4.354276041667e+01
RINT7718 nd7718 nd8369 4.354276041667e+01
RINT7719 nd7719 nd8370 9.521626084020e+00
RINT7720 nd7720 nd8371 8.221970933165e+00
RINT7721 nd7721 nd8372 8.221970933165e+00
RINT7722 nd7722 nd8373 4.770274982191e+02
RINT7723 nd7723 nd8374 1.692221380459e+01
RINT7724 nd7724 nd8375 1.704190338874e+01
RINT7725 nd7725 nd8376 1.704190338874e+01
RINT7726 nd7726 nd8377 6.769422734972e+02
RINT7727 nd7727 nd8378 1.128237122495e+02
RINT7728 nd7728 nd8379 1.934120781421e+02
RINT7729 nd7729 nd8380 1.934120781421e+02
RINT7730 nd7730 nd8381 1.934120781421e+02
RINT7731 nd7731 nd8382 1.934120781421e+02
RINT7732 nd7732 nd8383 1.934120781421e+02
RINT7733 nd7733 nd8384 1.934120781421e+02
RINT7734 nd7734 nd8385 1.934120781421e+02
RINT7735 nd7735 nd8386 4.298046180935e+01
RINT7736 nd7736 nd8387 4.298046180935e+01
RINT7737 nd7737 nd8388 8.910390474536e+02
RINT7738 nd7738 nd8389 6.408848699791e+01
RINT7739 nd7739 nd8390 1.421578774344e+03
RINT7740 nd7740 nd8391 5.923244893101e+00
RINT7741 nd7741 nd8392 5.923244893101e+00
RINT7742 nd7742 nd8393 5.923244893101e+00
RINT7743 nd7743 nd8394 5.923244893101e+00
RINT7744 nd7744 nd8395 5.923244893101e+00
RINT7745 nd7745 nd8396 5.923244893101e+00
RINT7746 nd7746 nd8397 5.923244893101e+00
RINT7747 nd7747 nd8398 5.923244893101e+00
RINT7748 nd7748 nd8399 5.923244893101e+00
RINT7749 nd7749 nd8400 5.923244893101e+00
RINT7750 nd7750 nd8401 9.521626084020e+00
RINT7751 nd7751 nd8402 8.221970933165e+00
RINT7752 nd7752 nd8403 8.221970933165e+00
RINT7753 nd7753 nd8404 4.770274982191e+02
RINT7754 nd7754 nd8405 1.692221380459e+01
RINT7755 nd7755 nd8406 1.704190338874e+01
RINT7756 nd7756 nd8407 1.704190338874e+01
RINT7757 nd7757 nd8408 6.769422734972e+02
RINT7758 nd7758 nd8409 1.128237122495e+02
RINT7759 nd7759 nd8410 1.934120781421e+02
RINT7760 nd7760 nd8411 1.934120781421e+02
RINT7761 nd7761 nd8412 1.934120781421e+02
RINT7762 nd7762 nd8413 1.934120781421e+02
RINT7763 nd7763 nd8414 1.934120781421e+02
RINT7764 nd7764 nd8415 1.934120781421e+02
RINT7765 nd7765 nd8416 1.934120781421e+02
RINT7766 nd7766 nd8417 4.298046180935e+01
RINT7767 nd7767 nd8418 4.298046180935e+01
RINT7768 nd7768 nd8419 8.910390474536e+02
RINT7769 nd7769 nd8420 6.408848699791e+01
RINT7770 nd7770 nd8421 1.421578774344e+03
RINT7771 nd7771 nd8422 5.923244893101e+00
RINT7772 nd7772 nd8423 5.923244893101e+00
RINT7773 nd7773 nd8424 5.923244893101e+00
RINT7774 nd7774 nd8425 5.923244893101e+00
RINT7775 nd7775 nd8426 5.923244893101e+00
RINT7776 nd7776 nd8427 5.923244893101e+00
RINT7777 nd7777 nd8428 5.923244893101e+00
RINT7778 nd7778 nd8429 5.923244893101e+00
RINT7779 nd7779 nd8430 5.923244893101e+00
RINT7780 nd7780 nd8431 5.923244893101e+00
RINT7781 nd7781 nd8432 9.521626084020e+00
RINT7782 nd7782 nd8433 8.221970933165e+00
RINT7783 nd7783 nd8434 8.221970933165e+00
RINT7784 nd7784 nd8435 4.770274982191e+02
RINT7785 nd7785 nd8436 1.692221380459e+01
RINT7786 nd7786 nd8437 1.704190338874e+01
RINT7787 nd7787 nd8438 1.704190338874e+01
RINT7788 nd7788 nd8439 6.769422734972e+02
RINT7789 nd7789 nd8440 1.128237122495e+02
RINT7790 nd7790 nd8441 1.934120781421e+02
RINT7791 nd7791 nd8442 1.934120781421e+02
RINT7792 nd7792 nd8443 1.934120781421e+02
RINT7793 nd7793 nd8444 1.934120781421e+02
RINT7794 nd7794 nd8445 1.934120781421e+02
RINT7795 nd7795 nd8446 1.934120781421e+02
RINT7796 nd7796 nd8447 1.934120781421e+02
RINT7797 nd7797 nd8448 4.298046180935e+01
RINT7798 nd7798 nd8449 4.298046180935e+01
RINT7799 nd7799 nd8450 8.910390474536e+02
RINT7800 nd7800 nd8451 6.408848699791e+01
RINT7801 nd7801 nd8452 1.421578774344e+03
RINT7802 nd7802 nd8453 5.923244893101e+00
RINT7803 nd7803 nd8454 5.923244893101e+00
RINT7804 nd7804 nd8455 5.923244893101e+00
RINT7805 nd7805 nd8456 5.923244893101e+00
RINT7806 nd7806 nd8457 5.923244893101e+00
RINT7807 nd7807 nd8458 5.923244893101e+00
RINT7808 nd7808 nd8459 5.923244893101e+00
RINT7809 nd7809 nd8460 5.923244893101e+00
RINT7810 nd7810 nd8461 5.923244893101e+00
RINT7811 nd7811 nd8462 5.923244893101e+00
RINT7812 nd7812 nd8463 1.722097716126e+01
RINT7813 nd7813 nd8464 1.487039843942e+01
RINT7814 nd7814 nd8465 1.487039843942e+01
RINT7815 nd7815 nd8466 8.627601608838e+02
RINT7816 nd7816 nd8467 3.060580775545e+01
RINT7817 nd7817 nd8468 3.082228040171e+01
RINT7818 nd7818 nd8469 3.082228040171e+01
RINT7819 nd7819 nd8470 1.224329471512e+03
RINT7820 nd7820 nd8471 2.040549119187e+02
RINT7821 nd7821 nd8472 3.498084204321e+02
RINT7822 nd7822 nd8473 3.498084204321e+02
RINT7823 nd7823 nd8474 3.498084204321e+02
RINT7824 nd7824 nd8475 3.498084204321e+02
RINT7825 nd7825 nd8476 3.498084204321e+02
RINT7826 nd7826 nd8477 3.498084204321e+02
RINT7827 nd7827 nd8478 3.498084204321e+02
RINT7828 nd7828 nd8479 7.773520454047e+01
RINT7829 nd7829 nd8480 7.773520454047e+01
RINT7830 nd7830 nd8481 1.611548589557e+03
RINT7831 nd7831 nd8482 1.159115429604e+02
RINT7832 nd7832 nd8483 2.571091890176e+03
RINT7833 nd7833 nd8484 1.071288287573e+01
RINT7834 nd7834 nd8485 1.071288287573e+01
RINT7835 nd7835 nd8486 1.071288287573e+01
RINT7836 nd7836 nd8487 1.071288287573e+01
RINT7837 nd7837 nd8488 1.071288287573e+01
RINT7838 nd7838 nd8489 1.071288287573e+01
RINT7839 nd7839 nd8490 1.071288287573e+01
RINT7840 nd7840 nd8491 1.071288287573e+01
RINT7841 nd7841 nd8492 1.071288287573e+01
RINT7842 nd7842 nd8493 1.071288287573e+01
RINT7843 nd7843 nd8494 1.722097716126e+01
RINT7844 nd7844 nd8495 1.487039843942e+01
RINT7845 nd7845 nd8496 1.487039843942e+01
RINT7846 nd7846 nd8497 8.627601608838e+02
RINT7847 nd7847 nd8498 3.060580775545e+01
RINT7848 nd7848 nd8499 3.082228040171e+01
RINT7849 nd7849 nd8500 3.082228040171e+01
RINT7850 nd7850 nd8501 1.224329471512e+03
RINT7851 nd7851 nd8502 2.040549119187e+02
RINT7852 nd7852 nd8503 3.498084204321e+02
RINT7853 nd7853 nd8504 3.498084204321e+02
RINT7854 nd7854 nd8505 3.498084204321e+02
RINT7855 nd7855 nd8506 3.498084204321e+02
RINT7856 nd7856 nd8507 3.498084204321e+02
RINT7857 nd7857 nd8508 3.498084204321e+02
RINT7858 nd7858 nd8509 3.498084204321e+02
RINT7859 nd7859 nd8510 7.773520454047e+01
RINT7860 nd7860 nd8511 7.773520454047e+01
RINT7861 nd7861 nd8512 1.611548589557e+03
RINT7862 nd7862 nd8513 1.159115429604e+02
RINT7863 nd7863 nd8514 2.571091890176e+03
RINT7864 nd7864 nd8515 1.071288287573e+01
RINT7865 nd7865 nd8516 1.071288287573e+01
RINT7866 nd7866 nd8517 1.071288287573e+01
RINT7867 nd7867 nd8518 1.071288287573e+01
RINT7868 nd7868 nd8519 1.071288287573e+01
RINT7869 nd7869 nd8520 1.071288287573e+01
RINT7870 nd7870 nd8521 1.071288287573e+01
RINT7871 nd7871 nd8522 1.071288287573e+01
RINT7872 nd7872 nd8523 1.071288287573e+01
RINT7873 nd7873 nd8524 1.071288287573e+01
RINT7874 nd7874 nd8525 1.722097716126e+01
RINT7875 nd7875 nd8526 1.487039843942e+01
RINT7876 nd7876 nd8527 1.487039843942e+01
RINT7877 nd7877 nd8528 8.627601608838e+02
RINT7878 nd7878 nd8529 3.060580775545e+01
RINT7879 nd7879 nd8530 3.082228040171e+01
RINT7880 nd7880 nd8531 3.082228040171e+01
RINT7881 nd7881 nd8532 1.224329471512e+03
RINT7882 nd7882 nd8533 2.040549119187e+02
RINT7883 nd7883 nd8534 3.498084204321e+02
RINT7884 nd7884 nd8535 3.498084204321e+02
RINT7885 nd7885 nd8536 3.498084204321e+02
RINT7886 nd7886 nd8537 3.498084204321e+02
RINT7887 nd7887 nd8538 3.498084204321e+02
RINT7888 nd7888 nd8539 3.498084204321e+02
RINT7889 nd7889 nd8540 3.498084204321e+02
RINT7890 nd7890 nd8541 7.773520454047e+01
RINT7891 nd7891 nd8542 7.773520454047e+01
RINT7892 nd7892 nd8543 1.611548589557e+03
RINT7893 nd7893 nd8544 1.159115429604e+02
RINT7894 nd7894 nd8545 2.571091890176e+03
RINT7895 nd7895 nd8546 1.071288287573e+01
RINT7896 nd7896 nd8547 1.071288287573e+01
RINT7897 nd7897 nd8548 1.071288287573e+01
RINT7898 nd7898 nd8549 1.071288287573e+01
RINT7899 nd7899 nd8550 1.071288287573e+01
RINT7900 nd7900 nd8551 1.071288287573e+01
RINT7901 nd7901 nd8552 1.071288287573e+01
RINT7902 nd7902 nd8553 1.071288287573e+01
RINT7903 nd7903 nd8554 1.071288287573e+01
RINT7904 nd7904 nd8555 1.071288287573e+01
RINT7905 nd7905 nd8556 1.265942732753e+02
RINT7906 nd7906 nd8557 1.093147773279e+02
RINT7907 nd7907 nd8558 1.093147773279e+02
RINT7908 nd7908 nd8559 6.342293736017e+03
RINT7909 nd7909 nd8560 2.249883937783e+02
RINT7910 nd7910 nd8561 2.265797202797e+02
RINT7911 nd7911 nd8562 2.265797202797e+02
RINT7912 nd7912 nd8563 5.906414062500e+05
RINT7913 nd7913 nd8564 9.844023437500e+04
RINT7914 nd7914 nd8565 1.687546875000e+05
RINT7915 nd7915 nd8566 1.687546875000e+05
RINT7916 nd7916 nd8567 1.687546875000e+05
RINT7917 nd7917 nd8568 1.687546875000e+05
RINT7918 nd7918 nd8569 1.687546875000e+05
RINT7919 nd7919 nd8570 1.687546875000e+05
RINT7920 nd7920 nd8571 1.687546875000e+05
RINT7921 nd7921 nd8572 3.750104166667e+04
RINT7922 nd7922 nd8573 3.750104166667e+04
RINT7923 nd7923 nd8574 1.184676227326e+04
RINT7924 nd7924 nd8575 8.520850708924e+02
RINT7925 nd7925 nd8576 1.890052500000e+04
RINT7926 nd7926 nd8577 7.875218750000e+01
RINT7927 nd7927 nd8578 7.875218750000e+01
RINT7928 nd7928 nd8579 7.875218750000e+01
RINT7929 nd7929 nd8580 7.875218750000e+01
RINT7930 nd7930 nd8581 7.875218750000e+01
RINT7931 nd7931 nd8582 7.875218750000e+01
RINT7932 nd7932 nd8583 7.875218750000e+01
RINT7933 nd7933 nd8584 7.875218750000e+01
RINT7934 nd7934 nd8585 7.875218750000e+01
RINT7935 nd7935 nd8586 7.875218750000e+01
RINT7936 nd7936 nd8587 1.322170110122e+01
RINT7937 nd7937 nd8588 1.141700390059e+01
RINT7938 nd7938 nd8589 1.141700390059e+01
RINT7939 nd7939 nd8590 6.623989372047e+02
RINT7940 nd7940 nd8591 2.349813476405e+01
RINT7941 nd7941 nd8592 2.366433535758e+01
RINT7942 nd7942 nd8593 2.366433535758e+01
RINT7943 nd7943 nd8594 1.239106136042e+03
RINT7944 nd7944 nd8595 1.373695180523e+02
RINT7945 nd7945 nd8596 2.711285174478e+02
RINT7946 nd7946 nd8597 2.711285174478e+02
RINT7947 nd7947 nd8598 2.711285174478e+02
RINT7948 nd7948 nd8599 2.711285174478e+02
RINT7949 nd7949 nd8600 2.711285174478e+02
RINT7950 nd7950 nd8601 2.711285174478e+02
RINT7951 nd7951 nd8602 2.711285174478e+02
RINT7952 nd7952 nd8603 5.233124497231e+01
RINT7953 nd7953 nd8604 5.390580832121e+01
RINT7954 nd7954 nd8605 1.237294118776e+03
RINT7955 nd7955 nd8606 8.899307866519e+01
RINT7956 nd7956 nd8607 1.973999974412e+03
RINT7957 nd7957 nd8608 8.224999893383e+00
RINT7958 nd7958 nd8609 8.224999893383e+00
RINT7959 nd7959 nd8610 8.224999893383e+00
RINT7960 nd7960 nd8611 8.224999893383e+00
RINT7961 nd7961 nd8612 8.224999893383e+00
RINT7962 nd7962 nd8613 8.224999893383e+00
RINT7963 nd7963 nd8614 8.224999893383e+00
RINT7964 nd7964 nd8615 8.224999893383e+00
RINT7965 nd7965 nd8616 8.224999893383e+00
RINT7966 nd7966 nd8617 8.224999893383e+00
RINT7967 nd7967 nd8618 1.322170110122e+01
RINT7968 nd7968 nd8619 1.141700390059e+01
RINT7969 nd7969 nd8620 1.141700390059e+01
RINT7970 nd7970 nd8621 6.623989372047e+02
RINT7971 nd7971 nd8622 2.349813476405e+01
RINT7972 nd7972 nd8623 2.366433535758e+01
RINT7973 nd7973 nd8624 2.366433535758e+01
RINT7974 nd7974 nd8625 1.239106136042e+03
RINT7975 nd7975 nd8626 1.373695180523e+02
RINT7976 nd7976 nd8627 2.711285174478e+02
RINT7977 nd7977 nd8628 2.711285174478e+02
RINT7978 nd7978 nd8629 2.711285174478e+02
RINT7979 nd7979 nd8630 2.711285174478e+02
RINT7980 nd7980 nd8631 2.711285174478e+02
RINT7981 nd7981 nd8632 2.711285174478e+02
RINT7982 nd7982 nd8633 2.711285174478e+02
RINT7983 nd7983 nd8634 5.233124497231e+01
RINT7984 nd7984 nd8635 5.390580832121e+01
RINT7985 nd7985 nd8636 1.237294118776e+03
RINT7986 nd7986 nd8637 8.899307866519e+01
RINT7987 nd7987 nd8638 1.973999974412e+03
RINT7988 nd7988 nd8639 8.224999893383e+00
RINT7989 nd7989 nd8640 8.224999893383e+00
RINT7990 nd7990 nd8641 8.224999893383e+00
RINT7991 nd7991 nd8642 8.224999893383e+00
RINT7992 nd7992 nd8643 8.224999893383e+00
RINT7993 nd7993 nd8644 8.224999893383e+00
RINT7994 nd7994 nd8645 8.224999893383e+00
RINT7995 nd7995 nd8646 8.224999893383e+00
RINT7996 nd7996 nd8647 8.224999893383e+00
RINT7997 nd7997 nd8648 8.224999893383e+00
RINT7998 nd7998 nd8649 1.322170110122e+01
RINT7999 nd7999 nd8650 1.141700390059e+01
RINT8000 nd8000 nd8651 1.141700390059e+01
RINT8001 nd8001 nd8652 6.623989372047e+02
RINT8002 nd8002 nd8653 2.349813476405e+01
RINT8003 nd8003 nd8654 2.366433535758e+01
RINT8004 nd8004 nd8655 2.366433535758e+01
RINT8005 nd8005 nd8656 1.239106136042e+03
RINT8006 nd8006 nd8657 1.373695180523e+02
RINT8007 nd8007 nd8658 2.711285174478e+02
RINT8008 nd8008 nd8659 2.711285174478e+02
RINT8009 nd8009 nd8660 2.711285174478e+02
RINT8010 nd8010 nd8661 2.711285174478e+02
RINT8011 nd8011 nd8662 2.711285174478e+02
RINT8012 nd8012 nd8663 2.711285174478e+02
RINT8013 nd8013 nd8664 2.711285174478e+02
RINT8014 nd8014 nd8665 5.233124497231e+01
RINT8015 nd8015 nd8666 5.390580832121e+01
RINT8016 nd8016 nd8667 1.237294118776e+03
RINT8017 nd8017 nd8668 8.899307866519e+01
RINT8018 nd8018 nd8669 1.973999974412e+03
RINT8019 nd8019 nd8670 8.224999893383e+00
RINT8020 nd8020 nd8671 8.224999893383e+00
RINT8021 nd8021 nd8672 8.224999893383e+00
RINT8022 nd8022 nd8673 8.224999893383e+00
RINT8023 nd8023 nd8674 8.224999893383e+00
RINT8024 nd8024 nd8675 8.224999893383e+00
RINT8025 nd8025 nd8676 8.224999893383e+00
RINT8026 nd8026 nd8677 8.224999893383e+00
RINT8027 nd8027 nd8678 8.224999893383e+00
RINT8028 nd8028 nd8679 8.224999893383e+00
RINT8029 nd8029 nd8680 1.322170110122e+01
RINT8030 nd8030 nd8681 1.141700390059e+01
RINT8031 nd8031 nd8682 1.141700390059e+01
RINT8032 nd8032 nd8683 6.623989372047e+02
RINT8033 nd8033 nd8684 2.349813476405e+01
RINT8034 nd8034 nd8685 2.366433535758e+01
RINT8035 nd8035 nd8686 2.366433535758e+01
RINT8036 nd8036 nd8687 1.239106136042e+03
RINT8037 nd8037 nd8688 1.373695180523e+02
RINT8038 nd8038 nd8689 2.711285174478e+02
RINT8039 nd8039 nd8690 2.711285174478e+02
RINT8040 nd8040 nd8691 2.711285174478e+02
RINT8041 nd8041 nd8692 2.711285174478e+02
RINT8042 nd8042 nd8693 2.711285174478e+02
RINT8043 nd8043 nd8694 2.711285174478e+02
RINT8044 nd8044 nd8695 2.711285174478e+02
RINT8045 nd8045 nd8696 5.233124497231e+01
RINT8046 nd8046 nd8697 5.390580832121e+01
RINT8047 nd8047 nd8698 1.237294118776e+03
RINT8048 nd8048 nd8699 8.899307866519e+01
RINT8049 nd8049 nd8700 1.973999974412e+03
RINT8050 nd8050 nd8701 8.224999893383e+00
RINT8051 nd8051 nd8702 8.224999893383e+00
RINT8052 nd8052 nd8703 8.224999893383e+00
RINT8053 nd8053 nd8704 8.224999893383e+00
RINT8054 nd8054 nd8705 8.224999893383e+00
RINT8055 nd8055 nd8706 8.224999893383e+00
RINT8056 nd8056 nd8707 8.224999893383e+00
RINT8057 nd8057 nd8708 8.224999893383e+00
RINT8058 nd8058 nd8709 8.224999893383e+00
RINT8059 nd8059 nd8710 8.224999893383e+00
RINT8060 nd8060 nd8711 1.322170110122e+01
RINT8061 nd8061 nd8712 1.141700390059e+01
RINT8062 nd8062 nd8713 1.141700390059e+01
RINT8063 nd8063 nd8714 6.623989372047e+02
RINT8064 nd8064 nd8715 2.349813476405e+01
RINT8065 nd8065 nd8716 2.366433535758e+01
RINT8066 nd8066 nd8717 2.366433535758e+01
RINT8067 nd8067 nd8718 1.239106136042e+03
RINT8068 nd8068 nd8719 1.373695180523e+02
RINT8069 nd8069 nd8720 2.711285174478e+02
RINT8070 nd8070 nd8721 2.711285174478e+02
RINT8071 nd8071 nd8722 2.711285174478e+02
RINT8072 nd8072 nd8723 2.711285174478e+02
RINT8073 nd8073 nd8724 2.711285174478e+02
RINT8074 nd8074 nd8725 2.711285174478e+02
RINT8075 nd8075 nd8726 2.711285174478e+02
RINT8076 nd8076 nd8727 5.233124497231e+01
RINT8077 nd8077 nd8728 5.390580832121e+01
RINT8078 nd8078 nd8729 1.237294118776e+03
RINT8079 nd8079 nd8730 8.899307866519e+01
RINT8080 nd8080 nd8731 1.973999974412e+03
RINT8081 nd8081 nd8732 8.224999893383e+00
RINT8082 nd8082 nd8733 8.224999893383e+00
RINT8083 nd8083 nd8734 8.224999893383e+00
RINT8084 nd8084 nd8735 8.224999893383e+00
RINT8085 nd8085 nd8736 8.224999893383e+00
RINT8086 nd8086 nd8737 8.224999893383e+00
RINT8087 nd8087 nd8738 8.224999893383e+00
RINT8088 nd8088 nd8739 8.224999893383e+00
RINT8089 nd8089 nd8740 8.224999893383e+00
RINT8090 nd8090 nd8741 8.224999893383e+00
RINT8091 nd8091 nd8742 1.322170110122e+01
RINT8092 nd8092 nd8743 1.141700390059e+01
RINT8093 nd8093 nd8744 1.141700390059e+01
RINT8094 nd8094 nd8745 6.623989372047e+02
RINT8095 nd8095 nd8746 2.349813476405e+01
RINT8096 nd8096 nd8747 2.366433535758e+01
RINT8097 nd8097 nd8748 2.366433535758e+01
RINT8098 nd8098 nd8749 1.239106136042e+03
RINT8099 nd8099 nd8750 1.373695180523e+02
RINT8100 nd8100 nd8751 2.711285174478e+02
RINT8101 nd8101 nd8752 2.711285174478e+02
RINT8102 nd8102 nd8753 2.711285174478e+02
RINT8103 nd8103 nd8754 2.711285174478e+02
RINT8104 nd8104 nd8755 2.711285174478e+02
RINT8105 nd8105 nd8756 2.711285174478e+02
RINT8106 nd8106 nd8757 2.711285174478e+02
RINT8107 nd8107 nd8758 5.233124497231e+01
RINT8108 nd8108 nd8759 5.390580832121e+01
RINT8109 nd8109 nd8760 1.237294118776e+03
RINT8110 nd8110 nd8761 8.899307866519e+01
RINT8111 nd8111 nd8762 1.973999974412e+03
RINT8112 nd8112 nd8763 8.224999893383e+00
RINT8113 nd8113 nd8764 8.224999893383e+00
RINT8114 nd8114 nd8765 8.224999893383e+00
RINT8115 nd8115 nd8766 8.224999893383e+00
RINT8116 nd8116 nd8767 8.224999893383e+00
RINT8117 nd8117 nd8768 8.224999893383e+00
RINT8118 nd8118 nd8769 8.224999893383e+00
RINT8119 nd8119 nd8770 8.224999893383e+00
RINT8120 nd8120 nd8771 8.224999893383e+00
RINT8121 nd8121 nd8772 8.224999893383e+00
RINT8122 nd8122 nd8773 1.265942732753e+02
RINT8123 nd8123 nd8774 1.093147773279e+02
RINT8124 nd8124 nd8775 1.093147773279e+02
RINT8125 nd8125 nd8776 6.342293736017e+03
RINT8126 nd8126 nd8777 2.249883937783e+02
RINT8127 nd8127 nd8778 2.265797202797e+02
RINT8128 nd8128 nd8779 2.265797202797e+02
RINT8129 nd8129 nd8780 5.906414062500e+05
RINT8130 nd8130 nd8781 9.844023437500e+04
RINT8131 nd8131 nd8782 1.687546875000e+05
RINT8132 nd8132 nd8783 1.687546875000e+05
RINT8133 nd8133 nd8784 1.687546875000e+05
RINT8134 nd8134 nd8785 1.687546875000e+05
RINT8135 nd8135 nd8786 1.687546875000e+05
RINT8136 nd8136 nd8787 1.687546875000e+05
RINT8137 nd8137 nd8788 1.687546875000e+05
RINT8138 nd8138 nd8789 3.750104166667e+04
RINT8139 nd8139 nd8790 3.750104166667e+04
RINT8140 nd8140 nd8791 1.184676227326e+04
RINT8141 nd8141 nd8792 8.520850708924e+02
RINT8142 nd8142 nd8793 1.890052500000e+04
RINT8143 nd8143 nd8794 7.875218750000e+01
RINT8144 nd8144 nd8795 7.875218750000e+01
RINT8145 nd8145 nd8796 7.875218750000e+01
RINT8146 nd8146 nd8797 7.875218750000e+01
RINT8147 nd8147 nd8798 7.875218750000e+01
RINT8148 nd8148 nd8799 7.875218750000e+01
RINT8149 nd8149 nd8800 7.875218750000e+01
RINT8150 nd8150 nd8801 7.875218750000e+01
RINT8151 nd8151 nd8802 7.875218750000e+01
RINT8152 nd8152 nd8803 7.875218750000e+01
RINT8153 nd8153 nd8804 1.322170110122e+01
RINT8154 nd8154 nd8805 1.141700390059e+01
RINT8155 nd8155 nd8806 1.141700390059e+01
RINT8156 nd8156 nd8807 6.623989372047e+02
RINT8157 nd8157 nd8808 2.349813476405e+01
RINT8158 nd8158 nd8809 2.366433535758e+01
RINT8159 nd8159 nd8810 2.366433535758e+01
RINT8160 nd8160 nd8811 1.239106136042e+03
RINT8161 nd8161 nd8812 1.373695180523e+02
RINT8162 nd8162 nd8813 2.711285174478e+02
RINT8163 nd8163 nd8814 2.711285174478e+02
RINT8164 nd8164 nd8815 2.711285174478e+02
RINT8165 nd8165 nd8816 2.711285174478e+02
RINT8166 nd8166 nd8817 2.711285174478e+02
RINT8167 nd8167 nd8818 2.711285174478e+02
RINT8168 nd8168 nd8819 2.711285174478e+02
RINT8169 nd8169 nd8820 5.233124497231e+01
RINT8170 nd8170 nd8821 5.390580832121e+01
RINT8171 nd8171 nd8822 1.237294118776e+03
RINT8172 nd8172 nd8823 8.899307866519e+01
RINT8173 nd8173 nd8824 1.973999974412e+03
RINT8174 nd8174 nd8825 8.224999893383e+00
RINT8175 nd8175 nd8826 8.224999893383e+00
RINT8176 nd8176 nd8827 8.224999893383e+00
RINT8177 nd8177 nd8828 8.224999893383e+00
RINT8178 nd8178 nd8829 8.224999893383e+00
RINT8179 nd8179 nd8830 8.224999893383e+00
RINT8180 nd8180 nd8831 8.224999893383e+00
RINT8181 nd8181 nd8832 8.224999893383e+00
RINT8182 nd8182 nd8833 8.224999893383e+00
RINT8183 nd8183 nd8834 8.224999893383e+00
RINT8184 nd8184 nd8835 1.322170110122e+01
RINT8185 nd8185 nd8836 1.141700390059e+01
RINT8186 nd8186 nd8837 1.141700390059e+01
RINT8187 nd8187 nd8838 6.623989372047e+02
RINT8188 nd8188 nd8839 2.349813476405e+01
RINT8189 nd8189 nd8840 2.366433535758e+01
RINT8190 nd8190 nd8841 2.366433535758e+01
RINT8191 nd8191 nd8842 1.239106136042e+03
RINT8192 nd8192 nd8843 1.373695180523e+02
RINT8193 nd8193 nd8844 2.711285174478e+02
RINT8194 nd8194 nd8845 2.711285174478e+02
RINT8195 nd8195 nd8846 2.711285174478e+02
RINT8196 nd8196 nd8847 2.711285174478e+02
RINT8197 nd8197 nd8848 2.711285174478e+02
RINT8198 nd8198 nd8849 2.711285174478e+02
RINT8199 nd8199 nd8850 2.711285174478e+02
RINT8200 nd8200 nd8851 5.233124497231e+01
RINT8201 nd8201 nd8852 5.390580832121e+01
RINT8202 nd8202 nd8853 1.237294118776e+03
RINT8203 nd8203 nd8854 8.899307866519e+01
RINT8204 nd8204 nd8855 1.973999974412e+03
RINT8205 nd8205 nd8856 8.224999893383e+00
RINT8206 nd8206 nd8857 8.224999893383e+00
RINT8207 nd8207 nd8858 8.224999893383e+00
RINT8208 nd8208 nd8859 8.224999893383e+00
RINT8209 nd8209 nd8860 8.224999893383e+00
RINT8210 nd8210 nd8861 8.224999893383e+00
RINT8211 nd8211 nd8862 8.224999893383e+00
RINT8212 nd8212 nd8863 8.224999893383e+00
RINT8213 nd8213 nd8864 8.224999893383e+00
RINT8214 nd8214 nd8865 8.224999893383e+00
RINT8215 nd8215 nd8866 1.322170110122e+01
RINT8216 nd8216 nd8867 1.141700390059e+01
RINT8217 nd8217 nd8868 1.141700390059e+01
RINT8218 nd8218 nd8869 6.623989372047e+02
RINT8219 nd8219 nd8870 2.349813476405e+01
RINT8220 nd8220 nd8871 2.366433535758e+01
RINT8221 nd8221 nd8872 2.366433535758e+01
RINT8222 nd8222 nd8873 1.239106136042e+03
RINT8223 nd8223 nd8874 1.373695180523e+02
RINT8224 nd8224 nd8875 2.711285174478e+02
RINT8225 nd8225 nd8876 2.711285174478e+02
RINT8226 nd8226 nd8877 2.711285174478e+02
RINT8227 nd8227 nd8878 2.711285174478e+02
RINT8228 nd8228 nd8879 2.711285174478e+02
RINT8229 nd8229 nd8880 2.711285174478e+02
RINT8230 nd8230 nd8881 2.711285174478e+02
RINT8231 nd8231 nd8882 5.233124497231e+01
RINT8232 nd8232 nd8883 5.390580832121e+01
RINT8233 nd8233 nd8884 1.237294118776e+03
RINT8234 nd8234 nd8885 8.899307866519e+01
RINT8235 nd8235 nd8886 1.973999974412e+03
RINT8236 nd8236 nd8887 8.224999893383e+00
RINT8237 nd8237 nd8888 8.224999893383e+00
RINT8238 nd8238 nd8889 8.224999893383e+00
RINT8239 nd8239 nd8890 8.224999893383e+00
RINT8240 nd8240 nd8891 8.224999893383e+00
RINT8241 nd8241 nd8892 8.224999893383e+00
RINT8242 nd8242 nd8893 8.224999893383e+00
RINT8243 nd8243 nd8894 8.224999893383e+00
RINT8244 nd8244 nd8895 8.224999893383e+00
RINT8245 nd8245 nd8896 8.224999893383e+00
RINT8246 nd8246 nd8897 1.322170110122e+01
RINT8247 nd8247 nd8898 1.141700390059e+01
RINT8248 nd8248 nd8899 1.141700390059e+01
RINT8249 nd8249 nd8900 6.623989372047e+02
RINT8250 nd8250 nd8901 2.349813476405e+01
RINT8251 nd8251 nd8902 2.366433535758e+01
RINT8252 nd8252 nd8903 2.366433535758e+01
RINT8253 nd8253 nd8904 1.239106136042e+03
RINT8254 nd8254 nd8905 1.373695180523e+02
RINT8255 nd8255 nd8906 2.711285174478e+02
RINT8256 nd8256 nd8907 2.711285174478e+02
RINT8257 nd8257 nd8908 2.711285174478e+02
RINT8258 nd8258 nd8909 2.711285174478e+02
RINT8259 nd8259 nd8910 2.711285174478e+02
RINT8260 nd8260 nd8911 2.711285174478e+02
RINT8261 nd8261 nd8912 2.711285174478e+02
RINT8262 nd8262 nd8913 5.233124497231e+01
RINT8263 nd8263 nd8914 5.390580832121e+01
RINT8264 nd8264 nd8915 1.237294118776e+03
RINT8265 nd8265 nd8916 8.899307866519e+01
RINT8266 nd8266 nd8917 1.973999974412e+03
RINT8267 nd8267 nd8918 8.224999893383e+00
RINT8268 nd8268 nd8919 8.224999893383e+00
RINT8269 nd8269 nd8920 8.224999893383e+00
RINT8270 nd8270 nd8921 8.224999893383e+00
RINT8271 nd8271 nd8922 8.224999893383e+00
RINT8272 nd8272 nd8923 8.224999893383e+00
RINT8273 nd8273 nd8924 8.224999893383e+00
RINT8274 nd8274 nd8925 8.224999893383e+00
RINT8275 nd8275 nd8926 8.224999893383e+00
RINT8276 nd8276 nd8927 8.224999893383e+00
RINT8277 nd8277 nd8928 1.322170110122e+01
RINT8278 nd8278 nd8929 1.141700390059e+01
RINT8279 nd8279 nd8930 1.141700390059e+01
RINT8280 nd8280 nd8931 6.623989372047e+02
RINT8281 nd8281 nd8932 2.349813476405e+01
RINT8282 nd8282 nd8933 2.366433535758e+01
RINT8283 nd8283 nd8934 2.366433535758e+01
RINT8284 nd8284 nd8935 1.239106136042e+03
RINT8285 nd8285 nd8936 1.373695180523e+02
RINT8286 nd8286 nd8937 2.711285174478e+02
RINT8287 nd8287 nd8938 2.711285174478e+02
RINT8288 nd8288 nd8939 2.711285174478e+02
RINT8289 nd8289 nd8940 2.711285174478e+02
RINT8290 nd8290 nd8941 2.711285174478e+02
RINT8291 nd8291 nd8942 2.711285174478e+02
RINT8292 nd8292 nd8943 2.711285174478e+02
RINT8293 nd8293 nd8944 5.233124497231e+01
RINT8294 nd8294 nd8945 5.390580832121e+01
RINT8295 nd8295 nd8946 1.237294118776e+03
RINT8296 nd8296 nd8947 8.899307866519e+01
RINT8297 nd8297 nd8948 1.973999974412e+03
RINT8298 nd8298 nd8949 8.224999893383e+00
RINT8299 nd8299 nd8950 8.224999893383e+00
RINT8300 nd8300 nd8951 8.224999893383e+00
RINT8301 nd8301 nd8952 8.224999893383e+00
RINT8302 nd8302 nd8953 8.224999893383e+00
RINT8303 nd8303 nd8954 8.224999893383e+00
RINT8304 nd8304 nd8955 8.224999893383e+00
RINT8305 nd8305 nd8956 8.224999893383e+00
RINT8306 nd8306 nd8957 8.224999893383e+00
RINT8307 nd8307 nd8958 8.224999893383e+00
RINT8308 nd8308 nd8959 1.322170110122e+01
RINT8309 nd8309 nd8960 1.141700390059e+01
RINT8310 nd8310 nd8961 1.141700390059e+01
RINT8311 nd8311 nd8962 6.623989372047e+02
RINT8312 nd8312 nd8963 2.349813476405e+01
RINT8313 nd8313 nd8964 2.366433535758e+01
RINT8314 nd8314 nd8965 2.366433535758e+01
RINT8315 nd8315 nd8966 1.239106136042e+03
RINT8316 nd8316 nd8967 1.373695180523e+02
RINT8317 nd8317 nd8968 2.711285174478e+02
RINT8318 nd8318 nd8969 2.711285174478e+02
RINT8319 nd8319 nd8970 2.711285174478e+02
RINT8320 nd8320 nd8971 2.711285174478e+02
RINT8321 nd8321 nd8972 2.711285174478e+02
RINT8322 nd8322 nd8973 2.711285174478e+02
RINT8323 nd8323 nd8974 2.711285174478e+02
RINT8324 nd8324 nd8975 5.233124497231e+01
RINT8325 nd8325 nd8976 5.390580832121e+01
RINT8326 nd8326 nd8977 1.237294118776e+03
RINT8327 nd8327 nd8978 8.899307866519e+01
RINT8328 nd8328 nd8979 1.973999974412e+03
RINT8329 nd8329 nd8980 8.224999893383e+00
RINT8330 nd8330 nd8981 8.224999893383e+00
RINT8331 nd8331 nd8982 8.224999893383e+00
RINT8332 nd8332 nd8983 8.224999893383e+00
RINT8333 nd8333 nd8984 8.224999893383e+00
RINT8334 nd8334 nd8985 8.224999893383e+00
RINT8335 nd8335 nd8986 8.224999893383e+00
RINT8336 nd8336 nd8987 8.224999893383e+00
RINT8337 nd8337 nd8988 8.224999893383e+00
RINT8338 nd8338 nd8989 8.224999893383e+00
RINT8339 nd8339 nd8990 1.265942732753e+02
RINT8340 nd8340 nd8991 1.093147773279e+02
RINT8341 nd8341 nd8992 1.093147773279e+02
RINT8342 nd8342 nd8993 6.342293736017e+03
RINT8343 nd8343 nd8994 2.249883937783e+02
RINT8344 nd8344 nd8995 2.265797202797e+02
RINT8345 nd8345 nd8996 2.265797202797e+02
RINT8346 nd8346 nd8997 5.906414062500e+05
RINT8347 nd8347 nd8998 9.844023437500e+04
RINT8348 nd8348 nd8999 1.687546875000e+05
RINT8349 nd8349 nd9000 1.687546875000e+05
RINT8350 nd8350 nd9001 1.687546875000e+05
RINT8351 nd8351 nd9002 1.687546875000e+05
RINT8352 nd8352 nd9003 1.687546875000e+05
RINT8353 nd8353 nd9004 1.687546875000e+05
RINT8354 nd8354 nd9005 1.687546875000e+05
RINT8355 nd8355 nd9006 3.750104166667e+04
RINT8356 nd8356 nd9007 3.750104166667e+04
RINT8357 nd8357 nd9008 1.184676227326e+04
RINT8358 nd8358 nd9009 8.520850708924e+02
RINT8359 nd8359 nd9010 1.890052500000e+04
RINT8360 nd8360 nd9011 7.875218750000e+01
RINT8361 nd8361 nd9012 7.875218750000e+01
RINT8362 nd8362 nd9013 7.875218750000e+01
RINT8363 nd8363 nd9014 7.875218750000e+01
RINT8364 nd8364 nd9015 7.875218750000e+01
RINT8365 nd8365 nd9016 7.875218750000e+01
RINT8366 nd8366 nd9017 7.875218750000e+01
RINT8367 nd8367 nd9018 7.875218750000e+01
RINT8368 nd8368 nd9019 7.875218750000e+01
RINT8369 nd8369 nd9020 7.875218750000e+01
RINT8370 nd8370 nd9021 1.722097716126e+01
RINT8371 nd8371 nd9022 1.487039843942e+01
RINT8372 nd8372 nd9023 1.487039843942e+01
RINT8373 nd8373 nd9024 8.627601608838e+02
RINT8374 nd8374 nd9025 3.060580775545e+01
RINT8375 nd8375 nd9026 3.082228040171e+01
RINT8376 nd8376 nd9027 3.082228040171e+01
RINT8377 nd8377 nd9028 1.224329471512e+03
RINT8378 nd8378 nd9029 2.040549119187e+02
RINT8379 nd8379 nd9030 3.498084204321e+02
RINT8380 nd8380 nd9031 3.498084204321e+02
RINT8381 nd8381 nd9032 3.498084204321e+02
RINT8382 nd8382 nd9033 3.498084204321e+02
RINT8383 nd8383 nd9034 3.498084204321e+02
RINT8384 nd8384 nd9035 3.498084204321e+02
RINT8385 nd8385 nd9036 3.498084204321e+02
RINT8386 nd8386 nd9037 7.773520454047e+01
RINT8387 nd8387 nd9038 7.773520454047e+01
RINT8388 nd8388 nd9039 1.611548589557e+03
RINT8389 nd8389 nd9040 1.159115429604e+02
RINT8390 nd8390 nd9041 2.571091890176e+03
RINT8391 nd8391 nd9042 1.071288287573e+01
RINT8392 nd8392 nd9043 1.071288287573e+01
RINT8393 nd8393 nd9044 1.071288287573e+01
RINT8394 nd8394 nd9045 1.071288287573e+01
RINT8395 nd8395 nd9046 1.071288287573e+01
RINT8396 nd8396 nd9047 1.071288287573e+01
RINT8397 nd8397 nd9048 1.071288287573e+01
RINT8398 nd8398 nd9049 1.071288287573e+01
RINT8399 nd8399 nd9050 1.071288287573e+01
RINT8400 nd8400 nd9051 1.071288287573e+01
RINT8401 nd8401 nd9052 1.722097716126e+01
RINT8402 nd8402 nd9053 1.487039843942e+01
RINT8403 nd8403 nd9054 1.487039843942e+01
RINT8404 nd8404 nd9055 8.627601608838e+02
RINT8405 nd8405 nd9056 3.060580775545e+01
RINT8406 nd8406 nd9057 3.082228040171e+01
RINT8407 nd8407 nd9058 3.082228040171e+01
RINT8408 nd8408 nd9059 1.224329471512e+03
RINT8409 nd8409 nd9060 2.040549119187e+02
RINT8410 nd8410 nd9061 3.498084204321e+02
RINT8411 nd8411 nd9062 3.498084204321e+02
RINT8412 nd8412 nd9063 3.498084204321e+02
RINT8413 nd8413 nd9064 3.498084204321e+02
RINT8414 nd8414 nd9065 3.498084204321e+02
RINT8415 nd8415 nd9066 3.498084204321e+02
RINT8416 nd8416 nd9067 3.498084204321e+02
RINT8417 nd8417 nd9068 7.773520454047e+01
RINT8418 nd8418 nd9069 7.773520454047e+01
RINT8419 nd8419 nd9070 1.611548589557e+03
RINT8420 nd8420 nd9071 1.159115429604e+02
RINT8421 nd8421 nd9072 2.571091890176e+03
RINT8422 nd8422 nd9073 1.071288287573e+01
RINT8423 nd8423 nd9074 1.071288287573e+01
RINT8424 nd8424 nd9075 1.071288287573e+01
RINT8425 nd8425 nd9076 1.071288287573e+01
RINT8426 nd8426 nd9077 1.071288287573e+01
RINT8427 nd8427 nd9078 1.071288287573e+01
RINT8428 nd8428 nd9079 1.071288287573e+01
RINT8429 nd8429 nd9080 1.071288287573e+01
RINT8430 nd8430 nd9081 1.071288287573e+01
RINT8431 nd8431 nd9082 1.071288287573e+01
RINT8432 nd8432 nd9083 1.722097716126e+01
RINT8433 nd8433 nd9084 1.487039843942e+01
RINT8434 nd8434 nd9085 1.487039843942e+01
RINT8435 nd8435 nd9086 8.627601608838e+02
RINT8436 nd8436 nd9087 3.060580775545e+01
RINT8437 nd8437 nd9088 3.082228040171e+01
RINT8438 nd8438 nd9089 3.082228040171e+01
RINT8439 nd8439 nd9090 1.224329471512e+03
RINT8440 nd8440 nd9091 2.040549119187e+02
RINT8441 nd8441 nd9092 3.498084204321e+02
RINT8442 nd8442 nd9093 3.498084204321e+02
RINT8443 nd8443 nd9094 3.498084204321e+02
RINT8444 nd8444 nd9095 3.498084204321e+02
RINT8445 nd8445 nd9096 3.498084204321e+02
RINT8446 nd8446 nd9097 3.498084204321e+02
RINT8447 nd8447 nd9098 3.498084204321e+02
RINT8448 nd8448 nd9099 7.773520454047e+01
RINT8449 nd8449 nd9100 7.773520454047e+01
RINT8450 nd8450 nd9101 1.611548589557e+03
RINT8451 nd8451 nd9102 1.159115429604e+02
RINT8452 nd8452 nd9103 2.571091890176e+03
RINT8453 nd8453 nd9104 1.071288287573e+01
RINT8454 nd8454 nd9105 1.071288287573e+01
RINT8455 nd8455 nd9106 1.071288287573e+01
RINT8456 nd8456 nd9107 1.071288287573e+01
RINT8457 nd8457 nd9108 1.071288287573e+01
RINT8458 nd8458 nd9109 1.071288287573e+01
RINT8459 nd8459 nd9110 1.071288287573e+01
RINT8460 nd8460 nd9111 1.071288287573e+01
RINT8461 nd8461 nd9112 1.071288287573e+01
RINT8462 nd8462 nd9113 1.071288287573e+01
RINT8463 nd8463 nd9114 1.722097716126e+01
RINT8464 nd8464 nd9115 1.487039843942e+01
RINT8465 nd8465 nd9116 1.487039843942e+01
RINT8466 nd8466 nd9117 8.627601608838e+02
RINT8467 nd8467 nd9118 3.060580775545e+01
RINT8468 nd8468 nd9119 3.082228040171e+01
RINT8469 nd8469 nd9120 3.082228040171e+01
RINT8470 nd8470 nd9121 1.224329471512e+03
RINT8471 nd8471 nd9122 2.040549119187e+02
RINT8472 nd8472 nd9123 3.498084204321e+02
RINT8473 nd8473 nd9124 3.498084204321e+02
RINT8474 nd8474 nd9125 3.498084204321e+02
RINT8475 nd8475 nd9126 3.498084204321e+02
RINT8476 nd8476 nd9127 3.498084204321e+02
RINT8477 nd8477 nd9128 3.498084204321e+02
RINT8478 nd8478 nd9129 3.498084204321e+02
RINT8479 nd8479 nd9130 7.773520454047e+01
RINT8480 nd8480 nd9131 7.773520454047e+01
RINT8481 nd8481 nd9132 1.611548589557e+03
RINT8482 nd8482 nd9133 1.159115429604e+02
RINT8483 nd8483 nd9134 2.571091890176e+03
RINT8484 nd8484 nd9135 1.071288287573e+01
RINT8485 nd8485 nd9136 1.071288287573e+01
RINT8486 nd8486 nd9137 1.071288287573e+01
RINT8487 nd8487 nd9138 1.071288287573e+01
RINT8488 nd8488 nd9139 1.071288287573e+01
RINT8489 nd8489 nd9140 1.071288287573e+01
RINT8490 nd8490 nd9141 1.071288287573e+01
RINT8491 nd8491 nd9142 1.071288287573e+01
RINT8492 nd8492 nd9143 1.071288287573e+01
RINT8493 nd8493 nd9144 1.071288287573e+01
RINT8494 nd8494 nd9145 1.722097716126e+01
RINT8495 nd8495 nd9146 1.487039843942e+01
RINT8496 nd8496 nd9147 1.487039843942e+01
RINT8497 nd8497 nd9148 8.627601608838e+02
RINT8498 nd8498 nd9149 3.060580775545e+01
RINT8499 nd8499 nd9150 3.082228040171e+01
RINT8500 nd8500 nd9151 3.082228040171e+01
RINT8501 nd8501 nd9152 1.224329471512e+03
RINT8502 nd8502 nd9153 2.040549119187e+02
RINT8503 nd8503 nd9154 3.498084204321e+02
RINT8504 nd8504 nd9155 3.498084204321e+02
RINT8505 nd8505 nd9156 3.498084204321e+02
RINT8506 nd8506 nd9157 3.498084204321e+02
RINT8507 nd8507 nd9158 3.498084204321e+02
RINT8508 nd8508 nd9159 3.498084204321e+02
RINT8509 nd8509 nd9160 3.498084204321e+02
RINT8510 nd8510 nd9161 7.773520454047e+01
RINT8511 nd8511 nd9162 7.773520454047e+01
RINT8512 nd8512 nd9163 1.611548589557e+03
RINT8513 nd8513 nd9164 1.159115429604e+02
RINT8514 nd8514 nd9165 2.571091890176e+03
RINT8515 nd8515 nd9166 1.071288287573e+01
RINT8516 nd8516 nd9167 1.071288287573e+01
RINT8517 nd8517 nd9168 1.071288287573e+01
RINT8518 nd8518 nd9169 1.071288287573e+01
RINT8519 nd8519 nd9170 1.071288287573e+01
RINT8520 nd8520 nd9171 1.071288287573e+01
RINT8521 nd8521 nd9172 1.071288287573e+01
RINT8522 nd8522 nd9173 1.071288287573e+01
RINT8523 nd8523 nd9174 1.071288287573e+01
RINT8524 nd8524 nd9175 1.071288287573e+01
RINT8525 nd8525 nd9176 1.722097716126e+01
RINT8526 nd8526 nd9177 1.487039843942e+01
RINT8527 nd8527 nd9178 1.487039843942e+01
RINT8528 nd8528 nd9179 8.627601608838e+02
RINT8529 nd8529 nd9180 3.060580775545e+01
RINT8530 nd8530 nd9181 3.082228040171e+01
RINT8531 nd8531 nd9182 3.082228040171e+01
RINT8532 nd8532 nd9183 1.224329471512e+03
RINT8533 nd8533 nd9184 2.040549119187e+02
RINT8534 nd8534 nd9185 3.498084204321e+02
RINT8535 nd8535 nd9186 3.498084204321e+02
RINT8536 nd8536 nd9187 3.498084204321e+02
RINT8537 nd8537 nd9188 3.498084204321e+02
RINT8538 nd8538 nd9189 3.498084204321e+02
RINT8539 nd8539 nd9190 3.498084204321e+02
RINT8540 nd8540 nd9191 3.498084204321e+02
RINT8541 nd8541 nd9192 7.773520454047e+01
RINT8542 nd8542 nd9193 7.773520454047e+01
RINT8543 nd8543 nd9194 1.611548589557e+03
RINT8544 nd8544 nd9195 1.159115429604e+02
RINT8545 nd8545 nd9196 2.571091890176e+03
RINT8546 nd8546 nd9197 1.071288287573e+01
RINT8547 nd8547 nd9198 1.071288287573e+01
RINT8548 nd8548 nd9199 1.071288287573e+01
RINT8549 nd8549 nd9200 1.071288287573e+01
RINT8550 nd8550 nd9201 1.071288287573e+01
RINT8551 nd8551 nd9202 1.071288287573e+01
RINT8552 nd8552 nd9203 1.071288287573e+01
RINT8553 nd8553 nd9204 1.071288287573e+01
RINT8554 nd8554 nd9205 1.071288287573e+01
RINT8555 nd8555 nd9206 1.071288287573e+01
RINT8556 nd8556 nd9207 1.265942732753e+02
RINT8557 nd8557 nd9208 1.093147773279e+02
RINT8558 nd8558 nd9209 1.093147773279e+02
RINT8559 nd8559 nd9210 6.342293736017e+03
RINT8560 nd8560 nd9211 2.249883937783e+02
RINT8561 nd8561 nd9212 2.265797202797e+02
RINT8562 nd8562 nd9213 2.265797202797e+02
RINT8563 nd8563 nd9214 5.906414062500e+05
RINT8564 nd8564 nd9215 9.844023437500e+04
RINT8565 nd8565 nd9216 1.687546875000e+05
RINT8566 nd8566 nd9217 1.687546875000e+05
RINT8567 nd8567 nd9218 1.687546875000e+05
RINT8568 nd8568 nd9219 1.687546875000e+05
RINT8569 nd8569 nd9220 1.687546875000e+05
RINT8570 nd8570 nd9221 1.687546875000e+05
RINT8571 nd8571 nd9222 1.687546875000e+05
RINT8572 nd8572 nd9223 3.750104166667e+04
RINT8573 nd8573 nd9224 3.750104166667e+04
RINT8574 nd8574 nd9225 1.184676227326e+04
RINT8575 nd8575 nd9226 8.520850708924e+02
RINT8576 nd8576 nd9227 1.890052500000e+04
RINT8577 nd8577 nd9228 7.875218750000e+01
RINT8578 nd8578 nd9229 7.875218750000e+01
RINT8579 nd8579 nd9230 7.875218750000e+01
RINT8580 nd8580 nd9231 7.875218750000e+01
RINT8581 nd8581 nd9232 7.875218750000e+01
RINT8582 nd8582 nd9233 7.875218750000e+01
RINT8583 nd8583 nd9234 7.875218750000e+01
RINT8584 nd8584 nd9235 7.875218750000e+01
RINT8585 nd8585 nd9236 7.875218750000e+01
RINT8586 nd8586 nd9237 7.875218750000e+01
RINT8587 nd8587 nd9238 1.322170110122e+01
RINT8588 nd8588 nd9239 1.141700390059e+01
RINT8589 nd8589 nd9240 1.141700390059e+01
RINT8590 nd8590 nd9241 6.623989372047e+02
RINT8591 nd8591 nd9242 2.349813476405e+01
RINT8592 nd8592 nd9243 2.366433535758e+01
RINT8593 nd8593 nd9244 2.366433535758e+01
RINT8594 nd8594 nd9245 1.239106136042e+03
RINT8595 nd8595 nd9246 1.373695180523e+02
RINT8596 nd8596 nd9247 2.711285174478e+02
RINT8597 nd8597 nd9248 2.711285174478e+02
RINT8598 nd8598 nd9249 2.711285174478e+02
RINT8599 nd8599 nd9250 2.711285174478e+02
RINT8600 nd8600 nd9251 2.711285174478e+02
RINT8601 nd8601 nd9252 2.711285174478e+02
RINT8602 nd8602 nd9253 2.711285174478e+02
RINT8603 nd8603 nd9254 5.233124497231e+01
RINT8604 nd8604 nd9255 5.390580832121e+01
RINT8605 nd8605 nd9256 1.237294118776e+03
RINT8606 nd8606 nd9257 8.899307866519e+01
RINT8607 nd8607 nd9258 1.973999974412e+03
RINT8608 nd8608 nd9259 8.224999893383e+00
RINT8609 nd8609 nd9260 8.224999893383e+00
RINT8610 nd8610 nd9261 8.224999893383e+00
RINT8611 nd8611 nd9262 8.224999893383e+00
RINT8612 nd8612 nd9263 8.224999893383e+00
RINT8613 nd8613 nd9264 8.224999893383e+00
RINT8614 nd8614 nd9265 8.224999893383e+00
RINT8615 nd8615 nd9266 8.224999893383e+00
RINT8616 nd8616 nd9267 8.224999893383e+00
RINT8617 nd8617 nd9268 8.224999893383e+00
RINT8618 nd8618 nd9269 1.322170110122e+01
RINT8619 nd8619 nd9270 1.141700390059e+01
RINT8620 nd8620 nd9271 1.141700390059e+01
RINT8621 nd8621 nd9272 6.623989372047e+02
RINT8622 nd8622 nd9273 2.349813476405e+01
RINT8623 nd8623 nd9274 2.366433535758e+01
RINT8624 nd8624 nd9275 2.366433535758e+01
RINT8625 nd8625 nd9276 1.239106136042e+03
RINT8626 nd8626 nd9277 1.373695180523e+02
RINT8627 nd8627 nd9278 2.711285174478e+02
RINT8628 nd8628 nd9279 2.711285174478e+02
RINT8629 nd8629 nd9280 2.711285174478e+02
RINT8630 nd8630 nd9281 2.711285174478e+02
RINT8631 nd8631 nd9282 2.711285174478e+02
RINT8632 nd8632 nd9283 2.711285174478e+02
RINT8633 nd8633 nd9284 2.711285174478e+02
RINT8634 nd8634 nd9285 5.233124497231e+01
RINT8635 nd8635 nd9286 5.390580832121e+01
RINT8636 nd8636 nd9287 1.237294118776e+03
RINT8637 nd8637 nd9288 8.899307866519e+01
RINT8638 nd8638 nd9289 1.973999974412e+03
RINT8639 nd8639 nd9290 8.224999893383e+00
RINT8640 nd8640 nd9291 8.224999893383e+00
RINT8641 nd8641 nd9292 8.224999893383e+00
RINT8642 nd8642 nd9293 8.224999893383e+00
RINT8643 nd8643 nd9294 8.224999893383e+00
RINT8644 nd8644 nd9295 8.224999893383e+00
RINT8645 nd8645 nd9296 8.224999893383e+00
RINT8646 nd8646 nd9297 8.224999893383e+00
RINT8647 nd8647 nd9298 8.224999893383e+00
RINT8648 nd8648 nd9299 8.224999893383e+00
RINT8649 nd8649 nd9300 1.322170110122e+01
RINT8650 nd8650 nd9301 1.141700390059e+01
RINT8651 nd8651 nd9302 1.141700390059e+01
RINT8652 nd8652 nd9303 6.623989372047e+02
RINT8653 nd8653 nd9304 2.349813476405e+01
RINT8654 nd8654 nd9305 2.366433535758e+01
RINT8655 nd8655 nd9306 2.366433535758e+01
RINT8656 nd8656 nd9307 1.239106136042e+03
RINT8657 nd8657 nd9308 1.373695180523e+02
RINT8658 nd8658 nd9309 2.711285174478e+02
RINT8659 nd8659 nd9310 2.711285174478e+02
RINT8660 nd8660 nd9311 2.711285174478e+02
RINT8661 nd8661 nd9312 2.711285174478e+02
RINT8662 nd8662 nd9313 2.711285174478e+02
RINT8663 nd8663 nd9314 2.711285174478e+02
RINT8664 nd8664 nd9315 2.711285174478e+02
RINT8665 nd8665 nd9316 5.233124497231e+01
RINT8666 nd8666 nd9317 5.390580832121e+01
RINT8667 nd8667 nd9318 1.237294118776e+03
RINT8668 nd8668 nd9319 8.899307866519e+01
RINT8669 nd8669 nd9320 1.973999974412e+03
RINT8670 nd8670 nd9321 8.224999893383e+00
RINT8671 nd8671 nd9322 8.224999893383e+00
RINT8672 nd8672 nd9323 8.224999893383e+00
RINT8673 nd8673 nd9324 8.224999893383e+00
RINT8674 nd8674 nd9325 8.224999893383e+00
RINT8675 nd8675 nd9326 8.224999893383e+00
RINT8676 nd8676 nd9327 8.224999893383e+00
RINT8677 nd8677 nd9328 8.224999893383e+00
RINT8678 nd8678 nd9329 8.224999893383e+00
RINT8679 nd8679 nd9330 8.224999893383e+00
RINT8680 nd8680 nd9331 1.322170110122e+01
RINT8681 nd8681 nd9332 1.141700390059e+01
RINT8682 nd8682 nd9333 1.141700390059e+01
RINT8683 nd8683 nd9334 6.623989372047e+02
RINT8684 nd8684 nd9335 2.349813476405e+01
RINT8685 nd8685 nd9336 2.366433535758e+01
RINT8686 nd8686 nd9337 2.366433535758e+01
RINT8687 nd8687 nd9338 1.239106136042e+03
RINT8688 nd8688 nd9339 1.373695180523e+02
RINT8689 nd8689 nd9340 2.711285174478e+02
RINT8690 nd8690 nd9341 2.711285174478e+02
RINT8691 nd8691 nd9342 2.711285174478e+02
RINT8692 nd8692 nd9343 2.711285174478e+02
RINT8693 nd8693 nd9344 2.711285174478e+02
RINT8694 nd8694 nd9345 2.711285174478e+02
RINT8695 nd8695 nd9346 2.711285174478e+02
RINT8696 nd8696 nd9347 5.233124497231e+01
RINT8697 nd8697 nd9348 5.390580832121e+01
RINT8698 nd8698 nd9349 1.237294118776e+03
RINT8699 nd8699 nd9350 8.899307866519e+01
RINT8700 nd8700 nd9351 1.973999974412e+03
RINT8701 nd8701 nd9352 8.224999893383e+00
RINT8702 nd8702 nd9353 8.224999893383e+00
RINT8703 nd8703 nd9354 8.224999893383e+00
RINT8704 nd8704 nd9355 8.224999893383e+00
RINT8705 nd8705 nd9356 8.224999893383e+00
RINT8706 nd8706 nd9357 8.224999893383e+00
RINT8707 nd8707 nd9358 8.224999893383e+00
RINT8708 nd8708 nd9359 8.224999893383e+00
RINT8709 nd8709 nd9360 8.224999893383e+00
RINT8710 nd8710 nd9361 8.224999893383e+00
RINT8711 nd8711 nd9362 1.322170110122e+01
RINT8712 nd8712 nd9363 1.141700390059e+01
RINT8713 nd8713 nd9364 1.141700390059e+01
RINT8714 nd8714 nd9365 6.623989372047e+02
RINT8715 nd8715 nd9366 2.349813476405e+01
RINT8716 nd8716 nd9367 2.366433535758e+01
RINT8717 nd8717 nd9368 2.366433535758e+01
RINT8718 nd8718 nd9369 1.239106136042e+03
RINT8719 nd8719 nd9370 1.373695180523e+02
RINT8720 nd8720 nd9371 2.711285174478e+02
RINT8721 nd8721 nd9372 2.711285174478e+02
RINT8722 nd8722 nd9373 2.711285174478e+02
RINT8723 nd8723 nd9374 2.711285174478e+02
RINT8724 nd8724 nd9375 2.711285174478e+02
RINT8725 nd8725 nd9376 2.711285174478e+02
RINT8726 nd8726 nd9377 2.711285174478e+02
RINT8727 nd8727 nd9378 5.233124497231e+01
RINT8728 nd8728 nd9379 5.390580832121e+01
RINT8729 nd8729 nd9380 1.237294118776e+03
RINT8730 nd8730 nd9381 8.899307866519e+01
RINT8731 nd8731 nd9382 1.973999974412e+03
RINT8732 nd8732 nd9383 8.224999893383e+00
RINT8733 nd8733 nd9384 8.224999893383e+00
RINT8734 nd8734 nd9385 8.224999893383e+00
RINT8735 nd8735 nd9386 8.224999893383e+00
RINT8736 nd8736 nd9387 8.224999893383e+00
RINT8737 nd8737 nd9388 8.224999893383e+00
RINT8738 nd8738 nd9389 8.224999893383e+00
RINT8739 nd8739 nd9390 8.224999893383e+00
RINT8740 nd8740 nd9391 8.224999893383e+00
RINT8741 nd8741 nd9392 8.224999893383e+00
RINT8742 nd8742 nd9393 1.322170110122e+01
RINT8743 nd8743 nd9394 1.141700390059e+01
RINT8744 nd8744 nd9395 1.141700390059e+01
RINT8745 nd8745 nd9396 6.623989372047e+02
RINT8746 nd8746 nd9397 2.349813476405e+01
RINT8747 nd8747 nd9398 2.366433535758e+01
RINT8748 nd8748 nd9399 2.366433535758e+01
RINT8749 nd8749 nd9400 1.239106136042e+03
RINT8750 nd8750 nd9401 1.373695180523e+02
RINT8751 nd8751 nd9402 2.711285174478e+02
RINT8752 nd8752 nd9403 2.711285174478e+02
RINT8753 nd8753 nd9404 2.711285174478e+02
RINT8754 nd8754 nd9405 2.711285174478e+02
RINT8755 nd8755 nd9406 2.711285174478e+02
RINT8756 nd8756 nd9407 2.711285174478e+02
RINT8757 nd8757 nd9408 2.711285174478e+02
RINT8758 nd8758 nd9409 5.233124497231e+01
RINT8759 nd8759 nd9410 5.390580832121e+01
RINT8760 nd8760 nd9411 1.237294118776e+03
RINT8761 nd8761 nd9412 8.899307866519e+01
RINT8762 nd8762 nd9413 1.973999974412e+03
RINT8763 nd8763 nd9414 8.224999893383e+00
RINT8764 nd8764 nd9415 8.224999893383e+00
RINT8765 nd8765 nd9416 8.224999893383e+00
RINT8766 nd8766 nd9417 8.224999893383e+00
RINT8767 nd8767 nd9418 8.224999893383e+00
RINT8768 nd8768 nd9419 8.224999893383e+00
RINT8769 nd8769 nd9420 8.224999893383e+00
RINT8770 nd8770 nd9421 8.224999893383e+00
RINT8771 nd8771 nd9422 8.224999893383e+00
RINT8772 nd8772 nd9423 8.224999893383e+00
RINT8773 nd8773 nd9424 1.265942732753e+02
RINT8774 nd8774 nd9425 1.093147773279e+02
RINT8775 nd8775 nd9426 1.093147773279e+02
RINT8776 nd8776 nd9427 6.342293736017e+03
RINT8777 nd8777 nd9428 2.249883937783e+02
RINT8778 nd8778 nd9429 2.265797202797e+02
RINT8779 nd8779 nd9430 2.265797202797e+02
RINT8780 nd8780 nd9431 5.906414062500e+05
RINT8781 nd8781 nd9432 9.844023437500e+04
RINT8782 nd8782 nd9433 1.687546875000e+05
RINT8783 nd8783 nd9434 1.687546875000e+05
RINT8784 nd8784 nd9435 1.687546875000e+05
RINT8785 nd8785 nd9436 1.687546875000e+05
RINT8786 nd8786 nd9437 1.687546875000e+05
RINT8787 nd8787 nd9438 1.687546875000e+05
RINT8788 nd8788 nd9439 1.687546875000e+05
RINT8789 nd8789 nd9440 3.750104166667e+04
RINT8790 nd8790 nd9441 3.750104166667e+04
RINT8791 nd8791 nd9442 1.184676227326e+04
RINT8792 nd8792 nd9443 8.520850708924e+02
RINT8793 nd8793 nd9444 1.890052500000e+04
RINT8794 nd8794 nd9445 7.875218750000e+01
RINT8795 nd8795 nd9446 7.875218750000e+01
RINT8796 nd8796 nd9447 7.875218750000e+01
RINT8797 nd8797 nd9448 7.875218750000e+01
RINT8798 nd8798 nd9449 7.875218750000e+01
RINT8799 nd8799 nd9450 7.875218750000e+01
RINT8800 nd8800 nd9451 7.875218750000e+01
RINT8801 nd8801 nd9452 7.875218750000e+01
RINT8802 nd8802 nd9453 7.875218750000e+01
RINT8803 nd8803 nd9454 7.875218750000e+01
RINT8804 nd8804 nd9455 1.322170110122e+01
RINT8805 nd8805 nd9456 1.141700390059e+01
RINT8806 nd8806 nd9457 1.141700390059e+01
RINT8807 nd8807 nd9458 6.623989372047e+02
RINT8808 nd8808 nd9459 2.349813476405e+01
RINT8809 nd8809 nd9460 2.366433535758e+01
RINT8810 nd8810 nd9461 2.366433535758e+01
RINT8811 nd8811 nd9462 1.239106136042e+03
RINT8812 nd8812 nd9463 1.373695180523e+02
RINT8813 nd8813 nd9464 2.711285174478e+02
RINT8814 nd8814 nd9465 2.711285174478e+02
RINT8815 nd8815 nd9466 2.711285174478e+02
RINT8816 nd8816 nd9467 2.711285174478e+02
RINT8817 nd8817 nd9468 2.711285174478e+02
RINT8818 nd8818 nd9469 2.711285174478e+02
RINT8819 nd8819 nd9470 2.711285174478e+02
RINT8820 nd8820 nd9471 5.233124497231e+01
RINT8821 nd8821 nd9472 5.390580832121e+01
RINT8822 nd8822 nd9473 1.237294118776e+03
RINT8823 nd8823 nd9474 8.899307866519e+01
RINT8824 nd8824 nd9475 1.973999974412e+03
RINT8825 nd8825 nd9476 8.224999893383e+00
RINT8826 nd8826 nd9477 8.224999893383e+00
RINT8827 nd8827 nd9478 8.224999893383e+00
RINT8828 nd8828 nd9479 8.224999893383e+00
RINT8829 nd8829 nd9480 8.224999893383e+00
RINT8830 nd8830 nd9481 8.224999893383e+00
RINT8831 nd8831 nd9482 8.224999893383e+00
RINT8832 nd8832 nd9483 8.224999893383e+00
RINT8833 nd8833 nd9484 8.224999893383e+00
RINT8834 nd8834 nd9485 8.224999893383e+00
RINT8835 nd8835 nd9486 1.322170110122e+01
RINT8836 nd8836 nd9487 1.141700390059e+01
RINT8837 nd8837 nd9488 1.141700390059e+01
RINT8838 nd8838 nd9489 6.623989372047e+02
RINT8839 nd8839 nd9490 2.349813476405e+01
RINT8840 nd8840 nd9491 2.366433535758e+01
RINT8841 nd8841 nd9492 2.366433535758e+01
RINT8842 nd8842 nd9493 1.239106136042e+03
RINT8843 nd8843 nd9494 1.373695180523e+02
RINT8844 nd8844 nd9495 2.711285174478e+02
RINT8845 nd8845 nd9496 2.711285174478e+02
RINT8846 nd8846 nd9497 2.711285174478e+02
RINT8847 nd8847 nd9498 2.711285174478e+02
RINT8848 nd8848 nd9499 2.711285174478e+02
RINT8849 nd8849 nd9500 2.711285174478e+02
RINT8850 nd8850 nd9501 2.711285174478e+02
RINT8851 nd8851 nd9502 5.233124497231e+01
RINT8852 nd8852 nd9503 5.390580832121e+01
RINT8853 nd8853 nd9504 1.237294118776e+03
RINT8854 nd8854 nd9505 8.899307866519e+01
RINT8855 nd8855 nd9506 1.973999974412e+03
RINT8856 nd8856 nd9507 8.224999893383e+00
RINT8857 nd8857 nd9508 8.224999893383e+00
RINT8858 nd8858 nd9509 8.224999893383e+00
RINT8859 nd8859 nd9510 8.224999893383e+00
RINT8860 nd8860 nd9511 8.224999893383e+00
RINT8861 nd8861 nd9512 8.224999893383e+00
RINT8862 nd8862 nd9513 8.224999893383e+00
RINT8863 nd8863 nd9514 8.224999893383e+00
RINT8864 nd8864 nd9515 8.224999893383e+00
RINT8865 nd8865 nd9516 8.224999893383e+00
RINT8866 nd8866 nd9517 1.322170110122e+01
RINT8867 nd8867 nd9518 1.141700390059e+01
RINT8868 nd8868 nd9519 1.141700390059e+01
RINT8869 nd8869 nd9520 6.623989372047e+02
RINT8870 nd8870 nd9521 2.349813476405e+01
RINT8871 nd8871 nd9522 2.366433535758e+01
RINT8872 nd8872 nd9523 2.366433535758e+01
RINT8873 nd8873 nd9524 1.239106136042e+03
RINT8874 nd8874 nd9525 1.373695180523e+02
RINT8875 nd8875 nd9526 2.711285174478e+02
RINT8876 nd8876 nd9527 2.711285174478e+02
RINT8877 nd8877 nd9528 2.711285174478e+02
RINT8878 nd8878 nd9529 2.711285174478e+02
RINT8879 nd8879 nd9530 2.711285174478e+02
RINT8880 nd8880 nd9531 2.711285174478e+02
RINT8881 nd8881 nd9532 2.711285174478e+02
RINT8882 nd8882 nd9533 5.233124497231e+01
RINT8883 nd8883 nd9534 5.390580832121e+01
RINT8884 nd8884 nd9535 1.237294118776e+03
RINT8885 nd8885 nd9536 8.899307866519e+01
RINT8886 nd8886 nd9537 1.973999974412e+03
RINT8887 nd8887 nd9538 8.224999893383e+00
RINT8888 nd8888 nd9539 8.224999893383e+00
RINT8889 nd8889 nd9540 8.224999893383e+00
RINT8890 nd8890 nd9541 8.224999893383e+00
RINT8891 nd8891 nd9542 8.224999893383e+00
RINT8892 nd8892 nd9543 8.224999893383e+00
RINT8893 nd8893 nd9544 8.224999893383e+00
RINT8894 nd8894 nd9545 8.224999893383e+00
RINT8895 nd8895 nd9546 8.224999893383e+00
RINT8896 nd8896 nd9547 8.224999893383e+00
RINT8897 nd8897 nd9548 1.322170110122e+01
RINT8898 nd8898 nd9549 1.141700390059e+01
RINT8899 nd8899 nd9550 1.141700390059e+01
RINT8900 nd8900 nd9551 6.623989372047e+02
RINT8901 nd8901 nd9552 2.349813476405e+01
RINT8902 nd8902 nd9553 2.366433535758e+01
RINT8903 nd8903 nd9554 2.366433535758e+01
RINT8904 nd8904 nd9555 1.239106136042e+03
RINT8905 nd8905 nd9556 1.373695180523e+02
RINT8906 nd8906 nd9557 2.711285174478e+02
RINT8907 nd8907 nd9558 2.711285174478e+02
RINT8908 nd8908 nd9559 2.711285174478e+02
RINT8909 nd8909 nd9560 2.711285174478e+02
RINT8910 nd8910 nd9561 2.711285174478e+02
RINT8911 nd8911 nd9562 2.711285174478e+02
RINT8912 nd8912 nd9563 2.711285174478e+02
RINT8913 nd8913 nd9564 5.233124497231e+01
RINT8914 nd8914 nd9565 5.390580832121e+01
RINT8915 nd8915 nd9566 1.237294118776e+03
RINT8916 nd8916 nd9567 8.899307866519e+01
RINT8917 nd8917 nd9568 1.973999974412e+03
RINT8918 nd8918 nd9569 8.224999893383e+00
RINT8919 nd8919 nd9570 8.224999893383e+00
RINT8920 nd8920 nd9571 8.224999893383e+00
RINT8921 nd8921 nd9572 8.224999893383e+00
RINT8922 nd8922 nd9573 8.224999893383e+00
RINT8923 nd8923 nd9574 8.224999893383e+00
RINT8924 nd8924 nd9575 8.224999893383e+00
RINT8925 nd8925 nd9576 8.224999893383e+00
RINT8926 nd8926 nd9577 8.224999893383e+00
RINT8927 nd8927 nd9578 8.224999893383e+00
RINT8928 nd8928 nd9579 1.322170110122e+01
RINT8929 nd8929 nd9580 1.141700390059e+01
RINT8930 nd8930 nd9581 1.141700390059e+01
RINT8931 nd8931 nd9582 6.623989372047e+02
RINT8932 nd8932 nd9583 2.349813476405e+01
RINT8933 nd8933 nd9584 2.366433535758e+01
RINT8934 nd8934 nd9585 2.366433535758e+01
RINT8935 nd8935 nd9586 1.239106136042e+03
RINT8936 nd8936 nd9587 1.373695180523e+02
RINT8937 nd8937 nd9588 2.711285174478e+02
RINT8938 nd8938 nd9589 2.711285174478e+02
RINT8939 nd8939 nd9590 2.711285174478e+02
RINT8940 nd8940 nd9591 2.711285174478e+02
RINT8941 nd8941 nd9592 2.711285174478e+02
RINT8942 nd8942 nd9593 2.711285174478e+02
RINT8943 nd8943 nd9594 2.711285174478e+02
RINT8944 nd8944 nd9595 5.233124497231e+01
RINT8945 nd8945 nd9596 5.390580832121e+01
RINT8946 nd8946 nd9597 1.237294118776e+03
RINT8947 nd8947 nd9598 8.899307866519e+01
RINT8948 nd8948 nd9599 1.973999974412e+03
RINT8949 nd8949 nd9600 8.224999893383e+00
RINT8950 nd8950 nd9601 8.224999893383e+00
RINT8951 nd8951 nd9602 8.224999893383e+00
RINT8952 nd8952 nd9603 8.224999893383e+00
RINT8953 nd8953 nd9604 8.224999893383e+00
RINT8954 nd8954 nd9605 8.224999893383e+00
RINT8955 nd8955 nd9606 8.224999893383e+00
RINT8956 nd8956 nd9607 8.224999893383e+00
RINT8957 nd8957 nd9608 8.224999893383e+00
RINT8958 nd8958 nd9609 8.224999893383e+00
RINT8959 nd8959 nd9610 1.322170110122e+01
RINT8960 nd8960 nd9611 1.141700390059e+01
RINT8961 nd8961 nd9612 1.141700390059e+01
RINT8962 nd8962 nd9613 6.623989372047e+02
RINT8963 nd8963 nd9614 2.349813476405e+01
RINT8964 nd8964 nd9615 2.366433535758e+01
RINT8965 nd8965 nd9616 2.366433535758e+01
RINT8966 nd8966 nd9617 1.239106136042e+03
RINT8967 nd8967 nd9618 1.373695180523e+02
RINT8968 nd8968 nd9619 2.711285174478e+02
RINT8969 nd8969 nd9620 2.711285174478e+02
RINT8970 nd8970 nd9621 2.711285174478e+02
RINT8971 nd8971 nd9622 2.711285174478e+02
RINT8972 nd8972 nd9623 2.711285174478e+02
RINT8973 nd8973 nd9624 2.711285174478e+02
RINT8974 nd8974 nd9625 2.711285174478e+02
RINT8975 nd8975 nd9626 5.233124497231e+01
RINT8976 nd8976 nd9627 5.390580832121e+01
RINT8977 nd8977 nd9628 1.237294118776e+03
RINT8978 nd8978 nd9629 8.899307866519e+01
RINT8979 nd8979 nd9630 1.973999974412e+03
RINT8980 nd8980 nd9631 8.224999893383e+00
RINT8981 nd8981 nd9632 8.224999893383e+00
RINT8982 nd8982 nd9633 8.224999893383e+00
RINT8983 nd8983 nd9634 8.224999893383e+00
RINT8984 nd8984 nd9635 8.224999893383e+00
RINT8985 nd8985 nd9636 8.224999893383e+00
RINT8986 nd8986 nd9637 8.224999893383e+00
RINT8987 nd8987 nd9638 8.224999893383e+00
RINT8988 nd8988 nd9639 8.224999893383e+00
RINT8989 nd8989 nd9640 8.224999893383e+00
RINT8990 nd8990 nd9641 1.265942732753e+02
RINT8991 nd8991 nd9642 1.093147773279e+02
RINT8992 nd8992 nd9643 1.093147773279e+02
RINT8993 nd8993 nd9644 6.342293736017e+03
RINT8994 nd8994 nd9645 2.249883937783e+02
RINT8995 nd8995 nd9646 2.265797202797e+02
RINT8996 nd8996 nd9647 2.265797202797e+02
RINT8997 nd8997 nd9648 5.906414062500e+05
RINT8998 nd8998 nd9649 9.844023437500e+04
RINT8999 nd8999 nd9650 1.687546875000e+05
RINT9000 nd9000 nd9651 1.687546875000e+05
RINT9001 nd9001 nd9652 1.687546875000e+05
RINT9002 nd9002 nd9653 1.687546875000e+05
RINT9003 nd9003 nd9654 1.687546875000e+05
RINT9004 nd9004 nd9655 1.687546875000e+05
RINT9005 nd9005 nd9656 1.687546875000e+05
RINT9006 nd9006 nd9657 3.750104166667e+04
RINT9007 nd9007 nd9658 3.750104166667e+04
RINT9008 nd9008 nd9659 1.184676227326e+04
RINT9009 nd9009 nd9660 8.520850708924e+02
RINT9010 nd9010 nd9661 1.890052500000e+04
RINT9011 nd9011 nd9662 7.875218750000e+01
RINT9012 nd9012 nd9663 7.875218750000e+01
RINT9013 nd9013 nd9664 7.875218750000e+01
RINT9014 nd9014 nd9665 7.875218750000e+01
RINT9015 nd9015 nd9666 7.875218750000e+01
RINT9016 nd9016 nd9667 7.875218750000e+01
RINT9017 nd9017 nd9668 7.875218750000e+01
RINT9018 nd9018 nd9669 7.875218750000e+01
RINT9019 nd9019 nd9670 7.875218750000e+01
RINT9020 nd9020 nd9671 7.875218750000e+01
RINT9021 nd9021 nd9672 1.722097716126e+01
RINT9022 nd9022 nd9673 1.487039843942e+01
RINT9023 nd9023 nd9674 1.487039843942e+01
RINT9024 nd9024 nd9675 8.627601608838e+02
RINT9025 nd9025 nd9676 3.060580775545e+01
RINT9026 nd9026 nd9677 3.082228040171e+01
RINT9027 nd9027 nd9678 3.082228040171e+01
RINT9028 nd9028 nd9679 1.224329471512e+03
RINT9029 nd9029 nd9680 2.040549119187e+02
RINT9030 nd9030 nd9681 3.498084204321e+02
RINT9031 nd9031 nd9682 3.498084204321e+02
RINT9032 nd9032 nd9683 3.498084204321e+02
RINT9033 nd9033 nd9684 3.498084204321e+02
RINT9034 nd9034 nd9685 3.498084204321e+02
RINT9035 nd9035 nd9686 3.498084204321e+02
RINT9036 nd9036 nd9687 3.498084204321e+02
RINT9037 nd9037 nd9688 7.773520454047e+01
RINT9038 nd9038 nd9689 7.773520454047e+01
RINT9039 nd9039 nd9690 1.611548589557e+03
RINT9040 nd9040 nd9691 1.159115429604e+02
RINT9041 nd9041 nd9692 2.571091890176e+03
RINT9042 nd9042 nd9693 1.071288287573e+01
RINT9043 nd9043 nd9694 1.071288287573e+01
RINT9044 nd9044 nd9695 1.071288287573e+01
RINT9045 nd9045 nd9696 1.071288287573e+01
RINT9046 nd9046 nd9697 1.071288287573e+01
RINT9047 nd9047 nd9698 1.071288287573e+01
RINT9048 nd9048 nd9699 1.071288287573e+01
RINT9049 nd9049 nd9700 1.071288287573e+01
RINT9050 nd9050 nd9701 1.071288287573e+01
RINT9051 nd9051 nd9702 1.071288287573e+01
RINT9052 nd9052 nd9703 1.722097716126e+01
RINT9053 nd9053 nd9704 1.487039843942e+01
RINT9054 nd9054 nd9705 1.487039843942e+01
RINT9055 nd9055 nd9706 8.627601608838e+02
RINT9056 nd9056 nd9707 3.060580775545e+01
RINT9057 nd9057 nd9708 3.082228040171e+01
RINT9058 nd9058 nd9709 3.082228040171e+01
RINT9059 nd9059 nd9710 1.224329471512e+03
RINT9060 nd9060 nd9711 2.040549119187e+02
RINT9061 nd9061 nd9712 3.498084204321e+02
RINT9062 nd9062 nd9713 3.498084204321e+02
RINT9063 nd9063 nd9714 3.498084204321e+02
RINT9064 nd9064 nd9715 3.498084204321e+02
RINT9065 nd9065 nd9716 3.498084204321e+02
RINT9066 nd9066 nd9717 3.498084204321e+02
RINT9067 nd9067 nd9718 3.498084204321e+02
RINT9068 nd9068 nd9719 7.773520454047e+01
RINT9069 nd9069 nd9720 7.773520454047e+01
RINT9070 nd9070 nd9721 1.611548589557e+03
RINT9071 nd9071 nd9722 1.159115429604e+02
RINT9072 nd9072 nd9723 2.571091890176e+03
RINT9073 nd9073 nd9724 1.071288287573e+01
RINT9074 nd9074 nd9725 1.071288287573e+01
RINT9075 nd9075 nd9726 1.071288287573e+01
RINT9076 nd9076 nd9727 1.071288287573e+01
RINT9077 nd9077 nd9728 1.071288287573e+01
RINT9078 nd9078 nd9729 1.071288287573e+01
RINT9079 nd9079 nd9730 1.071288287573e+01
RINT9080 nd9080 nd9731 1.071288287573e+01
RINT9081 nd9081 nd9732 1.071288287573e+01
RINT9082 nd9082 nd9733 1.071288287573e+01
RINT9083 nd9083 nd9734 1.722097716126e+01
RINT9084 nd9084 nd9735 1.487039843942e+01
RINT9085 nd9085 nd9736 1.487039843942e+01
RINT9086 nd9086 nd9737 8.627601608838e+02
RINT9087 nd9087 nd9738 3.060580775545e+01
RINT9088 nd9088 nd9739 3.082228040171e+01
RINT9089 nd9089 nd9740 3.082228040171e+01
RINT9090 nd9090 nd9741 1.224329471512e+03
RINT9091 nd9091 nd9742 2.040549119187e+02
RINT9092 nd9092 nd9743 3.498084204321e+02
RINT9093 nd9093 nd9744 3.498084204321e+02
RINT9094 nd9094 nd9745 3.498084204321e+02
RINT9095 nd9095 nd9746 3.498084204321e+02
RINT9096 nd9096 nd9747 3.498084204321e+02
RINT9097 nd9097 nd9748 3.498084204321e+02
RINT9098 nd9098 nd9749 3.498084204321e+02
RINT9099 nd9099 nd9750 7.773520454047e+01
RINT9100 nd9100 nd9751 7.773520454047e+01
RINT9101 nd9101 nd9752 1.611548589557e+03
RINT9102 nd9102 nd9753 1.159115429604e+02
RINT9103 nd9103 nd9754 2.571091890176e+03
RINT9104 nd9104 nd9755 1.071288287573e+01
RINT9105 nd9105 nd9756 1.071288287573e+01
RINT9106 nd9106 nd9757 1.071288287573e+01
RINT9107 nd9107 nd9758 1.071288287573e+01
RINT9108 nd9108 nd9759 1.071288287573e+01
RINT9109 nd9109 nd9760 1.071288287573e+01
RINT9110 nd9110 nd9761 1.071288287573e+01
RINT9111 nd9111 nd9762 1.071288287573e+01
RINT9112 nd9112 nd9763 1.071288287573e+01
RINT9113 nd9113 nd9764 1.071288287573e+01
RINT9114 nd9114 nd9765 1.722097716126e+01
RINT9115 nd9115 nd9766 1.487039843942e+01
RINT9116 nd9116 nd9767 1.487039843942e+01
RINT9117 nd9117 nd9768 8.627601608838e+02
RINT9118 nd9118 nd9769 3.060580775545e+01
RINT9119 nd9119 nd9770 3.082228040171e+01
RINT9120 nd9120 nd9771 3.082228040171e+01
RINT9121 nd9121 nd9772 1.224329471512e+03
RINT9122 nd9122 nd9773 2.040549119187e+02
RINT9123 nd9123 nd9774 3.498084204321e+02
RINT9124 nd9124 nd9775 3.498084204321e+02
RINT9125 nd9125 nd9776 3.498084204321e+02
RINT9126 nd9126 nd9777 3.498084204321e+02
RINT9127 nd9127 nd9778 3.498084204321e+02
RINT9128 nd9128 nd9779 3.498084204321e+02
RINT9129 nd9129 nd9780 3.498084204321e+02
RINT9130 nd9130 nd9781 7.773520454047e+01
RINT9131 nd9131 nd9782 7.773520454047e+01
RINT9132 nd9132 nd9783 1.611548589557e+03
RINT9133 nd9133 nd9784 1.159115429604e+02
RINT9134 nd9134 nd9785 2.571091890176e+03
RINT9135 nd9135 nd9786 1.071288287573e+01
RINT9136 nd9136 nd9787 1.071288287573e+01
RINT9137 nd9137 nd9788 1.071288287573e+01
RINT9138 nd9138 nd9789 1.071288287573e+01
RINT9139 nd9139 nd9790 1.071288287573e+01
RINT9140 nd9140 nd9791 1.071288287573e+01
RINT9141 nd9141 nd9792 1.071288287573e+01
RINT9142 nd9142 nd9793 1.071288287573e+01
RINT9143 nd9143 nd9794 1.071288287573e+01
RINT9144 nd9144 nd9795 1.071288287573e+01
RINT9145 nd9145 nd9796 1.722097716126e+01
RINT9146 nd9146 nd9797 1.487039843942e+01
RINT9147 nd9147 nd9798 1.487039843942e+01
RINT9148 nd9148 nd9799 8.627601608838e+02
RINT9149 nd9149 nd9800 3.060580775545e+01
RINT9150 nd9150 nd9801 3.082228040171e+01
RINT9151 nd9151 nd9802 3.082228040171e+01
RINT9152 nd9152 nd9803 1.224329471512e+03
RINT9153 nd9153 nd9804 2.040549119187e+02
RINT9154 nd9154 nd9805 3.498084204321e+02
RINT9155 nd9155 nd9806 3.498084204321e+02
RINT9156 nd9156 nd9807 3.498084204321e+02
RINT9157 nd9157 nd9808 3.498084204321e+02
RINT9158 nd9158 nd9809 3.498084204321e+02
RINT9159 nd9159 nd9810 3.498084204321e+02
RINT9160 nd9160 nd9811 3.498084204321e+02
RINT9161 nd9161 nd9812 7.773520454047e+01
RINT9162 nd9162 nd9813 7.773520454047e+01
RINT9163 nd9163 nd9814 1.611548589557e+03
RINT9164 nd9164 nd9815 1.159115429604e+02
RINT9165 nd9165 nd9816 2.571091890176e+03
RINT9166 nd9166 nd9817 1.071288287573e+01
RINT9167 nd9167 nd9818 1.071288287573e+01
RINT9168 nd9168 nd9819 1.071288287573e+01
RINT9169 nd9169 nd9820 1.071288287573e+01
RINT9170 nd9170 nd9821 1.071288287573e+01
RINT9171 nd9171 nd9822 1.071288287573e+01
RINT9172 nd9172 nd9823 1.071288287573e+01
RINT9173 nd9173 nd9824 1.071288287573e+01
RINT9174 nd9174 nd9825 1.071288287573e+01
RINT9175 nd9175 nd9826 1.071288287573e+01
RINT9176 nd9176 nd9827 1.722097716126e+01
RINT9177 nd9177 nd9828 1.487039843942e+01
RINT9178 nd9178 nd9829 1.487039843942e+01
RINT9179 nd9179 nd9830 8.627601608838e+02
RINT9180 nd9180 nd9831 3.060580775545e+01
RINT9181 nd9181 nd9832 3.082228040171e+01
RINT9182 nd9182 nd9833 3.082228040171e+01
RINT9183 nd9183 nd9834 1.224329471512e+03
RINT9184 nd9184 nd9835 2.040549119187e+02
RINT9185 nd9185 nd9836 3.498084204321e+02
RINT9186 nd9186 nd9837 3.498084204321e+02
RINT9187 nd9187 nd9838 3.498084204321e+02
RINT9188 nd9188 nd9839 3.498084204321e+02
RINT9189 nd9189 nd9840 3.498084204321e+02
RINT9190 nd9190 nd9841 3.498084204321e+02
RINT9191 nd9191 nd9842 3.498084204321e+02
RINT9192 nd9192 nd9843 7.773520454047e+01
RINT9193 nd9193 nd9844 7.773520454047e+01
RINT9194 nd9194 nd9845 1.611548589557e+03
RINT9195 nd9195 nd9846 1.159115429604e+02
RINT9196 nd9196 nd9847 2.571091890176e+03
RINT9197 nd9197 nd9848 1.071288287573e+01
RINT9198 nd9198 nd9849 1.071288287573e+01
RINT9199 nd9199 nd9850 1.071288287573e+01
RINT9200 nd9200 nd9851 1.071288287573e+01
RINT9201 nd9201 nd9852 1.071288287573e+01
RINT9202 nd9202 nd9853 1.071288287573e+01
RINT9203 nd9203 nd9854 1.071288287573e+01
RINT9204 nd9204 nd9855 1.071288287573e+01
RINT9205 nd9205 nd9856 1.071288287573e+01
RINT9206 nd9206 nd9857 1.071288287573e+01
RINT9207 nd9207 nd9858 1.265942732753e+02
RINT9208 nd9208 nd9859 1.093147773279e+02
RINT9209 nd9209 nd9860 1.093147773279e+02
RINT9210 nd9210 nd9861 6.342293736017e+03
RINT9211 nd9211 nd9862 2.249883937783e+02
RINT9212 nd9212 nd9863 2.265797202797e+02
RINT9213 nd9213 nd9864 2.265797202797e+02
RINT9214 nd9214 nd9865 5.906414062500e+05
RINT9215 nd9215 nd9866 9.844023437500e+04
RINT9216 nd9216 nd9867 1.687546875000e+05
RINT9217 nd9217 nd9868 1.687546875000e+05
RINT9218 nd9218 nd9869 1.687546875000e+05
RINT9219 nd9219 nd9870 1.687546875000e+05
RINT9220 nd9220 nd9871 1.687546875000e+05
RINT9221 nd9221 nd9872 1.687546875000e+05
RINT9222 nd9222 nd9873 1.687546875000e+05
RINT9223 nd9223 nd9874 3.750104166667e+04
RINT9224 nd9224 nd9875 3.750104166667e+04
RINT9225 nd9225 nd9876 1.184676227326e+04
RINT9226 nd9226 nd9877 8.520850708924e+02
RINT9227 nd9227 nd9878 1.890052500000e+04
RINT9228 nd9228 nd9879 7.875218750000e+01
RINT9229 nd9229 nd9880 7.875218750000e+01
RINT9230 nd9230 nd9881 7.875218750000e+01
RINT9231 nd9231 nd9882 7.875218750000e+01
RINT9232 nd9232 nd9883 7.875218750000e+01
RINT9233 nd9233 nd9884 7.875218750000e+01
RINT9234 nd9234 nd9885 7.875218750000e+01
RINT9235 nd9235 nd9886 7.875218750000e+01
RINT9236 nd9236 nd9887 7.875218750000e+01
RINT9237 nd9237 nd9888 7.875218750000e+01
RINT9238 nd9238 nd9889 1.322170110122e+01
RINT9239 nd9239 nd9890 1.141700390059e+01
RINT9240 nd9240 nd9891 1.141700390059e+01
RINT9241 nd9241 nd9892 6.623989372047e+02
RINT9242 nd9242 nd9893 2.349813476405e+01
RINT9243 nd9243 nd9894 2.366433535758e+01
RINT9244 nd9244 nd9895 2.366433535758e+01
RINT9245 nd9245 nd9896 1.239106136042e+03
RINT9246 nd9246 nd9897 1.373695180523e+02
RINT9247 nd9247 nd9898 2.711285174478e+02
RINT9248 nd9248 nd9899 2.711285174478e+02
RINT9249 nd9249 nd9900 2.711285174478e+02
RINT9250 nd9250 nd9901 2.711285174478e+02
RINT9251 nd9251 nd9902 2.711285174478e+02
RINT9252 nd9252 nd9903 2.711285174478e+02
RINT9253 nd9253 nd9904 2.711285174478e+02
RINT9254 nd9254 nd9905 5.233124497231e+01
RINT9255 nd9255 nd9906 5.390580832121e+01
RINT9256 nd9256 nd9907 1.237294118776e+03
RINT9257 nd9257 nd9908 8.899307866519e+01
RINT9258 nd9258 nd9909 1.973999974412e+03
RINT9259 nd9259 nd9910 8.224999893383e+00
RINT9260 nd9260 nd9911 8.224999893383e+00
RINT9261 nd9261 nd9912 8.224999893383e+00
RINT9262 nd9262 nd9913 8.224999893383e+00
RINT9263 nd9263 nd9914 8.224999893383e+00
RINT9264 nd9264 nd9915 8.224999893383e+00
RINT9265 nd9265 nd9916 8.224999893383e+00
RINT9266 nd9266 nd9917 8.224999893383e+00
RINT9267 nd9267 nd9918 8.224999893383e+00
RINT9268 nd9268 nd9919 8.224999893383e+00
RINT9269 nd9269 nd9920 1.322170110122e+01
RINT9270 nd9270 nd9921 1.141700390059e+01
RINT9271 nd9271 nd9922 1.141700390059e+01
RINT9272 nd9272 nd9923 6.623989372047e+02
RINT9273 nd9273 nd9924 2.349813476405e+01
RINT9274 nd9274 nd9925 2.366433535758e+01
RINT9275 nd9275 nd9926 2.366433535758e+01
RINT9276 nd9276 nd9927 1.239106136042e+03
RINT9277 nd9277 nd9928 1.373695180523e+02
RINT9278 nd9278 nd9929 2.711285174478e+02
RINT9279 nd9279 nd9930 2.711285174478e+02
RINT9280 nd9280 nd9931 2.711285174478e+02
RINT9281 nd9281 nd9932 2.711285174478e+02
RINT9282 nd9282 nd9933 2.711285174478e+02
RINT9283 nd9283 nd9934 2.711285174478e+02
RINT9284 nd9284 nd9935 2.711285174478e+02
RINT9285 nd9285 nd9936 5.233124497231e+01
RINT9286 nd9286 nd9937 5.390580832121e+01
RINT9287 nd9287 nd9938 1.237294118776e+03
RINT9288 nd9288 nd9939 8.899307866519e+01
RINT9289 nd9289 nd9940 1.973999974412e+03
RINT9290 nd9290 nd9941 8.224999893383e+00
RINT9291 nd9291 nd9942 8.224999893383e+00
RINT9292 nd9292 nd9943 8.224999893383e+00
RINT9293 nd9293 nd9944 8.224999893383e+00
RINT9294 nd9294 nd9945 8.224999893383e+00
RINT9295 nd9295 nd9946 8.224999893383e+00
RINT9296 nd9296 nd9947 8.224999893383e+00
RINT9297 nd9297 nd9948 8.224999893383e+00
RINT9298 nd9298 nd9949 8.224999893383e+00
RINT9299 nd9299 nd9950 8.224999893383e+00
RINT9300 nd9300 nd9951 1.322170110122e+01
RINT9301 nd9301 nd9952 1.141700390059e+01
RINT9302 nd9302 nd9953 1.141700390059e+01
RINT9303 nd9303 nd9954 6.623989372047e+02
RINT9304 nd9304 nd9955 2.349813476405e+01
RINT9305 nd9305 nd9956 2.366433535758e+01
RINT9306 nd9306 nd9957 2.366433535758e+01
RINT9307 nd9307 nd9958 1.239106136042e+03
RINT9308 nd9308 nd9959 1.373695180523e+02
RINT9309 nd9309 nd9960 2.711285174478e+02
RINT9310 nd9310 nd9961 2.711285174478e+02
RINT9311 nd9311 nd9962 2.711285174478e+02
RINT9312 nd9312 nd9963 2.711285174478e+02
RINT9313 nd9313 nd9964 2.711285174478e+02
RINT9314 nd9314 nd9965 2.711285174478e+02
RINT9315 nd9315 nd9966 2.711285174478e+02
RINT9316 nd9316 nd9967 5.233124497231e+01
RINT9317 nd9317 nd9968 5.390580832121e+01
RINT9318 nd9318 nd9969 1.237294118776e+03
RINT9319 nd9319 nd9970 8.899307866519e+01
RINT9320 nd9320 nd9971 1.973999974412e+03
RINT9321 nd9321 nd9972 8.224999893383e+00
RINT9322 nd9322 nd9973 8.224999893383e+00
RINT9323 nd9323 nd9974 8.224999893383e+00
RINT9324 nd9324 nd9975 8.224999893383e+00
RINT9325 nd9325 nd9976 8.224999893383e+00
RINT9326 nd9326 nd9977 8.224999893383e+00
RINT9327 nd9327 nd9978 8.224999893383e+00
RINT9328 nd9328 nd9979 8.224999893383e+00
RINT9329 nd9329 nd9980 8.224999893383e+00
RINT9330 nd9330 nd9981 8.224999893383e+00
RINT9331 nd9331 nd9982 1.322170110122e+01
RINT9332 nd9332 nd9983 1.141700390059e+01
RINT9333 nd9333 nd9984 1.141700390059e+01
RINT9334 nd9334 nd9985 6.623989372047e+02
RINT9335 nd9335 nd9986 2.349813476405e+01
RINT9336 nd9336 nd9987 2.366433535758e+01
RINT9337 nd9337 nd9988 2.366433535758e+01
RINT9338 nd9338 nd9989 1.239106136042e+03
RINT9339 nd9339 nd9990 1.373695180523e+02
RINT9340 nd9340 nd9991 2.711285174478e+02
RINT9341 nd9341 nd9992 2.711285174478e+02
RINT9342 nd9342 nd9993 2.711285174478e+02
RINT9343 nd9343 nd9994 2.711285174478e+02
RINT9344 nd9344 nd9995 2.711285174478e+02
RINT9345 nd9345 nd9996 2.711285174478e+02
RINT9346 nd9346 nd9997 2.711285174478e+02
RINT9347 nd9347 nd9998 5.233124497231e+01
RINT9348 nd9348 nd9999 5.390580832121e+01
RINT9349 nd9349 nd10000 1.237294118776e+03
RINT9350 nd9350 nd10001 8.899307866519e+01
RINT9351 nd9351 nd10002 1.973999974412e+03
RINT9352 nd9352 nd10003 8.224999893383e+00
RINT9353 nd9353 nd10004 8.224999893383e+00
RINT9354 nd9354 nd10005 8.224999893383e+00
RINT9355 nd9355 nd10006 8.224999893383e+00
RINT9356 nd9356 nd10007 8.224999893383e+00
RINT9357 nd9357 nd10008 8.224999893383e+00
RINT9358 nd9358 nd10009 8.224999893383e+00
RINT9359 nd9359 nd10010 8.224999893383e+00
RINT9360 nd9360 nd10011 8.224999893383e+00
RINT9361 nd9361 nd10012 8.224999893383e+00
RINT9362 nd9362 nd10013 1.322170110122e+01
RINT9363 nd9363 nd10014 1.141700390059e+01
RINT9364 nd9364 nd10015 1.141700390059e+01
RINT9365 nd9365 nd10016 6.623989372047e+02
RINT9366 nd9366 nd10017 2.349813476405e+01
RINT9367 nd9367 nd10018 2.366433535758e+01
RINT9368 nd9368 nd10019 2.366433535758e+01
RINT9369 nd9369 nd10020 1.239106136042e+03
RINT9370 nd9370 nd10021 1.373695180523e+02
RINT9371 nd9371 nd10022 2.711285174478e+02
RINT9372 nd9372 nd10023 2.711285174478e+02
RINT9373 nd9373 nd10024 2.711285174478e+02
RINT9374 nd9374 nd10025 2.711285174478e+02
RINT9375 nd9375 nd10026 2.711285174478e+02
RINT9376 nd9376 nd10027 2.711285174478e+02
RINT9377 nd9377 nd10028 2.711285174478e+02
RINT9378 nd9378 nd10029 5.233124497231e+01
RINT9379 nd9379 nd10030 5.390580832121e+01
RINT9380 nd9380 nd10031 1.237294118776e+03
RINT9381 nd9381 nd10032 8.899307866519e+01
RINT9382 nd9382 nd10033 1.973999974412e+03
RINT9383 nd9383 nd10034 8.224999893383e+00
RINT9384 nd9384 nd10035 8.224999893383e+00
RINT9385 nd9385 nd10036 8.224999893383e+00
RINT9386 nd9386 nd10037 8.224999893383e+00
RINT9387 nd9387 nd10038 8.224999893383e+00
RINT9388 nd9388 nd10039 8.224999893383e+00
RINT9389 nd9389 nd10040 8.224999893383e+00
RINT9390 nd9390 nd10041 8.224999893383e+00
RINT9391 nd9391 nd10042 8.224999893383e+00
RINT9392 nd9392 nd10043 8.224999893383e+00
RINT9393 nd9393 nd10044 1.322170110122e+01
RINT9394 nd9394 nd10045 1.141700390059e+01
RINT9395 nd9395 nd10046 1.141700390059e+01
RINT9396 nd9396 nd10047 6.623989372047e+02
RINT9397 nd9397 nd10048 2.349813476405e+01
RINT9398 nd9398 nd10049 2.366433535758e+01
RINT9399 nd9399 nd10050 2.366433535758e+01
RINT9400 nd9400 nd10051 1.239106136042e+03
RINT9401 nd9401 nd10052 1.373695180523e+02
RINT9402 nd9402 nd10053 2.711285174478e+02
RINT9403 nd9403 nd10054 2.711285174478e+02
RINT9404 nd9404 nd10055 2.711285174478e+02
RINT9405 nd9405 nd10056 2.711285174478e+02
RINT9406 nd9406 nd10057 2.711285174478e+02
RINT9407 nd9407 nd10058 2.711285174478e+02
RINT9408 nd9408 nd10059 2.711285174478e+02
RINT9409 nd9409 nd10060 5.233124497231e+01
RINT9410 nd9410 nd10061 5.390580832121e+01
RINT9411 nd9411 nd10062 1.237294118776e+03
RINT9412 nd9412 nd10063 8.899307866519e+01
RINT9413 nd9413 nd10064 1.973999974412e+03
RINT9414 nd9414 nd10065 8.224999893383e+00
RINT9415 nd9415 nd10066 8.224999893383e+00
RINT9416 nd9416 nd10067 8.224999893383e+00
RINT9417 nd9417 nd10068 8.224999893383e+00
RINT9418 nd9418 nd10069 8.224999893383e+00
RINT9419 nd9419 nd10070 8.224999893383e+00
RINT9420 nd9420 nd10071 8.224999893383e+00
RINT9421 nd9421 nd10072 8.224999893383e+00
RINT9422 nd9422 nd10073 8.224999893383e+00
RINT9423 nd9423 nd10074 8.224999893383e+00
RINT9424 nd9424 nd10075 1.265942732753e+02
RINT9425 nd9425 nd10076 1.093147773279e+02
RINT9426 nd9426 nd10077 1.093147773279e+02
RINT9427 nd9427 nd10078 6.342293736017e+03
RINT9428 nd9428 nd10079 2.249883937783e+02
RINT9429 nd9429 nd10080 2.265797202797e+02
RINT9430 nd9430 nd10081 2.265797202797e+02
RINT9431 nd9431 nd10082 5.906414062500e+05
RINT9432 nd9432 nd10083 9.844023437500e+04
RINT9433 nd9433 nd10084 1.687546875000e+05
RINT9434 nd9434 nd10085 1.687546875000e+05
RINT9435 nd9435 nd10086 1.687546875000e+05
RINT9436 nd9436 nd10087 1.687546875000e+05
RINT9437 nd9437 nd10088 1.687546875000e+05
RINT9438 nd9438 nd10089 1.687546875000e+05
RINT9439 nd9439 nd10090 1.687546875000e+05
RINT9440 nd9440 nd10091 3.750104166667e+04
RINT9441 nd9441 nd10092 3.750104166667e+04
RINT9442 nd9442 nd10093 1.184676227326e+04
RINT9443 nd9443 nd10094 8.520850708924e+02
RINT9444 nd9444 nd10095 1.890052500000e+04
RINT9445 nd9445 nd10096 7.875218750000e+01
RINT9446 nd9446 nd10097 7.875218750000e+01
RINT9447 nd9447 nd10098 7.875218750000e+01
RINT9448 nd9448 nd10099 7.875218750000e+01
RINT9449 nd9449 nd10100 7.875218750000e+01
RINT9450 nd9450 nd10101 7.875218750000e+01
RINT9451 nd9451 nd10102 7.875218750000e+01
RINT9452 nd9452 nd10103 7.875218750000e+01
RINT9453 nd9453 nd10104 7.875218750000e+01
RINT9454 nd9454 nd10105 7.875218750000e+01
RINT9455 nd9455 nd10106 1.322170110122e+01
RINT9456 nd9456 nd10107 1.141700390059e+01
RINT9457 nd9457 nd10108 1.141700390059e+01
RINT9458 nd9458 nd10109 6.623989372047e+02
RINT9459 nd9459 nd10110 2.349813476405e+01
RINT9460 nd9460 nd10111 2.366433535758e+01
RINT9461 nd9461 nd10112 2.366433535758e+01
RINT9462 nd9462 nd10113 1.239106136042e+03
RINT9463 nd9463 nd10114 1.373695180523e+02
RINT9464 nd9464 nd10115 2.711285174478e+02
RINT9465 nd9465 nd10116 2.711285174478e+02
RINT9466 nd9466 nd10117 2.711285174478e+02
RINT9467 nd9467 nd10118 2.711285174478e+02
RINT9468 nd9468 nd10119 2.711285174478e+02
RINT9469 nd9469 nd10120 2.711285174478e+02
RINT9470 nd9470 nd10121 2.711285174478e+02
RINT9471 nd9471 nd10122 5.233124497231e+01
RINT9472 nd9472 nd10123 5.390580832121e+01
RINT9473 nd9473 nd10124 1.237294118776e+03
RINT9474 nd9474 nd10125 8.899307866519e+01
RINT9475 nd9475 nd10126 1.973999974412e+03
RINT9476 nd9476 nd10127 8.224999893383e+00
RINT9477 nd9477 nd10128 8.224999893383e+00
RINT9478 nd9478 nd10129 8.224999893383e+00
RINT9479 nd9479 nd10130 8.224999893383e+00
RINT9480 nd9480 nd10131 8.224999893383e+00
RINT9481 nd9481 nd10132 8.224999893383e+00
RINT9482 nd9482 nd10133 8.224999893383e+00
RINT9483 nd9483 nd10134 8.224999893383e+00
RINT9484 nd9484 nd10135 8.224999893383e+00
RINT9485 nd9485 nd10136 8.224999893383e+00
RINT9486 nd9486 nd10137 1.322170110122e+01
RINT9487 nd9487 nd10138 1.141700390059e+01
RINT9488 nd9488 nd10139 1.141700390059e+01
RINT9489 nd9489 nd10140 6.623989372047e+02
RINT9490 nd9490 nd10141 2.349813476405e+01
RINT9491 nd9491 nd10142 2.366433535758e+01
RINT9492 nd9492 nd10143 2.366433535758e+01
RINT9493 nd9493 nd10144 1.239106136042e+03
RINT9494 nd9494 nd10145 1.373695180523e+02
RINT9495 nd9495 nd10146 2.711285174478e+02
RINT9496 nd9496 nd10147 2.711285174478e+02
RINT9497 nd9497 nd10148 2.711285174478e+02
RINT9498 nd9498 nd10149 2.711285174478e+02
RINT9499 nd9499 nd10150 2.711285174478e+02
RINT9500 nd9500 nd10151 2.711285174478e+02
RINT9501 nd9501 nd10152 2.711285174478e+02
RINT9502 nd9502 nd10153 5.233124497231e+01
RINT9503 nd9503 nd10154 5.390580832121e+01
RINT9504 nd9504 nd10155 1.237294118776e+03
RINT9505 nd9505 nd10156 8.899307866519e+01
RINT9506 nd9506 nd10157 1.973999974412e+03
RINT9507 nd9507 nd10158 8.224999893383e+00
RINT9508 nd9508 nd10159 8.224999893383e+00
RINT9509 nd9509 nd10160 8.224999893383e+00
RINT9510 nd9510 nd10161 8.224999893383e+00
RINT9511 nd9511 nd10162 8.224999893383e+00
RINT9512 nd9512 nd10163 8.224999893383e+00
RINT9513 nd9513 nd10164 8.224999893383e+00
RINT9514 nd9514 nd10165 8.224999893383e+00
RINT9515 nd9515 nd10166 8.224999893383e+00
RINT9516 nd9516 nd10167 8.224999893383e+00
RINT9517 nd9517 nd10168 1.322170110122e+01
RINT9518 nd9518 nd10169 1.141700390059e+01
RINT9519 nd9519 nd10170 1.141700390059e+01
RINT9520 nd9520 nd10171 6.623989372047e+02
RINT9521 nd9521 nd10172 2.349813476405e+01
RINT9522 nd9522 nd10173 2.366433535758e+01
RINT9523 nd9523 nd10174 2.366433535758e+01
RINT9524 nd9524 nd10175 1.239106136042e+03
RINT9525 nd9525 nd10176 1.373695180523e+02
RINT9526 nd9526 nd10177 2.711285174478e+02
RINT9527 nd9527 nd10178 2.711285174478e+02
RINT9528 nd9528 nd10179 2.711285174478e+02
RINT9529 nd9529 nd10180 2.711285174478e+02
RINT9530 nd9530 nd10181 2.711285174478e+02
RINT9531 nd9531 nd10182 2.711285174478e+02
RINT9532 nd9532 nd10183 2.711285174478e+02
RINT9533 nd9533 nd10184 5.233124497231e+01
RINT9534 nd9534 nd10185 5.390580832121e+01
RINT9535 nd9535 nd10186 1.237294118776e+03
RINT9536 nd9536 nd10187 8.899307866519e+01
RINT9537 nd9537 nd10188 1.973999974412e+03
RINT9538 nd9538 nd10189 8.224999893383e+00
RINT9539 nd9539 nd10190 8.224999893383e+00
RINT9540 nd9540 nd10191 8.224999893383e+00
RINT9541 nd9541 nd10192 8.224999893383e+00
RINT9542 nd9542 nd10193 8.224999893383e+00
RINT9543 nd9543 nd10194 8.224999893383e+00
RINT9544 nd9544 nd10195 8.224999893383e+00
RINT9545 nd9545 nd10196 8.224999893383e+00
RINT9546 nd9546 nd10197 8.224999893383e+00
RINT9547 nd9547 nd10198 8.224999893383e+00
RINT9548 nd9548 nd10199 1.322170110122e+01
RINT9549 nd9549 nd10200 1.141700390059e+01
RINT9550 nd9550 nd10201 1.141700390059e+01
RINT9551 nd9551 nd10202 6.623989372047e+02
RINT9552 nd9552 nd10203 2.349813476405e+01
RINT9553 nd9553 nd10204 2.366433535758e+01
RINT9554 nd9554 nd10205 2.366433535758e+01
RINT9555 nd9555 nd10206 1.239106136042e+03
RINT9556 nd9556 nd10207 1.373695180523e+02
RINT9557 nd9557 nd10208 2.711285174478e+02
RINT9558 nd9558 nd10209 2.711285174478e+02
RINT9559 nd9559 nd10210 2.711285174478e+02
RINT9560 nd9560 nd10211 2.711285174478e+02
RINT9561 nd9561 nd10212 2.711285174478e+02
RINT9562 nd9562 nd10213 2.711285174478e+02
RINT9563 nd9563 nd10214 2.711285174478e+02
RINT9564 nd9564 nd10215 5.233124497231e+01
RINT9565 nd9565 nd10216 5.390580832121e+01
RINT9566 nd9566 nd10217 1.237294118776e+03
RINT9567 nd9567 nd10218 8.899307866519e+01
RINT9568 nd9568 nd10219 1.973999974412e+03
RINT9569 nd9569 nd10220 8.224999893383e+00
RINT9570 nd9570 nd10221 8.224999893383e+00
RINT9571 nd9571 nd10222 8.224999893383e+00
RINT9572 nd9572 nd10223 8.224999893383e+00
RINT9573 nd9573 nd10224 8.224999893383e+00
RINT9574 nd9574 nd10225 8.224999893383e+00
RINT9575 nd9575 nd10226 8.224999893383e+00
RINT9576 nd9576 nd10227 8.224999893383e+00
RINT9577 nd9577 nd10228 8.224999893383e+00
RINT9578 nd9578 nd10229 8.224999893383e+00
RINT9579 nd9579 nd10230 1.322170110122e+01
RINT9580 nd9580 nd10231 1.141700390059e+01
RINT9581 nd9581 nd10232 1.141700390059e+01
RINT9582 nd9582 nd10233 6.623989372047e+02
RINT9583 nd9583 nd10234 2.349813476405e+01
RINT9584 nd9584 nd10235 2.366433535758e+01
RINT9585 nd9585 nd10236 2.366433535758e+01
RINT9586 nd9586 nd10237 1.239106136042e+03
RINT9587 nd9587 nd10238 1.373695180523e+02
RINT9588 nd9588 nd10239 2.711285174478e+02
RINT9589 nd9589 nd10240 2.711285174478e+02
RINT9590 nd9590 nd10241 2.711285174478e+02
RINT9591 nd9591 nd10242 2.711285174478e+02
RINT9592 nd9592 nd10243 2.711285174478e+02
RINT9593 nd9593 nd10244 2.711285174478e+02
RINT9594 nd9594 nd10245 2.711285174478e+02
RINT9595 nd9595 nd10246 5.233124497231e+01
RINT9596 nd9596 nd10247 5.390580832121e+01
RINT9597 nd9597 nd10248 1.237294118776e+03
RINT9598 nd9598 nd10249 8.899307866519e+01
RINT9599 nd9599 nd10250 1.973999974412e+03
RINT9600 nd9600 nd10251 8.224999893383e+00
RINT9601 nd9601 nd10252 8.224999893383e+00
RINT9602 nd9602 nd10253 8.224999893383e+00
RINT9603 nd9603 nd10254 8.224999893383e+00
RINT9604 nd9604 nd10255 8.224999893383e+00
RINT9605 nd9605 nd10256 8.224999893383e+00
RINT9606 nd9606 nd10257 8.224999893383e+00
RINT9607 nd9607 nd10258 8.224999893383e+00
RINT9608 nd9608 nd10259 8.224999893383e+00
RINT9609 nd9609 nd10260 8.224999893383e+00
RINT9610 nd9610 nd10261 1.322170110122e+01
RINT9611 nd9611 nd10262 1.141700390059e+01
RINT9612 nd9612 nd10263 1.141700390059e+01
RINT9613 nd9613 nd10264 6.623989372047e+02
RINT9614 nd9614 nd10265 2.349813476405e+01
RINT9615 nd9615 nd10266 2.366433535758e+01
RINT9616 nd9616 nd10267 2.366433535758e+01
RINT9617 nd9617 nd10268 1.239106136042e+03
RINT9618 nd9618 nd10269 1.373695180523e+02
RINT9619 nd9619 nd10270 2.711285174478e+02
RINT9620 nd9620 nd10271 2.711285174478e+02
RINT9621 nd9621 nd10272 2.711285174478e+02
RINT9622 nd9622 nd10273 2.711285174478e+02
RINT9623 nd9623 nd10274 2.711285174478e+02
RINT9624 nd9624 nd10275 2.711285174478e+02
RINT9625 nd9625 nd10276 2.711285174478e+02
RINT9626 nd9626 nd10277 5.233124497231e+01
RINT9627 nd9627 nd10278 5.390580832121e+01
RINT9628 nd9628 nd10279 1.237294118776e+03
RINT9629 nd9629 nd10280 8.899307866519e+01
RINT9630 nd9630 nd10281 1.973999974412e+03
RINT9631 nd9631 nd10282 8.224999893383e+00
RINT9632 nd9632 nd10283 8.224999893383e+00
RINT9633 nd9633 nd10284 8.224999893383e+00
RINT9634 nd9634 nd10285 8.224999893383e+00
RINT9635 nd9635 nd10286 8.224999893383e+00
RINT9636 nd9636 nd10287 8.224999893383e+00
RINT9637 nd9637 nd10288 8.224999893383e+00
RINT9638 nd9638 nd10289 8.224999893383e+00
RINT9639 nd9639 nd10290 8.224999893383e+00
RINT9640 nd9640 nd10291 8.224999893383e+00
RINT9641 nd9641 nd10292 1.265942732753e+02
RINT9642 nd9642 nd10293 1.093147773279e+02
RINT9643 nd9643 nd10294 1.093147773279e+02
RINT9644 nd9644 nd10295 6.342293736017e+03
RINT9645 nd9645 nd10296 2.249883937783e+02
RINT9646 nd9646 nd10297 2.265797202797e+02
RINT9647 nd9647 nd10298 2.265797202797e+02
RINT9648 nd9648 nd10299 5.906414062500e+05
RINT9649 nd9649 nd10300 9.844023437500e+04
RINT9650 nd9650 nd10301 1.687546875000e+05
RINT9651 nd9651 nd10302 1.687546875000e+05
RINT9652 nd9652 nd10303 1.687546875000e+05
RINT9653 nd9653 nd10304 1.687546875000e+05
RINT9654 nd9654 nd10305 1.687546875000e+05
RINT9655 nd9655 nd10306 1.687546875000e+05
RINT9656 nd9656 nd10307 1.687546875000e+05
RINT9657 nd9657 nd10308 3.750104166667e+04
RINT9658 nd9658 nd10309 3.750104166667e+04
RINT9659 nd9659 nd10310 1.184676227326e+04
RINT9660 nd9660 nd10311 8.520850708924e+02
RINT9661 nd9661 nd10312 1.890052500000e+04
RINT9662 nd9662 nd10313 7.875218750000e+01
RINT9663 nd9663 nd10314 7.875218750000e+01
RINT9664 nd9664 nd10315 7.875218750000e+01
RINT9665 nd9665 nd10316 7.875218750000e+01
RINT9666 nd9666 nd10317 7.875218750000e+01
RINT9667 nd9667 nd10318 7.875218750000e+01
RINT9668 nd9668 nd10319 7.875218750000e+01
RINT9669 nd9669 nd10320 7.875218750000e+01
RINT9670 nd9670 nd10321 7.875218750000e+01
RINT9671 nd9671 nd10322 7.875218750000e+01
RINT9672 nd9672 nd10323 1.722097716126e+01
RINT9673 nd9673 nd10324 1.487039843942e+01
RINT9674 nd9674 nd10325 1.487039843942e+01
RINT9675 nd9675 nd10326 8.627601608838e+02
RINT9676 nd9676 nd10327 3.060580775545e+01
RINT9677 nd9677 nd10328 3.082228040171e+01
RINT9678 nd9678 nd10329 3.082228040171e+01
RINT9679 nd9679 nd10330 1.224329471512e+03
RINT9680 nd9680 nd10331 2.040549119187e+02
RINT9681 nd9681 nd10332 3.498084204321e+02
RINT9682 nd9682 nd10333 3.498084204321e+02
RINT9683 nd9683 nd10334 3.498084204321e+02
RINT9684 nd9684 nd10335 3.498084204321e+02
RINT9685 nd9685 nd10336 3.498084204321e+02
RINT9686 nd9686 nd10337 3.498084204321e+02
RINT9687 nd9687 nd10338 3.498084204321e+02
RINT9688 nd9688 nd10339 7.773520454047e+01
RINT9689 nd9689 nd10340 7.773520454047e+01
RINT9690 nd9690 nd10341 1.611548589557e+03
RINT9691 nd9691 nd10342 1.159115429604e+02
RINT9692 nd9692 nd10343 2.571091890176e+03
RINT9693 nd9693 nd10344 1.071288287573e+01
RINT9694 nd9694 nd10345 1.071288287573e+01
RINT9695 nd9695 nd10346 1.071288287573e+01
RINT9696 nd9696 nd10347 1.071288287573e+01
RINT9697 nd9697 nd10348 1.071288287573e+01
RINT9698 nd9698 nd10349 1.071288287573e+01
RINT9699 nd9699 nd10350 1.071288287573e+01
RINT9700 nd9700 nd10351 1.071288287573e+01
RINT9701 nd9701 nd10352 1.071288287573e+01
RINT9702 nd9702 nd10353 1.071288287573e+01
RINT9703 nd9703 nd10354 1.722097716126e+01
RINT9704 nd9704 nd10355 1.487039843942e+01
RINT9705 nd9705 nd10356 1.487039843942e+01
RINT9706 nd9706 nd10357 8.627601608838e+02
RINT9707 nd9707 nd10358 3.060580775545e+01
RINT9708 nd9708 nd10359 3.082228040171e+01
RINT9709 nd9709 nd10360 3.082228040171e+01
RINT9710 nd9710 nd10361 1.224329471512e+03
RINT9711 nd9711 nd10362 2.040549119187e+02
RINT9712 nd9712 nd10363 3.498084204321e+02
RINT9713 nd9713 nd10364 3.498084204321e+02
RINT9714 nd9714 nd10365 3.498084204321e+02
RINT9715 nd9715 nd10366 3.498084204321e+02
RINT9716 nd9716 nd10367 3.498084204321e+02
RINT9717 nd9717 nd10368 3.498084204321e+02
RINT9718 nd9718 nd10369 3.498084204321e+02
RINT9719 nd9719 nd10370 7.773520454047e+01
RINT9720 nd9720 nd10371 7.773520454047e+01
RINT9721 nd9721 nd10372 1.611548589557e+03
RINT9722 nd9722 nd10373 1.159115429604e+02
RINT9723 nd9723 nd10374 2.571091890176e+03
RINT9724 nd9724 nd10375 1.071288287573e+01
RINT9725 nd9725 nd10376 1.071288287573e+01
RINT9726 nd9726 nd10377 1.071288287573e+01
RINT9727 nd9727 nd10378 1.071288287573e+01
RINT9728 nd9728 nd10379 1.071288287573e+01
RINT9729 nd9729 nd10380 1.071288287573e+01
RINT9730 nd9730 nd10381 1.071288287573e+01
RINT9731 nd9731 nd10382 1.071288287573e+01
RINT9732 nd9732 nd10383 1.071288287573e+01
RINT9733 nd9733 nd10384 1.071288287573e+01
RINT9734 nd9734 nd10385 1.722097716126e+01
RINT9735 nd9735 nd10386 1.487039843942e+01
RINT9736 nd9736 nd10387 1.487039843942e+01
RINT9737 nd9737 nd10388 8.627601608838e+02
RINT9738 nd9738 nd10389 3.060580775545e+01
RINT9739 nd9739 nd10390 3.082228040171e+01
RINT9740 nd9740 nd10391 3.082228040171e+01
RINT9741 nd9741 nd10392 1.224329471512e+03
RINT9742 nd9742 nd10393 2.040549119187e+02
RINT9743 nd9743 nd10394 3.498084204321e+02
RINT9744 nd9744 nd10395 3.498084204321e+02
RINT9745 nd9745 nd10396 3.498084204321e+02
RINT9746 nd9746 nd10397 3.498084204321e+02
RINT9747 nd9747 nd10398 3.498084204321e+02
RINT9748 nd9748 nd10399 3.498084204321e+02
RINT9749 nd9749 nd10400 3.498084204321e+02
RINT9750 nd9750 nd10401 7.773520454047e+01
RINT9751 nd9751 nd10402 7.773520454047e+01
RINT9752 nd9752 nd10403 1.611548589557e+03
RINT9753 nd9753 nd10404 1.159115429604e+02
RINT9754 nd9754 nd10405 2.571091890176e+03
RINT9755 nd9755 nd10406 1.071288287573e+01
RINT9756 nd9756 nd10407 1.071288287573e+01
RINT9757 nd9757 nd10408 1.071288287573e+01
RINT9758 nd9758 nd10409 1.071288287573e+01
RINT9759 nd9759 nd10410 1.071288287573e+01
RINT9760 nd9760 nd10411 1.071288287573e+01
RINT9761 nd9761 nd10412 1.071288287573e+01
RINT9762 nd9762 nd10413 1.071288287573e+01
RINT9763 nd9763 nd10414 1.071288287573e+01
RINT9764 nd9764 nd10415 1.071288287573e+01
RINT9765 nd9765 nd10416 9.521626084020e+00
RINT9766 nd9766 nd10417 8.221970933165e+00
RINT9767 nd9767 nd10418 8.221970933165e+00
RINT9768 nd9768 nd10419 4.770274982191e+02
RINT9769 nd9769 nd10420 1.692221380459e+01
RINT9770 nd9770 nd10421 1.704190338874e+01
RINT9771 nd9771 nd10422 1.704190338874e+01
RINT9772 nd9772 nd10423 6.769422734972e+02
RINT9773 nd9773 nd10424 1.128237122495e+02
RINT9774 nd9774 nd10425 1.934120781421e+02
RINT9775 nd9775 nd10426 1.934120781421e+02
RINT9776 nd9776 nd10427 1.934120781421e+02
RINT9777 nd9777 nd10428 1.934120781421e+02
RINT9778 nd9778 nd10429 1.934120781421e+02
RINT9779 nd9779 nd10430 1.934120781421e+02
RINT9780 nd9780 nd10431 1.934120781421e+02
RINT9781 nd9781 nd10432 4.298046180935e+01
RINT9782 nd9782 nd10433 4.298046180935e+01
RINT9783 nd9783 nd10434 8.910390474536e+02
RINT9784 nd9784 nd10435 6.408848699791e+01
RINT9785 nd9785 nd10436 1.421578774344e+03
RINT9786 nd9786 nd10437 5.923244893101e+00
RINT9787 nd9787 nd10438 5.923244893101e+00
RINT9788 nd9788 nd10439 5.923244893101e+00
RINT9789 nd9789 nd10440 5.923244893101e+00
RINT9790 nd9790 nd10441 5.923244893101e+00
RINT9791 nd9791 nd10442 5.923244893101e+00
RINT9792 nd9792 nd10443 5.923244893101e+00
RINT9793 nd9793 nd10444 5.923244893101e+00
RINT9794 nd9794 nd10445 5.923244893101e+00
RINT9795 nd9795 nd10446 5.923244893101e+00
RINT9796 nd9796 nd10447 9.521626084020e+00
RINT9797 nd9797 nd10448 8.221970933165e+00
RINT9798 nd9798 nd10449 8.221970933165e+00
RINT9799 nd9799 nd10450 4.770274982191e+02
RINT9800 nd9800 nd10451 1.692221380459e+01
RINT9801 nd9801 nd10452 1.704190338874e+01
RINT9802 nd9802 nd10453 1.704190338874e+01
RINT9803 nd9803 nd10454 6.769422734972e+02
RINT9804 nd9804 nd10455 1.128237122495e+02
RINT9805 nd9805 nd10456 1.934120781421e+02
RINT9806 nd9806 nd10457 1.934120781421e+02
RINT9807 nd9807 nd10458 1.934120781421e+02
RINT9808 nd9808 nd10459 1.934120781421e+02
RINT9809 nd9809 nd10460 1.934120781421e+02
RINT9810 nd9810 nd10461 1.934120781421e+02
RINT9811 nd9811 nd10462 1.934120781421e+02
RINT9812 nd9812 nd10463 4.298046180935e+01
RINT9813 nd9813 nd10464 4.298046180935e+01
RINT9814 nd9814 nd10465 8.910390474536e+02
RINT9815 nd9815 nd10466 6.408848699791e+01
RINT9816 nd9816 nd10467 1.421578774344e+03
RINT9817 nd9817 nd10468 5.923244893101e+00
RINT9818 nd9818 nd10469 5.923244893101e+00
RINT9819 nd9819 nd10470 5.923244893101e+00
RINT9820 nd9820 nd10471 5.923244893101e+00
RINT9821 nd9821 nd10472 5.923244893101e+00
RINT9822 nd9822 nd10473 5.923244893101e+00
RINT9823 nd9823 nd10474 5.923244893101e+00
RINT9824 nd9824 nd10475 5.923244893101e+00
RINT9825 nd9825 nd10476 5.923244893101e+00
RINT9826 nd9826 nd10477 5.923244893101e+00
RINT9827 nd9827 nd10478 9.521626084020e+00
RINT9828 nd9828 nd10479 8.221970933165e+00
RINT9829 nd9829 nd10480 8.221970933165e+00
RINT9830 nd9830 nd10481 4.770274982191e+02
RINT9831 nd9831 nd10482 1.692221380459e+01
RINT9832 nd9832 nd10483 1.704190338874e+01
RINT9833 nd9833 nd10484 1.704190338874e+01
RINT9834 nd9834 nd10485 6.769422734972e+02
RINT9835 nd9835 nd10486 1.128237122495e+02
RINT9836 nd9836 nd10487 1.934120781421e+02
RINT9837 nd9837 nd10488 1.934120781421e+02
RINT9838 nd9838 nd10489 1.934120781421e+02
RINT9839 nd9839 nd10490 1.934120781421e+02
RINT9840 nd9840 nd10491 1.934120781421e+02
RINT9841 nd9841 nd10492 1.934120781421e+02
RINT9842 nd9842 nd10493 1.934120781421e+02
RINT9843 nd9843 nd10494 4.298046180935e+01
RINT9844 nd9844 nd10495 4.298046180935e+01
RINT9845 nd9845 nd10496 8.910390474536e+02
RINT9846 nd9846 nd10497 6.408848699791e+01
RINT9847 nd9847 nd10498 1.421578774344e+03
RINT9848 nd9848 nd10499 5.923244893101e+00
RINT9849 nd9849 nd10500 5.923244893101e+00
RINT9850 nd9850 nd10501 5.923244893101e+00
RINT9851 nd9851 nd10502 5.923244893101e+00
RINT9852 nd9852 nd10503 5.923244893101e+00
RINT9853 nd9853 nd10504 5.923244893101e+00
RINT9854 nd9854 nd10505 5.923244893101e+00
RINT9855 nd9855 nd10506 5.923244893101e+00
RINT9856 nd9856 nd10507 5.923244893101e+00
RINT9857 nd9857 nd10508 5.923244893101e+00
RINT9858 nd9858 nd10509 6.999506028131e+01
RINT9859 nd9859 nd10510 6.044107865818e+01
RINT9860 nd9860 nd10511 6.044107865818e+01
RINT9861 nd9861 nd10512 3.506708643992e+03
RINT9862 nd9862 nd10513 1.243980140465e+02
RINT9863 nd9863 nd10514 1.252778721279e+02
RINT9864 nd9864 nd10515 1.252778721279e+02
RINT9865 nd9865 nd10516 3.265707031250e+05
RINT9866 nd9866 nd10517 5.442845052083e+04
RINT9867 nd9867 nd10518 9.330591517857e+04
RINT9868 nd9868 nd10519 9.330591517857e+04
RINT9869 nd9869 nd10520 9.330591517857e+04
RINT9870 nd9870 nd10521 9.330591517857e+04
RINT9871 nd9871 nd10522 9.330591517857e+04
RINT9872 nd9872 nd10523 9.330591517857e+04
RINT9873 nd9873 nd10524 9.330591517857e+04
RINT9874 nd9874 nd10525 2.073464781746e+04
RINT9875 nd9875 nd10526 2.073464781746e+04
RINT9876 nd9876 nd10527 6.550176544339e+03
RINT9877 nd9877 nd10528 4.711251493362e+02
RINT9878 nd9878 nd10529 1.045026250000e+04
RINT9879 nd9879 nd10530 4.354276041667e+01
RINT9880 nd9880 nd10531 4.354276041667e+01
RINT9881 nd9881 nd10532 4.354276041667e+01
RINT9882 nd9882 nd10533 4.354276041667e+01
RINT9883 nd9883 nd10534 4.354276041667e+01
RINT9884 nd9884 nd10535 4.354276041667e+01
RINT9885 nd9885 nd10536 4.354276041667e+01
RINT9886 nd9886 nd10537 4.354276041667e+01
RINT9887 nd9887 nd10538 4.354276041667e+01
RINT9888 nd9888 nd10539 4.354276041667e+01
RINT9889 nd9889 nd10540 7.310392023728e+00
RINT9890 nd9890 nd10541 6.312559451374e+00
RINT9891 nd9891 nd10542 6.312559451374e+00
RINT9892 nd9892 nd10543 3.662460579010e+02
RINT9893 nd9893 nd10544 1.299232040087e+01
RINT9894 nd9894 nd10545 1.308421413557e+01
RINT9895 nd9895 nd10546 1.308421413557e+01
RINT9896 nd9896 nd10547 3.883351253541e+03
RINT9897 nd9897 nd10548 6.126511232794e+02
RINT9898 nd9898 nd10549 1.068078026015e+03
RINT9899 nd9899 nd10550 1.068078026015e+03
RINT9900 nd9900 nd10551 1.068078026015e+03
RINT9901 nd9901 nd10552 1.068078026015e+03
RINT9902 nd9902 nd10553 1.068078026015e+03
RINT9903 nd9903 nd10554 1.068078026015e+03
RINT9904 nd9904 nd10555 1.068078026015e+03
RINT9905 nd9905 nd10556 2.333909041065e+02
RINT9906 nd9906 nd10557 2.341781857809e+02
RINT9907 nd9907 nd10558 6.841105382479e+02
RINT9908 nd9908 nd10559 4.920503704179e+01
RINT9909 nd9909 nd10560 1.091441529143e+03
RINT9910 nd9910 nd10561 4.547673038094e+00
RINT9911 nd9911 nd10562 4.547673038094e+00
RINT9912 nd9912 nd10563 4.547673038094e+00
RINT9913 nd9913 nd10564 4.547673038094e+00
RINT9914 nd9914 nd10565 4.547673038094e+00
RINT9915 nd9915 nd10566 4.547673038094e+00
RINT9916 nd9916 nd10567 4.547673038094e+00
RINT9917 nd9917 nd10568 4.547673038094e+00
RINT9918 nd9918 nd10569 4.547673038094e+00
RINT9919 nd9919 nd10570 4.547673038094e+00
RINT9920 nd9920 nd10571 7.310392023728e+00
RINT9921 nd9921 nd10572 6.312559451374e+00
RINT9922 nd9922 nd10573 6.312559451374e+00
RINT9923 nd9923 nd10574 3.662460579010e+02
RINT9924 nd9924 nd10575 1.299232040087e+01
RINT9925 nd9925 nd10576 1.308421413557e+01
RINT9926 nd9926 nd10577 1.308421413557e+01
RINT9927 nd9927 nd10578 3.883351253541e+03
RINT9928 nd9928 nd10579 6.126511232794e+02
RINT9929 nd9929 nd10580 1.068078026015e+03
RINT9930 nd9930 nd10581 1.068078026015e+03
RINT9931 nd9931 nd10582 1.068078026015e+03
RINT9932 nd9932 nd10583 1.068078026015e+03
RINT9933 nd9933 nd10584 1.068078026015e+03
RINT9934 nd9934 nd10585 1.068078026015e+03
RINT9935 nd9935 nd10586 1.068078026015e+03
RINT9936 nd9936 nd10587 2.333909041065e+02
RINT9937 nd9937 nd10588 2.341781857809e+02
RINT9938 nd9938 nd10589 6.841105382479e+02
RINT9939 nd9939 nd10590 4.920503704179e+01
RINT9940 nd9940 nd10591 1.091441529143e+03
RINT9941 nd9941 nd10592 4.547673038094e+00
RINT9942 nd9942 nd10593 4.547673038094e+00
RINT9943 nd9943 nd10594 4.547673038094e+00
RINT9944 nd9944 nd10595 4.547673038094e+00
RINT9945 nd9945 nd10596 4.547673038094e+00
RINT9946 nd9946 nd10597 4.547673038094e+00
RINT9947 nd9947 nd10598 4.547673038094e+00
RINT9948 nd9948 nd10599 4.547673038094e+00
RINT9949 nd9949 nd10600 4.547673038094e+00
RINT9950 nd9950 nd10601 4.547673038094e+00
RINT9951 nd9951 nd10602 7.310392023728e+00
RINT9952 nd9952 nd10603 6.312559451374e+00
RINT9953 nd9953 nd10604 6.312559451374e+00
RINT9954 nd9954 nd10605 3.662460579010e+02
RINT9955 nd9955 nd10606 1.299232040087e+01
RINT9956 nd9956 nd10607 1.308421413557e+01
RINT9957 nd9957 nd10608 1.308421413557e+01
RINT9958 nd9958 nd10609 3.883351253541e+03
RINT9959 nd9959 nd10610 6.126511232794e+02
RINT9960 nd9960 nd10611 1.068078026015e+03
RINT9961 nd9961 nd10612 1.068078026015e+03
RINT9962 nd9962 nd10613 1.068078026015e+03
RINT9963 nd9963 nd10614 1.068078026015e+03
RINT9964 nd9964 nd10615 1.068078026015e+03
RINT9965 nd9965 nd10616 1.068078026015e+03
RINT9966 nd9966 nd10617 1.068078026015e+03
RINT9967 nd9967 nd10618 2.333909041065e+02
RINT9968 nd9968 nd10619 2.341781857809e+02
RINT9969 nd9969 nd10620 6.841105382479e+02
RINT9970 nd9970 nd10621 4.920503704179e+01
RINT9971 nd9971 nd10622 1.091441529143e+03
RINT9972 nd9972 nd10623 4.547673038094e+00
RINT9973 nd9973 nd10624 4.547673038094e+00
RINT9974 nd9974 nd10625 4.547673038094e+00
RINT9975 nd9975 nd10626 4.547673038094e+00
RINT9976 nd9976 nd10627 4.547673038094e+00
RINT9977 nd9977 nd10628 4.547673038094e+00
RINT9978 nd9978 nd10629 4.547673038094e+00
RINT9979 nd9979 nd10630 4.547673038094e+00
RINT9980 nd9980 nd10631 4.547673038094e+00
RINT9981 nd9981 nd10632 4.547673038094e+00
RINT9982 nd9982 nd10633 7.310392023728e+00
RINT9983 nd9983 nd10634 6.312559451374e+00
RINT9984 nd9984 nd10635 6.312559451374e+00
RINT9985 nd9985 nd10636 3.662460579010e+02
RINT9986 nd9986 nd10637 1.299232040087e+01
RINT9987 nd9987 nd10638 1.308421413557e+01
RINT9988 nd9988 nd10639 1.308421413557e+01
RINT9989 nd9989 nd10640 3.883351253541e+03
RINT9990 nd9990 nd10641 6.126511232794e+02
RINT9991 nd9991 nd10642 1.068078026015e+03
RINT9992 nd9992 nd10643 1.068078026015e+03
RINT9993 nd9993 nd10644 1.068078026015e+03
RINT9994 nd9994 nd10645 1.068078026015e+03
RINT9995 nd9995 nd10646 1.068078026015e+03
RINT9996 nd9996 nd10647 1.068078026015e+03
RINT9997 nd9997 nd10648 1.068078026015e+03
RINT9998 nd9998 nd10649 2.333909041065e+02
RINT9999 nd9999 nd10650 2.341781857809e+02
RINT10000 nd10000 nd10651 6.841105382479e+02
RINT10001 nd10001 nd10652 4.920503704179e+01
RINT10002 nd10002 nd10653 1.091441529143e+03
RINT10003 nd10003 nd10654 4.547673038094e+00
RINT10004 nd10004 nd10655 4.547673038094e+00
RINT10005 nd10005 nd10656 4.547673038094e+00
RINT10006 nd10006 nd10657 4.547673038094e+00
RINT10007 nd10007 nd10658 4.547673038094e+00
RINT10008 nd10008 nd10659 4.547673038094e+00
RINT10009 nd10009 nd10660 4.547673038094e+00
RINT10010 nd10010 nd10661 4.547673038094e+00
RINT10011 nd10011 nd10662 4.547673038094e+00
RINT10012 nd10012 nd10663 4.547673038094e+00
RINT10013 nd10013 nd10664 7.310392023728e+00
RINT10014 nd10014 nd10665 6.312559451374e+00
RINT10015 nd10015 nd10666 6.312559451374e+00
RINT10016 nd10016 nd10667 3.662460579010e+02
RINT10017 nd10017 nd10668 1.299232040087e+01
RINT10018 nd10018 nd10669 1.308421413557e+01
RINT10019 nd10019 nd10670 1.308421413557e+01
RINT10020 nd10020 nd10671 3.883351253541e+03
RINT10021 nd10021 nd10672 6.126511232794e+02
RINT10022 nd10022 nd10673 1.068078026015e+03
RINT10023 nd10023 nd10674 1.068078026015e+03
RINT10024 nd10024 nd10675 1.068078026015e+03
RINT10025 nd10025 nd10676 1.068078026015e+03
RINT10026 nd10026 nd10677 1.068078026015e+03
RINT10027 nd10027 nd10678 1.068078026015e+03
RINT10028 nd10028 nd10679 1.068078026015e+03
RINT10029 nd10029 nd10680 2.333909041065e+02
RINT10030 nd10030 nd10681 2.341781857809e+02
RINT10031 nd10031 nd10682 6.841105382479e+02
RINT10032 nd10032 nd10683 4.920503704179e+01
RINT10033 nd10033 nd10684 1.091441529143e+03
RINT10034 nd10034 nd10685 4.547673038094e+00
RINT10035 nd10035 nd10686 4.547673038094e+00
RINT10036 nd10036 nd10687 4.547673038094e+00
RINT10037 nd10037 nd10688 4.547673038094e+00
RINT10038 nd10038 nd10689 4.547673038094e+00
RINT10039 nd10039 nd10690 4.547673038094e+00
RINT10040 nd10040 nd10691 4.547673038094e+00
RINT10041 nd10041 nd10692 4.547673038094e+00
RINT10042 nd10042 nd10693 4.547673038094e+00
RINT10043 nd10043 nd10694 4.547673038094e+00
RINT10044 nd10044 nd10695 7.310392023728e+00
RINT10045 nd10045 nd10696 6.312559451374e+00
RINT10046 nd10046 nd10697 6.312559451374e+00
RINT10047 nd10047 nd10698 3.662460579010e+02
RINT10048 nd10048 nd10699 1.299232040087e+01
RINT10049 nd10049 nd10700 1.308421413557e+01
RINT10050 nd10050 nd10701 1.308421413557e+01
RINT10051 nd10051 nd10702 3.883351253541e+03
RINT10052 nd10052 nd10703 6.126511232794e+02
RINT10053 nd10053 nd10704 1.068078026015e+03
RINT10054 nd10054 nd10705 1.068078026015e+03
RINT10055 nd10055 nd10706 1.068078026015e+03
RINT10056 nd10056 nd10707 1.068078026015e+03
RINT10057 nd10057 nd10708 1.068078026015e+03
RINT10058 nd10058 nd10709 1.068078026015e+03
RINT10059 nd10059 nd10710 1.068078026015e+03
RINT10060 nd10060 nd10711 2.333909041065e+02
RINT10061 nd10061 nd10712 2.341781857809e+02
RINT10062 nd10062 nd10713 6.841105382479e+02
RINT10063 nd10063 nd10714 4.920503704179e+01
RINT10064 nd10064 nd10715 1.091441529143e+03
RINT10065 nd10065 nd10716 4.547673038094e+00
RINT10066 nd10066 nd10717 4.547673038094e+00
RINT10067 nd10067 nd10718 4.547673038094e+00
RINT10068 nd10068 nd10719 4.547673038094e+00
RINT10069 nd10069 nd10720 4.547673038094e+00
RINT10070 nd10070 nd10721 4.547673038094e+00
RINT10071 nd10071 nd10722 4.547673038094e+00
RINT10072 nd10072 nd10723 4.547673038094e+00
RINT10073 nd10073 nd10724 4.547673038094e+00
RINT10074 nd10074 nd10725 4.547673038094e+00
RINT10075 nd10075 nd10726 6.999506028131e+01
RINT10076 nd10076 nd10727 6.044107865818e+01
RINT10077 nd10077 nd10728 6.044107865818e+01
RINT10078 nd10078 nd10729 3.506708643992e+03
RINT10079 nd10079 nd10730 1.243980140465e+02
RINT10080 nd10080 nd10731 1.252778721279e+02
RINT10081 nd10081 nd10732 1.252778721279e+02
RINT10082 nd10082 nd10733 3.265707031250e+05
RINT10083 nd10083 nd10734 5.442845052083e+04
RINT10084 nd10084 nd10735 9.330591517857e+04
RINT10085 nd10085 nd10736 9.330591517857e+04
RINT10086 nd10086 nd10737 9.330591517857e+04
RINT10087 nd10087 nd10738 9.330591517857e+04
RINT10088 nd10088 nd10739 9.330591517857e+04
RINT10089 nd10089 nd10740 9.330591517857e+04
RINT10090 nd10090 nd10741 9.330591517857e+04
RINT10091 nd10091 nd10742 2.073464781746e+04
RINT10092 nd10092 nd10743 2.073464781746e+04
RINT10093 nd10093 nd10744 6.550176544339e+03
RINT10094 nd10094 nd10745 4.711251493362e+02
RINT10095 nd10095 nd10746 1.045026250000e+04
RINT10096 nd10096 nd10747 4.354276041667e+01
RINT10097 nd10097 nd10748 4.354276041667e+01
RINT10098 nd10098 nd10749 4.354276041667e+01
RINT10099 nd10099 nd10750 4.354276041667e+01
RINT10100 nd10100 nd10751 4.354276041667e+01
RINT10101 nd10101 nd10752 4.354276041667e+01
RINT10102 nd10102 nd10753 4.354276041667e+01
RINT10103 nd10103 nd10754 4.354276041667e+01
RINT10104 nd10104 nd10755 4.354276041667e+01
RINT10105 nd10105 nd10756 4.354276041667e+01
RINT10106 nd10106 nd10757 7.310392023728e+00
RINT10107 nd10107 nd10758 6.312559451374e+00
RINT10108 nd10108 nd10759 6.312559451374e+00
RINT10109 nd10109 nd10760 3.662460579010e+02
RINT10110 nd10110 nd10761 1.299232040087e+01
RINT10111 nd10111 nd10762 1.308421413557e+01
RINT10112 nd10112 nd10763 1.308421413557e+01
RINT10113 nd10113 nd10764 3.883351253541e+03
RINT10114 nd10114 nd10765 6.126511232794e+02
RINT10115 nd10115 nd10766 1.068078026015e+03
RINT10116 nd10116 nd10767 1.068078026015e+03
RINT10117 nd10117 nd10768 1.068078026015e+03
RINT10118 nd10118 nd10769 1.068078026015e+03
RINT10119 nd10119 nd10770 1.068078026015e+03
RINT10120 nd10120 nd10771 1.068078026015e+03
RINT10121 nd10121 nd10772 1.068078026015e+03
RINT10122 nd10122 nd10773 2.333909041065e+02
RINT10123 nd10123 nd10774 2.341781857809e+02
RINT10124 nd10124 nd10775 6.841105382479e+02
RINT10125 nd10125 nd10776 4.920503704179e+01
RINT10126 nd10126 nd10777 1.091441529143e+03
RINT10127 nd10127 nd10778 4.547673038094e+00
RINT10128 nd10128 nd10779 4.547673038094e+00
RINT10129 nd10129 nd10780 4.547673038094e+00
RINT10130 nd10130 nd10781 4.547673038094e+00
RINT10131 nd10131 nd10782 4.547673038094e+00
RINT10132 nd10132 nd10783 4.547673038094e+00
RINT10133 nd10133 nd10784 4.547673038094e+00
RINT10134 nd10134 nd10785 4.547673038094e+00
RINT10135 nd10135 nd10786 4.547673038094e+00
RINT10136 nd10136 nd10787 4.547673038094e+00
RINT10137 nd10137 nd10788 7.310392023728e+00
RINT10138 nd10138 nd10789 6.312559451374e+00
RINT10139 nd10139 nd10790 6.312559451374e+00
RINT10140 nd10140 nd10791 3.662460579010e+02
RINT10141 nd10141 nd10792 1.299232040087e+01
RINT10142 nd10142 nd10793 1.308421413557e+01
RINT10143 nd10143 nd10794 1.308421413557e+01
RINT10144 nd10144 nd10795 3.883351253541e+03
RINT10145 nd10145 nd10796 6.126511232794e+02
RINT10146 nd10146 nd10797 1.068078026015e+03
RINT10147 nd10147 nd10798 1.068078026015e+03
RINT10148 nd10148 nd10799 1.068078026015e+03
RINT10149 nd10149 nd10800 1.068078026015e+03
RINT10150 nd10150 nd10801 1.068078026015e+03
RINT10151 nd10151 nd10802 1.068078026015e+03
RINT10152 nd10152 nd10803 1.068078026015e+03
RINT10153 nd10153 nd10804 2.333909041065e+02
RINT10154 nd10154 nd10805 2.341781857809e+02
RINT10155 nd10155 nd10806 6.841105382479e+02
RINT10156 nd10156 nd10807 4.920503704179e+01
RINT10157 nd10157 nd10808 1.091441529143e+03
RINT10158 nd10158 nd10809 4.547673038094e+00
RINT10159 nd10159 nd10810 4.547673038094e+00
RINT10160 nd10160 nd10811 4.547673038094e+00
RINT10161 nd10161 nd10812 4.547673038094e+00
RINT10162 nd10162 nd10813 4.547673038094e+00
RINT10163 nd10163 nd10814 4.547673038094e+00
RINT10164 nd10164 nd10815 4.547673038094e+00
RINT10165 nd10165 nd10816 4.547673038094e+00
RINT10166 nd10166 nd10817 4.547673038094e+00
RINT10167 nd10167 nd10818 4.547673038094e+00
RINT10168 nd10168 nd10819 7.310392023728e+00
RINT10169 nd10169 nd10820 6.312559451374e+00
RINT10170 nd10170 nd10821 6.312559451374e+00
RINT10171 nd10171 nd10822 3.662460579010e+02
RINT10172 nd10172 nd10823 1.299232040087e+01
RINT10173 nd10173 nd10824 1.308421413557e+01
RINT10174 nd10174 nd10825 1.308421413557e+01
RINT10175 nd10175 nd10826 3.883351253541e+03
RINT10176 nd10176 nd10827 6.126511232794e+02
RINT10177 nd10177 nd10828 1.068078026015e+03
RINT10178 nd10178 nd10829 1.068078026015e+03
RINT10179 nd10179 nd10830 1.068078026015e+03
RINT10180 nd10180 nd10831 1.068078026015e+03
RINT10181 nd10181 nd10832 1.068078026015e+03
RINT10182 nd10182 nd10833 1.068078026015e+03
RINT10183 nd10183 nd10834 1.068078026015e+03
RINT10184 nd10184 nd10835 2.333909041065e+02
RINT10185 nd10185 nd10836 2.341781857809e+02
RINT10186 nd10186 nd10837 6.841105382479e+02
RINT10187 nd10187 nd10838 4.920503704179e+01
RINT10188 nd10188 nd10839 1.091441529143e+03
RINT10189 nd10189 nd10840 4.547673038094e+00
RINT10190 nd10190 nd10841 4.547673038094e+00
RINT10191 nd10191 nd10842 4.547673038094e+00
RINT10192 nd10192 nd10843 4.547673038094e+00
RINT10193 nd10193 nd10844 4.547673038094e+00
RINT10194 nd10194 nd10845 4.547673038094e+00
RINT10195 nd10195 nd10846 4.547673038094e+00
RINT10196 nd10196 nd10847 4.547673038094e+00
RINT10197 nd10197 nd10848 4.547673038094e+00
RINT10198 nd10198 nd10849 4.547673038094e+00
RINT10199 nd10199 nd10850 7.310392023728e+00
RINT10200 nd10200 nd10851 6.312559451374e+00
RINT10201 nd10201 nd10852 6.312559451374e+00
RINT10202 nd10202 nd10853 3.662460579010e+02
RINT10203 nd10203 nd10854 1.299232040087e+01
RINT10204 nd10204 nd10855 1.308421413557e+01
RINT10205 nd10205 nd10856 1.308421413557e+01
RINT10206 nd10206 nd10857 3.883351253541e+03
RINT10207 nd10207 nd10858 6.126511232794e+02
RINT10208 nd10208 nd10859 1.068078026015e+03
RINT10209 nd10209 nd10860 1.068078026015e+03
RINT10210 nd10210 nd10861 1.068078026015e+03
RINT10211 nd10211 nd10862 1.068078026015e+03
RINT10212 nd10212 nd10863 1.068078026015e+03
RINT10213 nd10213 nd10864 1.068078026015e+03
RINT10214 nd10214 nd10865 1.068078026015e+03
RINT10215 nd10215 nd10866 2.333909041065e+02
RINT10216 nd10216 nd10867 2.341781857809e+02
RINT10217 nd10217 nd10868 6.841105382479e+02
RINT10218 nd10218 nd10869 4.920503704179e+01
RINT10219 nd10219 nd10870 1.091441529143e+03
RINT10220 nd10220 nd10871 4.547673038094e+00
RINT10221 nd10221 nd10872 4.547673038094e+00
RINT10222 nd10222 nd10873 4.547673038094e+00
RINT10223 nd10223 nd10874 4.547673038094e+00
RINT10224 nd10224 nd10875 4.547673038094e+00
RINT10225 nd10225 nd10876 4.547673038094e+00
RINT10226 nd10226 nd10877 4.547673038094e+00
RINT10227 nd10227 nd10878 4.547673038094e+00
RINT10228 nd10228 nd10879 4.547673038094e+00
RINT10229 nd10229 nd10880 4.547673038094e+00
RINT10230 nd10230 nd10881 7.310392023728e+00
RINT10231 nd10231 nd10882 6.312559451374e+00
RINT10232 nd10232 nd10883 6.312559451374e+00
RINT10233 nd10233 nd10884 3.662460579010e+02
RINT10234 nd10234 nd10885 1.299232040087e+01
RINT10235 nd10235 nd10886 1.308421413557e+01
RINT10236 nd10236 nd10887 1.308421413557e+01
RINT10237 nd10237 nd10888 3.883351253541e+03
RINT10238 nd10238 nd10889 6.126511232794e+02
RINT10239 nd10239 nd10890 1.068078026015e+03
RINT10240 nd10240 nd10891 1.068078026015e+03
RINT10241 nd10241 nd10892 1.068078026015e+03
RINT10242 nd10242 nd10893 1.068078026015e+03
RINT10243 nd10243 nd10894 1.068078026015e+03
RINT10244 nd10244 nd10895 1.068078026015e+03
RINT10245 nd10245 nd10896 1.068078026015e+03
RINT10246 nd10246 nd10897 2.333909041065e+02
RINT10247 nd10247 nd10898 2.341781857809e+02
RINT10248 nd10248 nd10899 6.841105382479e+02
RINT10249 nd10249 nd10900 4.920503704179e+01
RINT10250 nd10250 nd10901 1.091441529143e+03
RINT10251 nd10251 nd10902 4.547673038094e+00
RINT10252 nd10252 nd10903 4.547673038094e+00
RINT10253 nd10253 nd10904 4.547673038094e+00
RINT10254 nd10254 nd10905 4.547673038094e+00
RINT10255 nd10255 nd10906 4.547673038094e+00
RINT10256 nd10256 nd10907 4.547673038094e+00
RINT10257 nd10257 nd10908 4.547673038094e+00
RINT10258 nd10258 nd10909 4.547673038094e+00
RINT10259 nd10259 nd10910 4.547673038094e+00
RINT10260 nd10260 nd10911 4.547673038094e+00
RINT10261 nd10261 nd10912 7.310392023728e+00
RINT10262 nd10262 nd10913 6.312559451374e+00
RINT10263 nd10263 nd10914 6.312559451374e+00
RINT10264 nd10264 nd10915 3.662460579010e+02
RINT10265 nd10265 nd10916 1.299232040087e+01
RINT10266 nd10266 nd10917 1.308421413557e+01
RINT10267 nd10267 nd10918 1.308421413557e+01
RINT10268 nd10268 nd10919 3.883351253541e+03
RINT10269 nd10269 nd10920 6.126511232794e+02
RINT10270 nd10270 nd10921 1.068078026015e+03
RINT10271 nd10271 nd10922 1.068078026015e+03
RINT10272 nd10272 nd10923 1.068078026015e+03
RINT10273 nd10273 nd10924 1.068078026015e+03
RINT10274 nd10274 nd10925 1.068078026015e+03
RINT10275 nd10275 nd10926 1.068078026015e+03
RINT10276 nd10276 nd10927 1.068078026015e+03
RINT10277 nd10277 nd10928 2.333909041065e+02
RINT10278 nd10278 nd10929 2.341781857809e+02
RINT10279 nd10279 nd10930 6.841105382479e+02
RINT10280 nd10280 nd10931 4.920503704179e+01
RINT10281 nd10281 nd10932 1.091441529143e+03
RINT10282 nd10282 nd10933 4.547673038094e+00
RINT10283 nd10283 nd10934 4.547673038094e+00
RINT10284 nd10284 nd10935 4.547673038094e+00
RINT10285 nd10285 nd10936 4.547673038094e+00
RINT10286 nd10286 nd10937 4.547673038094e+00
RINT10287 nd10287 nd10938 4.547673038094e+00
RINT10288 nd10288 nd10939 4.547673038094e+00
RINT10289 nd10289 nd10940 4.547673038094e+00
RINT10290 nd10290 nd10941 4.547673038094e+00
RINT10291 nd10291 nd10942 4.547673038094e+00
RINT10292 nd10292 nd10943 6.999506028131e+01
RINT10293 nd10293 nd10944 6.044107865818e+01
RINT10294 nd10294 nd10945 6.044107865818e+01
RINT10295 nd10295 nd10946 3.506708643992e+03
RINT10296 nd10296 nd10947 1.243980140465e+02
RINT10297 nd10297 nd10948 1.252778721279e+02
RINT10298 nd10298 nd10949 1.252778721279e+02
RINT10299 nd10299 nd10950 3.265707031250e+05
RINT10300 nd10300 nd10951 5.442845052083e+04
RINT10301 nd10301 nd10952 9.330591517857e+04
RINT10302 nd10302 nd10953 9.330591517857e+04
RINT10303 nd10303 nd10954 9.330591517857e+04
RINT10304 nd10304 nd10955 9.330591517857e+04
RINT10305 nd10305 nd10956 9.330591517857e+04
RINT10306 nd10306 nd10957 9.330591517857e+04
RINT10307 nd10307 nd10958 9.330591517857e+04
RINT10308 nd10308 nd10959 2.073464781746e+04
RINT10309 nd10309 nd10960 2.073464781746e+04
RINT10310 nd10310 nd10961 6.550176544339e+03
RINT10311 nd10311 nd10962 4.711251493362e+02
RINT10312 nd10312 nd10963 1.045026250000e+04
RINT10313 nd10313 nd10964 4.354276041667e+01
RINT10314 nd10314 nd10965 4.354276041667e+01
RINT10315 nd10315 nd10966 4.354276041667e+01
RINT10316 nd10316 nd10967 4.354276041667e+01
RINT10317 nd10317 nd10968 4.354276041667e+01
RINT10318 nd10318 nd10969 4.354276041667e+01
RINT10319 nd10319 nd10970 4.354276041667e+01
RINT10320 nd10320 nd10971 4.354276041667e+01
RINT10321 nd10321 nd10972 4.354276041667e+01
RINT10322 nd10322 nd10973 4.354276041667e+01
RINT10323 nd10323 nd10974 9.521626084020e+00
RINT10324 nd10324 nd10975 8.221970933165e+00
RINT10325 nd10325 nd10976 8.221970933165e+00
RINT10326 nd10326 nd10977 4.770274982191e+02
RINT10327 nd10327 nd10978 1.692221380459e+01
RINT10328 nd10328 nd10979 1.704190338874e+01
RINT10329 nd10329 nd10980 1.704190338874e+01
RINT10330 nd10330 nd10981 6.769422734972e+02
RINT10331 nd10331 nd10982 1.128237122495e+02
RINT10332 nd10332 nd10983 1.934120781421e+02
RINT10333 nd10333 nd10984 1.934120781421e+02
RINT10334 nd10334 nd10985 1.934120781421e+02
RINT10335 nd10335 nd10986 1.934120781421e+02
RINT10336 nd10336 nd10987 1.934120781421e+02
RINT10337 nd10337 nd10988 1.934120781421e+02
RINT10338 nd10338 nd10989 1.934120781421e+02
RINT10339 nd10339 nd10990 4.298046180935e+01
RINT10340 nd10340 nd10991 4.298046180935e+01
RINT10341 nd10341 nd10992 8.910390474536e+02
RINT10342 nd10342 nd10993 6.408848699791e+01
RINT10343 nd10343 nd10994 1.421578774344e+03
RINT10344 nd10344 nd10995 5.923244893101e+00
RINT10345 nd10345 nd10996 5.923244893101e+00
RINT10346 nd10346 nd10997 5.923244893101e+00
RINT10347 nd10347 nd10998 5.923244893101e+00
RINT10348 nd10348 nd10999 5.923244893101e+00
RINT10349 nd10349 nd11000 5.923244893101e+00
RINT10350 nd10350 nd11001 5.923244893101e+00
RINT10351 nd10351 nd11002 5.923244893101e+00
RINT10352 nd10352 nd11003 5.923244893101e+00
RINT10353 nd10353 nd11004 5.923244893101e+00
RINT10354 nd10354 nd11005 9.521626084020e+00
RINT10355 nd10355 nd11006 8.221970933165e+00
RINT10356 nd10356 nd11007 8.221970933165e+00
RINT10357 nd10357 nd11008 4.770274982191e+02
RINT10358 nd10358 nd11009 1.692221380459e+01
RINT10359 nd10359 nd11010 1.704190338874e+01
RINT10360 nd10360 nd11011 1.704190338874e+01
RINT10361 nd10361 nd11012 6.769422734972e+02
RINT10362 nd10362 nd11013 1.128237122495e+02
RINT10363 nd10363 nd11014 1.934120781421e+02
RINT10364 nd10364 nd11015 1.934120781421e+02
RINT10365 nd10365 nd11016 1.934120781421e+02
RINT10366 nd10366 nd11017 1.934120781421e+02
RINT10367 nd10367 nd11018 1.934120781421e+02
RINT10368 nd10368 nd11019 1.934120781421e+02
RINT10369 nd10369 nd11020 1.934120781421e+02
RINT10370 nd10370 nd11021 4.298046180935e+01
RINT10371 nd10371 nd11022 4.298046180935e+01
RINT10372 nd10372 nd11023 8.910390474536e+02
RINT10373 nd10373 nd11024 6.408848699791e+01
RINT10374 nd10374 nd11025 1.421578774344e+03
RINT10375 nd10375 nd11026 5.923244893101e+00
RINT10376 nd10376 nd11027 5.923244893101e+00
RINT10377 nd10377 nd11028 5.923244893101e+00
RINT10378 nd10378 nd11029 5.923244893101e+00
RINT10379 nd10379 nd11030 5.923244893101e+00
RINT10380 nd10380 nd11031 5.923244893101e+00
RINT10381 nd10381 nd11032 5.923244893101e+00
RINT10382 nd10382 nd11033 5.923244893101e+00
RINT10383 nd10383 nd11034 5.923244893101e+00
RINT10384 nd10384 nd11035 5.923244893101e+00
RINT10385 nd10385 nd11036 9.521626084020e+00
RINT10386 nd10386 nd11037 8.221970933165e+00
RINT10387 nd10387 nd11038 8.221970933165e+00
RINT10388 nd10388 nd11039 4.770274982191e+02
RINT10389 nd10389 nd11040 1.692221380459e+01
RINT10390 nd10390 nd11041 1.704190338874e+01
RINT10391 nd10391 nd11042 1.704190338874e+01
RINT10392 nd10392 nd11043 6.769422734972e+02
RINT10393 nd10393 nd11044 1.128237122495e+02
RINT10394 nd10394 nd11045 1.934120781421e+02
RINT10395 nd10395 nd11046 1.934120781421e+02
RINT10396 nd10396 nd11047 1.934120781421e+02
RINT10397 nd10397 nd11048 1.934120781421e+02
RINT10398 nd10398 nd11049 1.934120781421e+02
RINT10399 nd10399 nd11050 1.934120781421e+02
RINT10400 nd10400 nd11051 1.934120781421e+02
RINT10401 nd10401 nd11052 4.298046180935e+01
RINT10402 nd10402 nd11053 4.298046180935e+01
RINT10403 nd10403 nd11054 8.910390474536e+02
RINT10404 nd10404 nd11055 6.408848699791e+01
RINT10405 nd10405 nd11056 1.421578774344e+03
RINT10406 nd10406 nd11057 5.923244893101e+00
RINT10407 nd10407 nd11058 5.923244893101e+00
RINT10408 nd10408 nd11059 5.923244893101e+00
RINT10409 nd10409 nd11060 5.923244893101e+00
RINT10410 nd10410 nd11061 5.923244893101e+00
RINT10411 nd10411 nd11062 5.923244893101e+00
RINT10412 nd10412 nd11063 5.923244893101e+00
RINT10413 nd10413 nd11064 5.923244893101e+00
RINT10414 nd10414 nd11065 5.923244893101e+00
RINT10415 nd10415 nd11066 5.923244893101e+00
RINT10416 nd10416 nd11067 5.509580147687e+00
RINT10417 nd10417 nd11068 4.757549543375e+00
RINT10418 nd10418 nd11069 4.757549543375e+00
RINT10419 nd10419 nd11070 2.760265117425e+02
RINT10420 nd10420 nd11071 9.791845679505e+00
RINT10421 nd10421 nd11072 9.861102689905e+00
RINT10422 nd10422 nd11073 9.861102689905e+00
RINT10423 nd10423 nd11074 3.917049124046e+02
RINT10424 nd10424 nd11075 6.528415206743e+01
RINT10425 nd10425 nd11076 1.119156892585e+02
RINT10426 nd10426 nd11077 1.119156892584e+02
RINT10427 nd10427 nd11078 1.119156892585e+02
RINT10428 nd10428 nd11079 1.119156892584e+02
RINT10429 nd10429 nd11080 1.119156892585e+02
RINT10430 nd10430 nd11081 1.119156892585e+02
RINT10431 nd10431 nd11082 1.119156892584e+02
RINT10432 nd10432 nd11083 2.487015316854e+01
RINT10433 nd10433 nd11084 2.487015316854e+01
RINT10434 nd10434 nd11085 5.155895645706e+02
RINT10435 nd10435 nd11086 3.708407078194e+01
RINT10436 nd10436 nd11087 8.225803160496e+02
RINT10437 nd10437 nd11088 3.427417983540e+00
RINT10438 nd10438 nd11089 3.427417983540e+00
RINT10439 nd10439 nd11090 3.427417983540e+00
RINT10440 nd10440 nd11091 3.427417983540e+00
RINT10441 nd10441 nd11092 3.427417983540e+00
RINT10442 nd10442 nd11093 3.427417983540e+00
RINT10443 nd10443 nd11094 3.427417983540e+00
RINT10444 nd10444 nd11095 3.427417983540e+00
RINT10445 nd10445 nd11096 3.427417983540e+00
RINT10446 nd10446 nd11097 3.427417983540e+00
RINT10447 nd10447 nd11098 5.509580147687e+00
RINT10448 nd10448 nd11099 4.757549543375e+00
RINT10449 nd10449 nd11100 4.757549543375e+00
RINT10450 nd10450 nd11101 2.760265117425e+02
RINT10451 nd10451 nd11102 9.791845679505e+00
RINT10452 nd10452 nd11103 9.861102689905e+00
RINT10453 nd10453 nd11104 9.861102689905e+00
RINT10454 nd10454 nd11105 3.917049124046e+02
RINT10455 nd10455 nd11106 6.528415206743e+01
RINT10456 nd10456 nd11107 1.119156892585e+02
RINT10457 nd10457 nd11108 1.119156892584e+02
RINT10458 nd10458 nd11109 1.119156892585e+02
RINT10459 nd10459 nd11110 1.119156892584e+02
RINT10460 nd10460 nd11111 1.119156892585e+02
RINT10461 nd10461 nd11112 1.119156892585e+02
RINT10462 nd10462 nd11113 1.119156892584e+02
RINT10463 nd10463 nd11114 2.487015316854e+01
RINT10464 nd10464 nd11115 2.487015316854e+01
RINT10465 nd10465 nd11116 5.155895645706e+02
RINT10466 nd10466 nd11117 3.708407078194e+01
RINT10467 nd10467 nd11118 8.225803160496e+02
RINT10468 nd10468 nd11119 3.427417983540e+00
RINT10469 nd10469 nd11120 3.427417983540e+00
RINT10470 nd10470 nd11121 3.427417983540e+00
RINT10471 nd10471 nd11122 3.427417983540e+00
RINT10472 nd10472 nd11123 3.427417983540e+00
RINT10473 nd10473 nd11124 3.427417983540e+00
RINT10474 nd10474 nd11125 3.427417983540e+00
RINT10475 nd10475 nd11126 3.427417983540e+00
RINT10476 nd10476 nd11127 3.427417983540e+00
RINT10477 nd10477 nd11128 3.427417983540e+00
RINT10478 nd10478 nd11129 5.509580147687e+00
RINT10479 nd10479 nd11130 4.757549543375e+00
RINT10480 nd10480 nd11131 4.757549543375e+00
RINT10481 nd10481 nd11132 2.760265117425e+02
RINT10482 nd10482 nd11133 9.791845679505e+00
RINT10483 nd10483 nd11134 9.861102689905e+00
RINT10484 nd10484 nd11135 9.861102689905e+00
RINT10485 nd10485 nd11136 3.917049124046e+02
RINT10486 nd10486 nd11137 6.528415206743e+01
RINT10487 nd10487 nd11138 1.119156892585e+02
RINT10488 nd10488 nd11139 1.119156892584e+02
RINT10489 nd10489 nd11140 1.119156892585e+02
RINT10490 nd10490 nd11141 1.119156892584e+02
RINT10491 nd10491 nd11142 1.119156892585e+02
RINT10492 nd10492 nd11143 1.119156892585e+02
RINT10493 nd10493 nd11144 1.119156892584e+02
RINT10494 nd10494 nd11145 2.487015316854e+01
RINT10495 nd10495 nd11146 2.487015316854e+01
RINT10496 nd10496 nd11147 5.155895645706e+02
RINT10497 nd10497 nd11148 3.708407078194e+01
RINT10498 nd10498 nd11149 8.225803160496e+02
RINT10499 nd10499 nd11150 3.427417983540e+00
RINT10500 nd10500 nd11151 3.427417983540e+00
RINT10501 nd10501 nd11152 3.427417983540e+00
RINT10502 nd10502 nd11153 3.427417983540e+00
RINT10503 nd10503 nd11154 3.427417983540e+00
RINT10504 nd10504 nd11155 3.427417983540e+00
RINT10505 nd10505 nd11156 3.427417983540e+00
RINT10506 nd10506 nd11157 3.427417983540e+00
RINT10507 nd10507 nd11158 3.427417983540e+00
RINT10508 nd10508 nd11159 3.427417983540e+00
RINT10509 nd10509 nd11160 4.050184192900e+01
RINT10510 nd10510 nd11161 3.497353961828e+01
RINT10511 nd10511 nd11162 3.497353961828e+01
RINT10512 nd10512 nd11163 2.029116892238e+03
RINT10513 nd10513 nd11164 7.198148956432e+01
RINT10514 nd10514 nd11165 7.249060939061e+01
RINT10515 nd10515 nd11166 7.249060939061e+01
RINT10516 nd10516 nd11167 3.365329761905e+04
RINT10517 nd10517 nd11168 5.608882936508e+03
RINT10518 nd10518 nd11169 9.615227891156e+03
RINT10519 nd10519 nd11170 9.615227891156e+03
RINT10520 nd10520 nd11171 9.615227891156e+03
RINT10521 nd10521 nd11172 9.615227891156e+03
RINT10522 nd10522 nd11173 9.615227891156e+03
RINT10523 nd10523 nd11174 9.615227891156e+03
RINT10524 nd10524 nd11175 9.615227891156e+03
RINT10525 nd10525 nd11176 2.136717309146e+03
RINT10526 nd10526 nd11177 2.136717309146e+03
RINT10527 nd10527 nd11178 3.790184820752e+03
RINT10528 nd10528 nd11179 2.726111849965e+02
RINT10529 nd10529 nd11180 6.046925000000e+03
RINT10530 nd10530 nd11181 2.519552083333e+01
RINT10531 nd10531 nd11182 2.519552083333e+01
RINT10532 nd10532 nd11183 2.519552083333e+01
RINT10533 nd10533 nd11184 2.519552083333e+01
RINT10534 nd10534 nd11185 2.519552083333e+01
RINT10535 nd10535 nd11186 2.519552083333e+01
RINT10536 nd10536 nd11187 2.519552083333e+01
RINT10537 nd10537 nd11188 2.519552083333e+01
RINT10538 nd10538 nd11189 2.519552083333e+01
RINT10539 nd10539 nd11190 2.519552083333e+01
RINT10540 nd10540 nd11191 4.230074822339e+00
RINT10541 nd10541 nd11192 3.652690404715e+00
RINT10542 nd10542 nd11193 3.652690404715e+00
RINT10543 nd10543 nd11194 2.119240969950e+02
RINT10544 nd10544 nd11195 7.517857760993e+00
RINT10545 nd10545 nd11196 7.571031020681e+00
RINT10546 nd10546 nd11197 7.571031020681e+00
RINT10547 nd10547 nd11198 3.514802294586e+03
RINT10548 nd10548 nd11199 5.858003824309e+02
RINT10549 nd10549 nd11200 1.004229227024e+03
RINT10550 nd10550 nd11201 1.004229227024e+03
RINT10551 nd10551 nd11202 1.004229227024e+03
RINT10552 nd10552 nd11203 1.004229227024e+03
RINT10553 nd10553 nd11204 1.004229227024e+03
RINT10554 nd10554 nd11205 1.004229227024e+03
RINT10555 nd10555 nd11206 1.004229227024e+03
RINT10556 nd10556 nd11207 2.231620504499e+02
RINT10557 nd10557 nd11208 2.231620504499e+02
RINT10558 nd10558 nd11209 3.958527469042e+02
RINT10559 nd10559 nd11210 2.847193251021e+01
RINT10560 nd10560 nd11211 6.315501709752e+02
RINT10561 nd10561 nd11212 2.631459045730e+00
RINT10562 nd10562 nd11213 2.631459045730e+00
RINT10563 nd10563 nd11214 2.631459045730e+00
RINT10564 nd10564 nd11215 2.631459045730e+00
RINT10565 nd10565 nd11216 2.631459045730e+00
RINT10566 nd10566 nd11217 2.631459045730e+00
RINT10567 nd10567 nd11218 2.631459045730e+00
RINT10568 nd10568 nd11219 2.631459045730e+00
RINT10569 nd10569 nd11220 2.631459045730e+00
RINT10570 nd10570 nd11221 2.631459045730e+00
RINT10571 nd10571 nd11222 4.230074822339e+00
RINT10572 nd10572 nd11223 3.652690404715e+00
RINT10573 nd10573 nd11224 3.652690404715e+00
RINT10574 nd10574 nd11225 2.119240969950e+02
RINT10575 nd10575 nd11226 7.517857760993e+00
RINT10576 nd10576 nd11227 7.571031020681e+00
RINT10577 nd10577 nd11228 7.571031020681e+00
RINT10578 nd10578 nd11229 3.514802294586e+03
RINT10579 nd10579 nd11230 5.858003824309e+02
RINT10580 nd10580 nd11231 1.004229227024e+03
RINT10581 nd10581 nd11232 1.004229227024e+03
RINT10582 nd10582 nd11233 1.004229227024e+03
RINT10583 nd10583 nd11234 1.004229227024e+03
RINT10584 nd10584 nd11235 1.004229227024e+03
RINT10585 nd10585 nd11236 1.004229227024e+03
RINT10586 nd10586 nd11237 1.004229227024e+03
RINT10587 nd10587 nd11238 2.231620504499e+02
RINT10588 nd10588 nd11239 2.231620504499e+02
RINT10589 nd10589 nd11240 3.958527469042e+02
RINT10590 nd10590 nd11241 2.847193251021e+01
RINT10591 nd10591 nd11242 6.315501709752e+02
RINT10592 nd10592 nd11243 2.631459045730e+00
RINT10593 nd10593 nd11244 2.631459045730e+00
RINT10594 nd10594 nd11245 2.631459045730e+00
RINT10595 nd10595 nd11246 2.631459045730e+00
RINT10596 nd10596 nd11247 2.631459045730e+00
RINT10597 nd10597 nd11248 2.631459045730e+00
RINT10598 nd10598 nd11249 2.631459045730e+00
RINT10599 nd10599 nd11250 2.631459045730e+00
RINT10600 nd10600 nd11251 2.631459045730e+00
RINT10601 nd10601 nd11252 2.631459045730e+00
RINT10602 nd10602 nd11253 4.230074822339e+00
RINT10603 nd10603 nd11254 3.652690404715e+00
RINT10604 nd10604 nd11255 3.652690404715e+00
RINT10605 nd10605 nd11256 2.119240969950e+02
RINT10606 nd10606 nd11257 7.517857760993e+00
RINT10607 nd10607 nd11258 7.571031020681e+00
RINT10608 nd10608 nd11259 7.571031020681e+00
RINT10609 nd10609 nd11260 3.514802294586e+03
RINT10610 nd10610 nd11261 5.858003824309e+02
RINT10611 nd10611 nd11262 1.004229227024e+03
RINT10612 nd10612 nd11263 1.004229227024e+03
RINT10613 nd10613 nd11264 1.004229227024e+03
RINT10614 nd10614 nd11265 1.004229227024e+03
RINT10615 nd10615 nd11266 1.004229227024e+03
RINT10616 nd10616 nd11267 1.004229227024e+03
RINT10617 nd10617 nd11268 1.004229227024e+03
RINT10618 nd10618 nd11269 2.231620504499e+02
RINT10619 nd10619 nd11270 2.231620504499e+02
RINT10620 nd10620 nd11271 3.958527469042e+02
RINT10621 nd10621 nd11272 2.847193251021e+01
RINT10622 nd10622 nd11273 6.315501709752e+02
RINT10623 nd10623 nd11274 2.631459045730e+00
RINT10624 nd10624 nd11275 2.631459045730e+00
RINT10625 nd10625 nd11276 2.631459045730e+00
RINT10626 nd10626 nd11277 2.631459045730e+00
RINT10627 nd10627 nd11278 2.631459045730e+00
RINT10628 nd10628 nd11279 2.631459045730e+00
RINT10629 nd10629 nd11280 2.631459045730e+00
RINT10630 nd10630 nd11281 2.631459045730e+00
RINT10631 nd10631 nd11282 2.631459045730e+00
RINT10632 nd10632 nd11283 2.631459045730e+00
RINT10633 nd10633 nd11284 4.230074822339e+00
RINT10634 nd10634 nd11285 3.652690404715e+00
RINT10635 nd10635 nd11286 3.652690404715e+00
RINT10636 nd10636 nd11287 2.119240969950e+02
RINT10637 nd10637 nd11288 7.517857760993e+00
RINT10638 nd10638 nd11289 7.571031020681e+00
RINT10639 nd10639 nd11290 7.571031020681e+00
RINT10640 nd10640 nd11291 3.514802294586e+03
RINT10641 nd10641 nd11292 5.858003824309e+02
RINT10642 nd10642 nd11293 1.004229227024e+03
RINT10643 nd10643 nd11294 1.004229227024e+03
RINT10644 nd10644 nd11295 1.004229227024e+03
RINT10645 nd10645 nd11296 1.004229227024e+03
RINT10646 nd10646 nd11297 1.004229227024e+03
RINT10647 nd10647 nd11298 1.004229227024e+03
RINT10648 nd10648 nd11299 1.004229227024e+03
RINT10649 nd10649 nd11300 2.231620504499e+02
RINT10650 nd10650 nd11301 2.231620504499e+02
RINT10651 nd10651 nd11302 3.958527469042e+02
RINT10652 nd10652 nd11303 2.847193251021e+01
RINT10653 nd10653 nd11304 6.315501709752e+02
RINT10654 nd10654 nd11305 2.631459045730e+00
RINT10655 nd10655 nd11306 2.631459045730e+00
RINT10656 nd10656 nd11307 2.631459045730e+00
RINT10657 nd10657 nd11308 2.631459045730e+00
RINT10658 nd10658 nd11309 2.631459045730e+00
RINT10659 nd10659 nd11310 2.631459045730e+00
RINT10660 nd10660 nd11311 2.631459045730e+00
RINT10661 nd10661 nd11312 2.631459045730e+00
RINT10662 nd10662 nd11313 2.631459045730e+00
RINT10663 nd10663 nd11314 2.631459045730e+00
RINT10664 nd10664 nd11315 4.230074822339e+00
RINT10665 nd10665 nd11316 3.652690404715e+00
RINT10666 nd10666 nd11317 3.652690404715e+00
RINT10667 nd10667 nd11318 2.119240969950e+02
RINT10668 nd10668 nd11319 7.517857760993e+00
RINT10669 nd10669 nd11320 7.571031020681e+00
RINT10670 nd10670 nd11321 7.571031020681e+00
RINT10671 nd10671 nd11322 3.514802294586e+03
RINT10672 nd10672 nd11323 5.858003824309e+02
RINT10673 nd10673 nd11324 1.004229227024e+03
RINT10674 nd10674 nd11325 1.004229227024e+03
RINT10675 nd10675 nd11326 1.004229227024e+03
RINT10676 nd10676 nd11327 1.004229227024e+03
RINT10677 nd10677 nd11328 1.004229227024e+03
RINT10678 nd10678 nd11329 1.004229227024e+03
RINT10679 nd10679 nd11330 1.004229227024e+03
RINT10680 nd10680 nd11331 2.231620504499e+02
RINT10681 nd10681 nd11332 2.231620504499e+02
RINT10682 nd10682 nd11333 3.958527469042e+02
RINT10683 nd10683 nd11334 2.847193251021e+01
RINT10684 nd10684 nd11335 6.315501709752e+02
RINT10685 nd10685 nd11336 2.631459045730e+00
RINT10686 nd10686 nd11337 2.631459045730e+00
RINT10687 nd10687 nd11338 2.631459045730e+00
RINT10688 nd10688 nd11339 2.631459045730e+00
RINT10689 nd10689 nd11340 2.631459045730e+00
RINT10690 nd10690 nd11341 2.631459045730e+00
RINT10691 nd10691 nd11342 2.631459045730e+00
RINT10692 nd10692 nd11343 2.631459045730e+00
RINT10693 nd10693 nd11344 2.631459045730e+00
RINT10694 nd10694 nd11345 2.631459045730e+00
RINT10695 nd10695 nd11346 4.230074822339e+00
RINT10696 nd10696 nd11347 3.652690404715e+00
RINT10697 nd10697 nd11348 3.652690404715e+00
RINT10698 nd10698 nd11349 2.119240969950e+02
RINT10699 nd10699 nd11350 7.517857760993e+00
RINT10700 nd10700 nd11351 7.571031020681e+00
RINT10701 nd10701 nd11352 7.571031020681e+00
RINT10702 nd10702 nd11353 3.514802294586e+03
RINT10703 nd10703 nd11354 5.858003824309e+02
RINT10704 nd10704 nd11355 1.004229227024e+03
RINT10705 nd10705 nd11356 1.004229227024e+03
RINT10706 nd10706 nd11357 1.004229227024e+03
RINT10707 nd10707 nd11358 1.004229227024e+03
RINT10708 nd10708 nd11359 1.004229227024e+03
RINT10709 nd10709 nd11360 1.004229227024e+03
RINT10710 nd10710 nd11361 1.004229227024e+03
RINT10711 nd10711 nd11362 2.231620504499e+02
RINT10712 nd10712 nd11363 2.231620504499e+02
RINT10713 nd10713 nd11364 3.958527469042e+02
RINT10714 nd10714 nd11365 2.847193251021e+01
RINT10715 nd10715 nd11366 6.315501709752e+02
RINT10716 nd10716 nd11367 2.631459045730e+00
RINT10717 nd10717 nd11368 2.631459045730e+00
RINT10718 nd10718 nd11369 2.631459045730e+00
RINT10719 nd10719 nd11370 2.631459045730e+00
RINT10720 nd10720 nd11371 2.631459045730e+00
RINT10721 nd10721 nd11372 2.631459045730e+00
RINT10722 nd10722 nd11373 2.631459045730e+00
RINT10723 nd10723 nd11374 2.631459045730e+00
RINT10724 nd10724 nd11375 2.631459045730e+00
RINT10725 nd10725 nd11376 2.631459045730e+00
RINT10726 nd10726 nd11377 4.050184192900e+01
RINT10727 nd10727 nd11378 3.497353961828e+01
RINT10728 nd10728 nd11379 3.497353961828e+01
RINT10729 nd10729 nd11380 2.029116892238e+03
RINT10730 nd10730 nd11381 7.198148956432e+01
RINT10731 nd10731 nd11382 7.249060939061e+01
RINT10732 nd10732 nd11383 7.249060939061e+01
RINT10733 nd10733 nd11384 3.365329761905e+04
RINT10734 nd10734 nd11385 5.608882936508e+03
RINT10735 nd10735 nd11386 9.615227891156e+03
RINT10736 nd10736 nd11387 9.615227891156e+03
RINT10737 nd10737 nd11388 9.615227891156e+03
RINT10738 nd10738 nd11389 9.615227891156e+03
RINT10739 nd10739 nd11390 9.615227891156e+03
RINT10740 nd10740 nd11391 9.615227891156e+03
RINT10741 nd10741 nd11392 9.615227891156e+03
RINT10742 nd10742 nd11393 2.136717309146e+03
RINT10743 nd10743 nd11394 2.136717309146e+03
RINT10744 nd10744 nd11395 3.790184820752e+03
RINT10745 nd10745 nd11396 2.726111849965e+02
RINT10746 nd10746 nd11397 6.046925000000e+03
RINT10747 nd10747 nd11398 2.519552083333e+01
RINT10748 nd10748 nd11399 2.519552083333e+01
RINT10749 nd10749 nd11400 2.519552083333e+01
RINT10750 nd10750 nd11401 2.519552083333e+01
RINT10751 nd10751 nd11402 2.519552083333e+01
RINT10752 nd10752 nd11403 2.519552083333e+01
RINT10753 nd10753 nd11404 2.519552083333e+01
RINT10754 nd10754 nd11405 2.519552083333e+01
RINT10755 nd10755 nd11406 2.519552083333e+01
RINT10756 nd10756 nd11407 2.519552083333e+01
RINT10757 nd10757 nd11408 4.230074822339e+00
RINT10758 nd10758 nd11409 3.652690404715e+00
RINT10759 nd10759 nd11410 3.652690404715e+00
RINT10760 nd10760 nd11411 2.119240969950e+02
RINT10761 nd10761 nd11412 7.517857760993e+00
RINT10762 nd10762 nd11413 7.571031020681e+00
RINT10763 nd10763 nd11414 7.571031020681e+00
RINT10764 nd10764 nd11415 3.514802294586e+03
RINT10765 nd10765 nd11416 5.858003824309e+02
RINT10766 nd10766 nd11417 1.004229227024e+03
RINT10767 nd10767 nd11418 1.004229227024e+03
RINT10768 nd10768 nd11419 1.004229227024e+03
RINT10769 nd10769 nd11420 1.004229227024e+03
RINT10770 nd10770 nd11421 1.004229227024e+03
RINT10771 nd10771 nd11422 1.004229227024e+03
RINT10772 nd10772 nd11423 1.004229227024e+03
RINT10773 nd10773 nd11424 2.231620504499e+02
RINT10774 nd10774 nd11425 2.231620504499e+02
RINT10775 nd10775 nd11426 3.958527469042e+02
RINT10776 nd10776 nd11427 2.847193251021e+01
RINT10777 nd10777 nd11428 6.315501709752e+02
RINT10778 nd10778 nd11429 2.631459045730e+00
RINT10779 nd10779 nd11430 2.631459045730e+00
RINT10780 nd10780 nd11431 2.631459045730e+00
RINT10781 nd10781 nd11432 2.631459045730e+00
RINT10782 nd10782 nd11433 2.631459045730e+00
RINT10783 nd10783 nd11434 2.631459045730e+00
RINT10784 nd10784 nd11435 2.631459045730e+00
RINT10785 nd10785 nd11436 2.631459045730e+00
RINT10786 nd10786 nd11437 2.631459045730e+00
RINT10787 nd10787 nd11438 2.631459045730e+00
RINT10788 nd10788 nd11439 4.230074822339e+00
RINT10789 nd10789 nd11440 3.652690404715e+00
RINT10790 nd10790 nd11441 3.652690404715e+00
RINT10791 nd10791 nd11442 2.119240969950e+02
RINT10792 nd10792 nd11443 7.517857760993e+00
RINT10793 nd10793 nd11444 7.571031020681e+00
RINT10794 nd10794 nd11445 7.571031020681e+00
RINT10795 nd10795 nd11446 3.514802294586e+03
RINT10796 nd10796 nd11447 5.858003824309e+02
RINT10797 nd10797 nd11448 1.004229227024e+03
RINT10798 nd10798 nd11449 1.004229227024e+03
RINT10799 nd10799 nd11450 1.004229227024e+03
RINT10800 nd10800 nd11451 1.004229227024e+03
RINT10801 nd10801 nd11452 1.004229227024e+03
RINT10802 nd10802 nd11453 1.004229227024e+03
RINT10803 nd10803 nd11454 1.004229227024e+03
RINT10804 nd10804 nd11455 2.231620504499e+02
RINT10805 nd10805 nd11456 2.231620504499e+02
RINT10806 nd10806 nd11457 3.958527469042e+02
RINT10807 nd10807 nd11458 2.847193251021e+01
RINT10808 nd10808 nd11459 6.315501709752e+02
RINT10809 nd10809 nd11460 2.631459045730e+00
RINT10810 nd10810 nd11461 2.631459045730e+00
RINT10811 nd10811 nd11462 2.631459045730e+00
RINT10812 nd10812 nd11463 2.631459045730e+00
RINT10813 nd10813 nd11464 2.631459045730e+00
RINT10814 nd10814 nd11465 2.631459045730e+00
RINT10815 nd10815 nd11466 2.631459045730e+00
RINT10816 nd10816 nd11467 2.631459045730e+00
RINT10817 nd10817 nd11468 2.631459045730e+00
RINT10818 nd10818 nd11469 2.631459045730e+00
RINT10819 nd10819 nd11470 4.230074822339e+00
RINT10820 nd10820 nd11471 3.652690404715e+00
RINT10821 nd10821 nd11472 3.652690404715e+00
RINT10822 nd10822 nd11473 2.119240969950e+02
RINT10823 nd10823 nd11474 7.517857760993e+00
RINT10824 nd10824 nd11475 7.571031020681e+00
RINT10825 nd10825 nd11476 7.571031020681e+00
RINT10826 nd10826 nd11477 3.514802294586e+03
RINT10827 nd10827 nd11478 5.858003824309e+02
RINT10828 nd10828 nd11479 1.004229227024e+03
RINT10829 nd10829 nd11480 1.004229227024e+03
RINT10830 nd10830 nd11481 1.004229227024e+03
RINT10831 nd10831 nd11482 1.004229227024e+03
RINT10832 nd10832 nd11483 1.004229227024e+03
RINT10833 nd10833 nd11484 1.004229227024e+03
RINT10834 nd10834 nd11485 1.004229227024e+03
RINT10835 nd10835 nd11486 2.231620504499e+02
RINT10836 nd10836 nd11487 2.231620504499e+02
RINT10837 nd10837 nd11488 3.958527469042e+02
RINT10838 nd10838 nd11489 2.847193251021e+01
RINT10839 nd10839 nd11490 6.315501709752e+02
RINT10840 nd10840 nd11491 2.631459045730e+00
RINT10841 nd10841 nd11492 2.631459045730e+00
RINT10842 nd10842 nd11493 2.631459045730e+00
RINT10843 nd10843 nd11494 2.631459045730e+00
RINT10844 nd10844 nd11495 2.631459045730e+00
RINT10845 nd10845 nd11496 2.631459045730e+00
RINT10846 nd10846 nd11497 2.631459045730e+00
RINT10847 nd10847 nd11498 2.631459045730e+00
RINT10848 nd10848 nd11499 2.631459045730e+00
RINT10849 nd10849 nd11500 2.631459045730e+00
RINT10850 nd10850 nd11501 4.230074822339e+00
RINT10851 nd10851 nd11502 3.652690404715e+00
RINT10852 nd10852 nd11503 3.652690404715e+00
RINT10853 nd10853 nd11504 2.119240969950e+02
RINT10854 nd10854 nd11505 7.517857760993e+00
RINT10855 nd10855 nd11506 7.571031020681e+00
RINT10856 nd10856 nd11507 7.571031020681e+00
RINT10857 nd10857 nd11508 3.514802294586e+03
RINT10858 nd10858 nd11509 5.858003824309e+02
RINT10859 nd10859 nd11510 1.004229227024e+03
RINT10860 nd10860 nd11511 1.004229227024e+03
RINT10861 nd10861 nd11512 1.004229227024e+03
RINT10862 nd10862 nd11513 1.004229227024e+03
RINT10863 nd10863 nd11514 1.004229227024e+03
RINT10864 nd10864 nd11515 1.004229227024e+03
RINT10865 nd10865 nd11516 1.004229227024e+03
RINT10866 nd10866 nd11517 2.231620504499e+02
RINT10867 nd10867 nd11518 2.231620504499e+02
RINT10868 nd10868 nd11519 3.958527469042e+02
RINT10869 nd10869 nd11520 2.847193251021e+01
RINT10870 nd10870 nd11521 6.315501709752e+02
RINT10871 nd10871 nd11522 2.631459045730e+00
RINT10872 nd10872 nd11523 2.631459045730e+00
RINT10873 nd10873 nd11524 2.631459045730e+00
RINT10874 nd10874 nd11525 2.631459045730e+00
RINT10875 nd10875 nd11526 2.631459045730e+00
RINT10876 nd10876 nd11527 2.631459045730e+00
RINT10877 nd10877 nd11528 2.631459045730e+00
RINT10878 nd10878 nd11529 2.631459045730e+00
RINT10879 nd10879 nd11530 2.631459045730e+00
RINT10880 nd10880 nd11531 2.631459045730e+00
RINT10881 nd10881 nd11532 4.230074822339e+00
RINT10882 nd10882 nd11533 3.652690404715e+00
RINT10883 nd10883 nd11534 3.652690404715e+00
RINT10884 nd10884 nd11535 2.119240969950e+02
RINT10885 nd10885 nd11536 7.517857760993e+00
RINT10886 nd10886 nd11537 7.571031020681e+00
RINT10887 nd10887 nd11538 7.571031020681e+00
RINT10888 nd10888 nd11539 3.514802294586e+03
RINT10889 nd10889 nd11540 5.858003824309e+02
RINT10890 nd10890 nd11541 1.004229227024e+03
RINT10891 nd10891 nd11542 1.004229227024e+03
RINT10892 nd10892 nd11543 1.004229227024e+03
RINT10893 nd10893 nd11544 1.004229227024e+03
RINT10894 nd10894 nd11545 1.004229227024e+03
RINT10895 nd10895 nd11546 1.004229227024e+03
RINT10896 nd10896 nd11547 1.004229227024e+03
RINT10897 nd10897 nd11548 2.231620504499e+02
RINT10898 nd10898 nd11549 2.231620504499e+02
RINT10899 nd10899 nd11550 3.958527469042e+02
RINT10900 nd10900 nd11551 2.847193251021e+01
RINT10901 nd10901 nd11552 6.315501709752e+02
RINT10902 nd10902 nd11553 2.631459045730e+00
RINT10903 nd10903 nd11554 2.631459045730e+00
RINT10904 nd10904 nd11555 2.631459045730e+00
RINT10905 nd10905 nd11556 2.631459045730e+00
RINT10906 nd10906 nd11557 2.631459045730e+00
RINT10907 nd10907 nd11558 2.631459045730e+00
RINT10908 nd10908 nd11559 2.631459045730e+00
RINT10909 nd10909 nd11560 2.631459045730e+00
RINT10910 nd10910 nd11561 2.631459045730e+00
RINT10911 nd10911 nd11562 2.631459045730e+00
RINT10912 nd10912 nd11563 4.230074822339e+00
RINT10913 nd10913 nd11564 3.652690404715e+00
RINT10914 nd10914 nd11565 3.652690404715e+00
RINT10915 nd10915 nd11566 2.119240969950e+02
RINT10916 nd10916 nd11567 7.517857760993e+00
RINT10917 nd10917 nd11568 7.571031020681e+00
RINT10918 nd10918 nd11569 7.571031020681e+00
RINT10919 nd10919 nd11570 3.514802294586e+03
RINT10920 nd10920 nd11571 5.858003824309e+02
RINT10921 nd10921 nd11572 1.004229227024e+03
RINT10922 nd10922 nd11573 1.004229227024e+03
RINT10923 nd10923 nd11574 1.004229227024e+03
RINT10924 nd10924 nd11575 1.004229227024e+03
RINT10925 nd10925 nd11576 1.004229227024e+03
RINT10926 nd10926 nd11577 1.004229227024e+03
RINT10927 nd10927 nd11578 1.004229227024e+03
RINT10928 nd10928 nd11579 2.231620504499e+02
RINT10929 nd10929 nd11580 2.231620504499e+02
RINT10930 nd10930 nd11581 3.958527469042e+02
RINT10931 nd10931 nd11582 2.847193251021e+01
RINT10932 nd10932 nd11583 6.315501709752e+02
RINT10933 nd10933 nd11584 2.631459045730e+00
RINT10934 nd10934 nd11585 2.631459045730e+00
RINT10935 nd10935 nd11586 2.631459045730e+00
RINT10936 nd10936 nd11587 2.631459045730e+00
RINT10937 nd10937 nd11588 2.631459045730e+00
RINT10938 nd10938 nd11589 2.631459045730e+00
RINT10939 nd10939 nd11590 2.631459045730e+00
RINT10940 nd10940 nd11591 2.631459045730e+00
RINT10941 nd10941 nd11592 2.631459045730e+00
RINT10942 nd10942 nd11593 2.631459045730e+00
RINT10943 nd10943 nd11594 4.050184192900e+01
RINT10944 nd10944 nd11595 3.497353961828e+01
RINT10945 nd10945 nd11596 3.497353961828e+01
RINT10946 nd10946 nd11597 2.029116892238e+03
RINT10947 nd10947 nd11598 7.198148956432e+01
RINT10948 nd10948 nd11599 7.249060939061e+01
RINT10949 nd10949 nd11600 7.249060939061e+01
RINT10950 nd10950 nd11601 3.365329761905e+04
RINT10951 nd10951 nd11602 5.608882936508e+03
RINT10952 nd10952 nd11603 9.615227891156e+03
RINT10953 nd10953 nd11604 9.615227891156e+03
RINT10954 nd10954 nd11605 9.615227891156e+03
RINT10955 nd10955 nd11606 9.615227891156e+03
RINT10956 nd10956 nd11607 9.615227891156e+03
RINT10957 nd10957 nd11608 9.615227891156e+03
RINT10958 nd10958 nd11609 9.615227891156e+03
RINT10959 nd10959 nd11610 2.136717309146e+03
RINT10960 nd10960 nd11611 2.136717309146e+03
RINT10961 nd10961 nd11612 3.790184820752e+03
RINT10962 nd10962 nd11613 2.726111849965e+02
RINT10963 nd10963 nd11614 6.046925000000e+03
RINT10964 nd10964 nd11615 2.519552083333e+01
RINT10965 nd10965 nd11616 2.519552083333e+01
RINT10966 nd10966 nd11617 2.519552083333e+01
RINT10967 nd10967 nd11618 2.519552083333e+01
RINT10968 nd10968 nd11619 2.519552083333e+01
RINT10969 nd10969 nd11620 2.519552083333e+01
RINT10970 nd10970 nd11621 2.519552083333e+01
RINT10971 nd10971 nd11622 2.519552083333e+01
RINT10972 nd10972 nd11623 2.519552083333e+01
RINT10973 nd10973 nd11624 2.519552083333e+01
RINT10974 nd10974 nd11625 5.509580147687e+00
RINT10975 nd10975 nd11626 4.757549543375e+00
RINT10976 nd10976 nd11627 4.757549543375e+00
RINT10977 nd10977 nd11628 2.760265117425e+02
RINT10978 nd10978 nd11629 9.791845679505e+00
RINT10979 nd10979 nd11630 9.861102689905e+00
RINT10980 nd10980 nd11631 9.861102689905e+00
RINT10981 nd10981 nd11632 3.917049124046e+02
RINT10982 nd10982 nd11633 6.528415206743e+01
RINT10983 nd10983 nd11634 1.119156892585e+02
RINT10984 nd10984 nd11635 1.119156892584e+02
RINT10985 nd10985 nd11636 1.119156892585e+02
RINT10986 nd10986 nd11637 1.119156892584e+02
RINT10987 nd10987 nd11638 1.119156892585e+02
RINT10988 nd10988 nd11639 1.119156892585e+02
RINT10989 nd10989 nd11640 1.119156892584e+02
RINT10990 nd10990 nd11641 2.487015316854e+01
RINT10991 nd10991 nd11642 2.487015316854e+01
RINT10992 nd10992 nd11643 5.155895645706e+02
RINT10993 nd10993 nd11644 3.708407078194e+01
RINT10994 nd10994 nd11645 8.225803160496e+02
RINT10995 nd10995 nd11646 3.427417983540e+00
RINT10996 nd10996 nd11647 3.427417983540e+00
RINT10997 nd10997 nd11648 3.427417983540e+00
RINT10998 nd10998 nd11649 3.427417983540e+00
RINT10999 nd10999 nd11650 3.427417983540e+00
RINT11000 nd11000 nd11651 3.427417983540e+00
RINT11001 nd11001 nd11652 3.427417983540e+00
RINT11002 nd11002 nd11653 3.427417983540e+00
RINT11003 nd11003 nd11654 3.427417983540e+00
RINT11004 nd11004 nd11655 3.427417983540e+00
RINT11005 nd11005 nd11656 5.509580147687e+00
RINT11006 nd11006 nd11657 4.757549543375e+00
RINT11007 nd11007 nd11658 4.757549543375e+00
RINT11008 nd11008 nd11659 2.760265117425e+02
RINT11009 nd11009 nd11660 9.791845679505e+00
RINT11010 nd11010 nd11661 9.861102689905e+00
RINT11011 nd11011 nd11662 9.861102689905e+00
RINT11012 nd11012 nd11663 3.917049124046e+02
RINT11013 nd11013 nd11664 6.528415206743e+01
RINT11014 nd11014 nd11665 1.119156892585e+02
RINT11015 nd11015 nd11666 1.119156892584e+02
RINT11016 nd11016 nd11667 1.119156892585e+02
RINT11017 nd11017 nd11668 1.119156892584e+02
RINT11018 nd11018 nd11669 1.119156892585e+02
RINT11019 nd11019 nd11670 1.119156892585e+02
RINT11020 nd11020 nd11671 1.119156892584e+02
RINT11021 nd11021 nd11672 2.487015316854e+01
RINT11022 nd11022 nd11673 2.487015316854e+01
RINT11023 nd11023 nd11674 5.155895645706e+02
RINT11024 nd11024 nd11675 3.708407078194e+01
RINT11025 nd11025 nd11676 8.225803160496e+02
RINT11026 nd11026 nd11677 3.427417983540e+00
RINT11027 nd11027 nd11678 3.427417983540e+00
RINT11028 nd11028 nd11679 3.427417983540e+00
RINT11029 nd11029 nd11680 3.427417983540e+00
RINT11030 nd11030 nd11681 3.427417983540e+00
RINT11031 nd11031 nd11682 3.427417983540e+00
RINT11032 nd11032 nd11683 3.427417983540e+00
RINT11033 nd11033 nd11684 3.427417983540e+00
RINT11034 nd11034 nd11685 3.427417983540e+00
RINT11035 nd11035 nd11686 3.427417983540e+00
RINT11036 nd11036 nd11687 5.509580147687e+00
RINT11037 nd11037 nd11688 4.757549543375e+00
RINT11038 nd11038 nd11689 4.757549543375e+00
RINT11039 nd11039 nd11690 2.760265117425e+02
RINT11040 nd11040 nd11691 9.791845679505e+00
RINT11041 nd11041 nd11692 9.861102689905e+00
RINT11042 nd11042 nd11693 9.861102689905e+00
RINT11043 nd11043 nd11694 3.917049124046e+02
RINT11044 nd11044 nd11695 6.528415206743e+01
RINT11045 nd11045 nd11696 1.119156892585e+02
RINT11046 nd11046 nd11697 1.119156892584e+02
RINT11047 nd11047 nd11698 1.119156892585e+02
RINT11048 nd11048 nd11699 1.119156892584e+02
RINT11049 nd11049 nd11700 1.119156892585e+02
RINT11050 nd11050 nd11701 1.119156892585e+02
RINT11051 nd11051 nd11702 1.119156892584e+02
RINT11052 nd11052 nd11703 2.487015316854e+01
RINT11053 nd11053 nd11704 2.487015316854e+01
RINT11054 nd11054 nd11705 5.155895645706e+02
RINT11055 nd11055 nd11706 3.708407078194e+01
RINT11056 nd11056 nd11707 8.225803160496e+02
RINT11057 nd11057 nd11708 3.427417983540e+00
RINT11058 nd11058 nd11709 3.427417983540e+00
RINT11059 nd11059 nd11710 3.427417983540e+00
RINT11060 nd11060 nd11711 3.427417983540e+00
RINT11061 nd11061 nd11712 3.427417983540e+00
RINT11062 nd11062 nd11713 3.427417983540e+00
RINT11063 nd11063 nd11714 3.427417983540e+00
RINT11064 nd11064 nd11715 3.427417983540e+00
RINT11065 nd11065 nd11716 3.427417983540e+00
RINT11066 nd11066 nd11717 3.427417983540e+00
RINT11067 nd0 nd31 1.951190200973e+01
RINT11068 nd1 nd32 1.684862330858e+01
RINT11069 nd2 nd33 1.684862330858e+01
RINT11070 nd3 nd34 9.775340597358e+02
RINT11071 nd4 nd35 3.467733080771e+01
RINT11072 nd5 nd36 3.492260103959e+01
RINT11073 nd6 nd37 3.492260103959e+01
RINT11074 nd7 nd38 1.387203319073e+03
RINT11075 nd8 nd39 2.312005531788e+02
RINT11076 nd9 nd40 3.963438054494e+02
RINT11077 nd10 nd41 3.963438054493e+02
RINT11078 nd11 nd42 3.963438054494e+02
RINT11079 nd12 nd43 3.963438054493e+02
RINT11080 nd13 nd44 3.963438054494e+02
RINT11081 nd14 nd45 3.963438054494e+02
RINT11082 nd15 nd46 3.963438054493e+02
RINT11083 nd16 nd47 8.807640121097e+01
RINT11084 nd17 nd48 8.807640121097e+01
RINT11085 nd18 nd49 1.825934606898e+03
RINT11086 nd19 nd50 1.313313784033e+02
RINT11087 nd20 nd51 2.913126970053e+03
RINT11088 nd21 nd52 1.213802904189e+01
RINT11089 nd22 nd53 1.213802904189e+01
RINT11090 nd23 nd54 1.213802904189e+01
RINT11091 nd24 nd55 1.213802904189e+01
RINT11092 nd25 nd56 1.213802904189e+01
RINT11093 nd26 nd57 1.213802904189e+01
RINT11094 nd27 nd58 1.213802904189e+01
RINT11095 nd28 nd59 1.213802904189e+01
RINT11096 nd29 nd60 1.213802904189e+01
RINT11097 nd30 nd61 1.213802904189e+01
RINT11098 nd31 nd62 1.951190200973e+01
RINT11099 nd32 nd63 1.684862330858e+01
RINT11100 nd33 nd64 1.684862330858e+01
RINT11101 nd34 nd65 9.775340597358e+02
RINT11102 nd35 nd66 3.467733080771e+01
RINT11103 nd36 nd67 3.492260103959e+01
RINT11104 nd37 nd68 3.492260103959e+01
RINT11105 nd38 nd69 1.387203319073e+03
RINT11106 nd39 nd70 2.312005531788e+02
RINT11107 nd40 nd71 3.963438054494e+02
RINT11108 nd41 nd72 3.963438054493e+02
RINT11109 nd42 nd73 3.963438054494e+02
RINT11110 nd43 nd74 3.963438054493e+02
RINT11111 nd44 nd75 3.963438054494e+02
RINT11112 nd45 nd76 3.963438054494e+02
RINT11113 nd46 nd77 3.963438054493e+02
RINT11114 nd47 nd78 8.807640121097e+01
RINT11115 nd48 nd79 8.807640121097e+01
RINT11116 nd49 nd80 1.825934606898e+03
RINT11117 nd50 nd81 1.313313784033e+02
RINT11118 nd51 nd82 2.913126970053e+03
RINT11119 nd52 nd83 1.213802904189e+01
RINT11120 nd53 nd84 1.213802904189e+01
RINT11121 nd54 nd85 1.213802904189e+01
RINT11122 nd55 nd86 1.213802904189e+01
RINT11123 nd56 nd87 1.213802904189e+01
RINT11124 nd57 nd88 1.213802904189e+01
RINT11125 nd58 nd89 1.213802904189e+01
RINT11126 nd59 nd90 1.213802904189e+01
RINT11127 nd60 nd91 1.213802904189e+01
RINT11128 nd61 nd92 1.213802904189e+01
RINT11129 nd62 nd93 1.108308062214e+01
RINT11130 nd63 nd94 9.570294603156e+00
RINT11131 nd64 nd95 9.570294603156e+00
RINT11132 nd65 nd96 5.552553917880e+02
RINT11133 nd66 nd97 1.969729311426e+01
RINT11134 nd67 nd98 1.983661063200e+01
RINT11135 nd68 nd99 1.983661063200e+01
RINT11136 nd69 nd100 7.879542556598e+02
RINT11137 nd70 nd101 1.313257092766e+02
RINT11138 nd71 nd102 2.251297873314e+02
RINT11139 nd72 nd103 2.251297873314e+02
RINT11140 nd73 nd104 2.251297873314e+02
RINT11141 nd74 nd105 2.251297873314e+02
RINT11142 nd75 nd106 2.251297873314e+02
RINT11143 nd76 nd107 2.251297873314e+02
RINT11144 nd77 nd108 2.251297873314e+02
RINT11145 nd78 nd109 5.002884162920e+01
RINT11146 nd79 nd110 5.002884162920e+01
RINT11147 nd80 nd111 1.037160828756e+03
RINT11148 nd81 nd112 7.459837868880e+01
RINT11149 nd82 nd113 1.654703936886e+03
RINT11150 nd83 nd114 6.894599737024e+00
RINT11151 nd84 nd115 6.894599737024e+00
RINT11152 nd85 nd116 6.894599737024e+00
RINT11153 nd86 nd117 6.894599737024e+00
RINT11154 nd87 nd118 6.894599737024e+00
RINT11155 nd88 nd119 6.894599737024e+00
RINT11156 nd89 nd120 6.894599737024e+00
RINT11157 nd90 nd121 6.894599737024e+00
RINT11158 nd91 nd122 6.894599737024e+00
RINT11159 nd92 nd123 6.894599737024e+00
RINT11160 nd93 nd124 1.403404290740e+01
RINT11161 nd94 nd125 1.211846504381e+01
RINT11162 nd95 nd126 1.211846504381e+01
RINT11163 nd96 nd127 7.030967524816e+02
RINT11164 nd97 nd128 2.494186103574e+01
RINT11165 nd98 nd129 2.511827299990e+01
RINT11166 nd99 nd130 2.511827299990e+01
RINT11167 nd100 nd131 9.977536219406e+02
RINT11168 nd101 nd132 1.662922703234e+02
RINT11169 nd102 nd133 2.850724634116e+02
RINT11170 nd103 nd134 2.850724634116e+02
RINT11171 nd104 nd135 2.850724634116e+02
RINT11172 nd105 nd136 2.850724634116e+02
RINT11173 nd106 nd137 2.850724634116e+02
RINT11174 nd107 nd138 2.850724634116e+02
RINT11175 nd108 nd139 2.850724634116e+02
RINT11176 nd109 nd140 6.334943631369e+01
RINT11177 nd110 nd141 6.334943631369e+01
RINT11178 nd111 nd142 1.313313515338e+03
RINT11179 nd112 nd143 9.446081672003e+01
RINT11180 nd113 nd144 2.095282606075e+03
RINT11181 nd114 nd145 8.730344191980e+00
RINT11182 nd115 nd146 8.730344191980e+00
RINT11183 nd116 nd147 8.730344191980e+00
RINT11184 nd117 nd148 8.730344191980e+00
RINT11185 nd118 nd149 8.730344191980e+00
RINT11186 nd119 nd150 8.730344191980e+00
RINT11187 nd120 nd151 8.730344191980e+00
RINT11188 nd121 nd152 8.730344191980e+00
RINT11189 nd122 nd153 8.730344191980e+00
RINT11190 nd123 nd154 8.730344191980e+00
RINT11191 nd124 nd155 2.541382658025e+01
RINT11192 nd125 nd156 2.194496418989e+01
RINT11193 nd126 nd157 2.194496418989e+01
RINT11194 nd127 nd158 1.273216781123e+03
RINT11195 nd128 nd159 4.516646665065e+01
RINT11196 nd129 nd160 4.548592577541e+01
RINT11197 nd130 nd161 4.548592577541e+01
RINT11198 nd131 nd162 1.806802051634e+03
RINT11199 nd132 nd163 3.011336752724e+02
RINT11200 nd133 nd164 5.162291576098e+02
RINT11201 nd134 nd165 5.162291576098e+02
RINT11202 nd135 nd166 5.162291576098e+02
RINT11203 nd136 nd167 5.162291576098e+02
RINT11204 nd137 nd168 5.162291576098e+02
RINT11205 nd138 nd169 5.162291576098e+02
RINT11206 nd139 nd170 5.162291576098e+02
RINT11207 nd140 nd171 1.147175905800e+02
RINT11208 nd141 nd172 1.147175905800e+02
RINT11209 nd142 nd173 2.378239980062e+03
RINT11210 nd143 nd174 1.710562544658e+02
RINT11211 nd144 nd175 3.794284308432e+03
RINT11212 nd145 nd176 1.580951795180e+01
RINT11213 nd146 nd177 1.580951795180e+01
RINT11214 nd147 nd178 1.580951795180e+01
RINT11215 nd148 nd179 1.580951795180e+01
RINT11216 nd149 nd180 1.580951795180e+01
RINT11217 nd150 nd181 1.580951795180e+01
RINT11218 nd151 nd182 1.580951795180e+01
RINT11219 nd152 nd183 1.580951795180e+01
RINT11220 nd153 nd184 1.580951795180e+01
RINT11221 nd154 nd185 1.580951795180e+01
RINT11222 nd155 nd186 2.541382658025e+01
RINT11223 nd156 nd187 2.194496418989e+01
RINT11224 nd157 nd188 2.194496418989e+01
RINT11225 nd158 nd189 1.273216781123e+03
RINT11226 nd159 nd190 4.516646665065e+01
RINT11227 nd160 nd191 4.548592577541e+01
RINT11228 nd161 nd192 4.548592577541e+01
RINT11229 nd162 nd193 1.806802051634e+03
RINT11230 nd163 nd194 3.011336752724e+02
RINT11231 nd164 nd195 5.162291576098e+02
RINT11232 nd165 nd196 5.162291576098e+02
RINT11233 nd166 nd197 5.162291576098e+02
RINT11234 nd167 nd198 5.162291576098e+02
RINT11235 nd168 nd199 5.162291576098e+02
RINT11236 nd169 nd200 5.162291576098e+02
RINT11237 nd170 nd201 5.162291576098e+02
RINT11238 nd171 nd202 1.147175905800e+02
RINT11239 nd172 nd203 1.147175905800e+02
RINT11240 nd173 nd204 2.378239980062e+03
RINT11241 nd174 nd205 1.710562544658e+02
RINT11242 nd175 nd206 3.794284308432e+03
RINT11243 nd176 nd207 1.580951795180e+01
RINT11244 nd177 nd208 1.580951795180e+01
RINT11245 nd178 nd209 1.580951795180e+01
RINT11246 nd179 nd210 1.580951795180e+01
RINT11247 nd180 nd211 1.580951795180e+01
RINT11248 nd181 nd212 1.580951795180e+01
RINT11249 nd182 nd213 1.580951795180e+01
RINT11250 nd183 nd214 1.580951795180e+01
RINT11251 nd184 nd215 1.580951795180e+01
RINT11252 nd185 nd216 1.580951795180e+01
RINT11253 nd186 nd217 2.541382658025e+01
RINT11254 nd187 nd218 2.194496418989e+01
RINT11255 nd188 nd219 2.194496418989e+01
RINT11256 nd189 nd220 1.273216781123e+03
RINT11257 nd190 nd221 4.516646665065e+01
RINT11258 nd191 nd222 4.548592577541e+01
RINT11259 nd192 nd223 4.548592577541e+01
RINT11260 nd193 nd224 1.806802051634e+03
RINT11261 nd194 nd225 3.011336752724e+02
RINT11262 nd195 nd226 5.162291576098e+02
RINT11263 nd196 nd227 5.162291576098e+02
RINT11264 nd197 nd228 5.162291576098e+02
RINT11265 nd198 nd229 5.162291576098e+02
RINT11266 nd199 nd230 5.162291576098e+02
RINT11267 nd200 nd231 5.162291576098e+02
RINT11268 nd201 nd232 5.162291576098e+02
RINT11269 nd202 nd233 1.147175905800e+02
RINT11270 nd203 nd234 1.147175905800e+02
RINT11271 nd204 nd235 2.378239980062e+03
RINT11272 nd205 nd236 1.710562544658e+02
RINT11273 nd206 nd237 3.794284308432e+03
RINT11274 nd207 nd238 1.580951795180e+01
RINT11275 nd208 nd239 1.580951795180e+01
RINT11276 nd209 nd240 1.580951795180e+01
RINT11277 nd210 nd241 1.580951795180e+01
RINT11278 nd211 nd242 1.580951795180e+01
RINT11279 nd212 nd243 1.580951795180e+01
RINT11280 nd213 nd244 1.580951795180e+01
RINT11281 nd214 nd245 1.580951795180e+01
RINT11282 nd215 nd246 1.580951795180e+01
RINT11283 nd216 nd247 1.580951795180e+01
RINT11284 nd217 nd248 2.541382658025e+01
RINT11285 nd218 nd249 2.194496418989e+01
RINT11286 nd219 nd250 2.194496418989e+01
RINT11287 nd220 nd251 1.273216781123e+03
RINT11288 nd221 nd252 4.516646665065e+01
RINT11289 nd222 nd253 4.548592577541e+01
RINT11290 nd223 nd254 4.548592577541e+01
RINT11291 nd224 nd255 1.806802051634e+03
RINT11292 nd225 nd256 3.011336752724e+02
RINT11293 nd226 nd257 5.162291576098e+02
RINT11294 nd227 nd258 5.162291576098e+02
RINT11295 nd228 nd259 5.162291576098e+02
RINT11296 nd229 nd260 5.162291576098e+02
RINT11297 nd230 nd261 5.162291576098e+02
RINT11298 nd231 nd262 5.162291576098e+02
RINT11299 nd232 nd263 5.162291576098e+02
RINT11300 nd233 nd264 1.147175905800e+02
RINT11301 nd234 nd265 1.147175905800e+02
RINT11302 nd235 nd266 2.378239980062e+03
RINT11303 nd236 nd267 1.710562544658e+02
RINT11304 nd237 nd268 3.794284308432e+03
RINT11305 nd238 nd269 1.580951795180e+01
RINT11306 nd239 nd270 1.580951795180e+01
RINT11307 nd240 nd271 1.580951795180e+01
RINT11308 nd241 nd272 1.580951795180e+01
RINT11309 nd242 nd273 1.580951795180e+01
RINT11310 nd243 nd274 1.580951795180e+01
RINT11311 nd244 nd275 1.580951795180e+01
RINT11312 nd245 nd276 1.580951795180e+01
RINT11313 nd246 nd277 1.580951795180e+01
RINT11314 nd247 nd278 1.580951795180e+01
RINT11315 nd248 nd279 2.541382658025e+01
RINT11316 nd249 nd280 2.194496418989e+01
RINT11317 nd250 nd281 2.194496418989e+01
RINT11318 nd251 nd282 1.273216781123e+03
RINT11319 nd252 nd283 4.516646665065e+01
RINT11320 nd253 nd284 4.548592577541e+01
RINT11321 nd254 nd285 4.548592577541e+01
RINT11322 nd255 nd286 1.806802051634e+03
RINT11323 nd256 nd287 3.011336752724e+02
RINT11324 nd257 nd288 5.162291576098e+02
RINT11325 nd258 nd289 5.162291576098e+02
RINT11326 nd259 nd290 5.162291576098e+02
RINT11327 nd260 nd291 5.162291576098e+02
RINT11328 nd261 nd292 5.162291576098e+02
RINT11329 nd262 nd293 5.162291576098e+02
RINT11330 nd263 nd294 5.162291576098e+02
RINT11331 nd264 nd295 1.147175905800e+02
RINT11332 nd265 nd296 1.147175905800e+02
RINT11333 nd266 nd297 2.378239980062e+03
RINT11334 nd267 nd298 1.710562544658e+02
RINT11335 nd268 nd299 3.794284308432e+03
RINT11336 nd269 nd300 1.580951795180e+01
RINT11337 nd270 nd301 1.580951795180e+01
RINT11338 nd271 nd302 1.580951795180e+01
RINT11339 nd272 nd303 1.580951795180e+01
RINT11340 nd273 nd304 1.580951795180e+01
RINT11341 nd274 nd305 1.580951795180e+01
RINT11342 nd275 nd306 1.580951795180e+01
RINT11343 nd276 nd307 1.580951795180e+01
RINT11344 nd277 nd308 1.580951795180e+01
RINT11345 nd278 nd309 1.580951795180e+01
RINT11346 nd279 nd310 1.403404290740e+01
RINT11347 nd280 nd311 1.211846504381e+01
RINT11348 nd281 nd312 1.211846504381e+01
RINT11349 nd282 nd313 7.030967524816e+02
RINT11350 nd283 nd314 2.494186103574e+01
RINT11351 nd284 nd315 2.511827299990e+01
RINT11352 nd285 nd316 2.511827299990e+01
RINT11353 nd286 nd317 9.977536219406e+02
RINT11354 nd287 nd318 1.662922703234e+02
RINT11355 nd288 nd319 2.850724634116e+02
RINT11356 nd289 nd320 2.850724634116e+02
RINT11357 nd290 nd321 2.850724634116e+02
RINT11358 nd291 nd322 2.850724634116e+02
RINT11359 nd292 nd323 2.850724634116e+02
RINT11360 nd293 nd324 2.850724634116e+02
RINT11361 nd294 nd325 2.850724634116e+02
RINT11362 nd295 nd326 6.334943631369e+01
RINT11363 nd296 nd327 6.334943631369e+01
RINT11364 nd297 nd328 1.313313515338e+03
RINT11365 nd298 nd329 9.446081672003e+01
RINT11366 nd299 nd330 2.095282606075e+03
RINT11367 nd300 nd331 8.730344191981e+00
RINT11368 nd301 nd332 8.730344191980e+00
RINT11369 nd302 nd333 8.730344191981e+00
RINT11370 nd303 nd334 8.730344191980e+00
RINT11371 nd304 nd335 8.730344191981e+00
RINT11372 nd305 nd336 8.730344191981e+00
RINT11373 nd306 nd337 8.730344191981e+00
RINT11374 nd307 nd338 8.730344191980e+00
RINT11375 nd308 nd339 8.730344191981e+00
RINT11376 nd309 nd340 8.730344191981e+00
RINT11377 nd310 nd341 1.403404290740e+01
RINT11378 nd311 nd342 1.211846504381e+01
RINT11379 nd312 nd343 1.211846504381e+01
RINT11380 nd313 nd344 7.030967524816e+02
RINT11381 nd314 nd345 2.494186103574e+01
RINT11382 nd315 nd346 2.511827299990e+01
RINT11383 nd316 nd347 2.511827299990e+01
RINT11384 nd317 nd348 9.977536219406e+02
RINT11385 nd318 nd349 1.662922703234e+02
RINT11386 nd319 nd350 2.850724634116e+02
RINT11387 nd320 nd351 2.850724634116e+02
RINT11388 nd321 nd352 2.850724634116e+02
RINT11389 nd322 nd353 2.850724634116e+02
RINT11390 nd323 nd354 2.850724634116e+02
RINT11391 nd324 nd355 2.850724634116e+02
RINT11392 nd325 nd356 2.850724634116e+02
RINT11393 nd326 nd357 6.334943631369e+01
RINT11394 nd327 nd358 6.334943631369e+01
RINT11395 nd328 nd359 1.313313515338e+03
RINT11396 nd329 nd360 9.446081672003e+01
RINT11397 nd330 nd361 2.095282606075e+03
RINT11398 nd331 nd362 8.730344191980e+00
RINT11399 nd332 nd363 8.730344191980e+00
RINT11400 nd333 nd364 8.730344191980e+00
RINT11401 nd334 nd365 8.730344191980e+00
RINT11402 nd335 nd366 8.730344191980e+00
RINT11403 nd336 nd367 8.730344191980e+00
RINT11404 nd337 nd368 8.730344191980e+00
RINT11405 nd338 nd369 8.730344191980e+00
RINT11406 nd339 nd370 8.730344191980e+00
RINT11407 nd340 nd371 8.730344191980e+00
RINT11408 nd341 nd372 2.541382658025e+01
RINT11409 nd342 nd373 2.194496418989e+01
RINT11410 nd343 nd374 2.194496418989e+01
RINT11411 nd344 nd375 1.273216781123e+03
RINT11412 nd345 nd376 4.516646665065e+01
RINT11413 nd346 nd377 4.548592577541e+01
RINT11414 nd347 nd378 4.548592577541e+01
RINT11415 nd348 nd379 1.806802051634e+03
RINT11416 nd349 nd380 3.011336752724e+02
RINT11417 nd350 nd381 5.162291576098e+02
RINT11418 nd351 nd382 5.162291576098e+02
RINT11419 nd352 nd383 5.162291576098e+02
RINT11420 nd353 nd384 5.162291576098e+02
RINT11421 nd354 nd385 5.162291576098e+02
RINT11422 nd355 nd386 5.162291576098e+02
RINT11423 nd356 nd387 5.162291576098e+02
RINT11424 nd357 nd388 1.147175905800e+02
RINT11425 nd358 nd389 1.147175905800e+02
RINT11426 nd359 nd390 2.378239980062e+03
RINT11427 nd360 nd391 1.710562544658e+02
RINT11428 nd361 nd392 3.794284308432e+03
RINT11429 nd362 nd393 1.580951795180e+01
RINT11430 nd363 nd394 1.580951795180e+01
RINT11431 nd364 nd395 1.580951795180e+01
RINT11432 nd365 nd396 1.580951795180e+01
RINT11433 nd366 nd397 1.580951795180e+01
RINT11434 nd367 nd398 1.580951795180e+01
RINT11435 nd368 nd399 1.580951795180e+01
RINT11436 nd369 nd400 1.580951795180e+01
RINT11437 nd370 nd401 1.580951795180e+01
RINT11438 nd371 nd402 1.580951795180e+01
RINT11439 nd372 nd403 2.541382658025e+01
RINT11440 nd373 nd404 2.194496418989e+01
RINT11441 nd374 nd405 2.194496418989e+01
RINT11442 nd375 nd406 1.273216781123e+03
RINT11443 nd376 nd407 4.516646665065e+01
RINT11444 nd377 nd408 4.548592577541e+01
RINT11445 nd378 nd409 4.548592577541e+01
RINT11446 nd379 nd410 1.806802051634e+03
RINT11447 nd380 nd411 3.011336752724e+02
RINT11448 nd381 nd412 5.162291576098e+02
RINT11449 nd382 nd413 5.162291576098e+02
RINT11450 nd383 nd414 5.162291576098e+02
RINT11451 nd384 nd415 5.162291576098e+02
RINT11452 nd385 nd416 5.162291576098e+02
RINT11453 nd386 nd417 5.162291576098e+02
RINT11454 nd387 nd418 5.162291576098e+02
RINT11455 nd388 nd419 1.147175905800e+02
RINT11456 nd389 nd420 1.147175905800e+02
RINT11457 nd390 nd421 2.378239980062e+03
RINT11458 nd391 nd422 1.710562544658e+02
RINT11459 nd392 nd423 3.794284308432e+03
RINT11460 nd393 nd424 1.580951795180e+01
RINT11461 nd394 nd425 1.580951795180e+01
RINT11462 nd395 nd426 1.580951795180e+01
RINT11463 nd396 nd427 1.580951795180e+01
RINT11464 nd397 nd428 1.580951795180e+01
RINT11465 nd398 nd429 1.580951795180e+01
RINT11466 nd399 nd430 1.580951795180e+01
RINT11467 nd400 nd431 1.580951795180e+01
RINT11468 nd401 nd432 1.580951795180e+01
RINT11469 nd402 nd433 1.580951795180e+01
RINT11470 nd403 nd434 2.541382658025e+01
RINT11471 nd404 nd435 2.194496418989e+01
RINT11472 nd405 nd436 2.194496418989e+01
RINT11473 nd406 nd437 1.273216781123e+03
RINT11474 nd407 nd438 4.516646665065e+01
RINT11475 nd408 nd439 4.548592577541e+01
RINT11476 nd409 nd440 4.548592577541e+01
RINT11477 nd410 nd441 1.806802051634e+03
RINT11478 nd411 nd442 3.011336752724e+02
RINT11479 nd412 nd443 5.162291576098e+02
RINT11480 nd413 nd444 5.162291576098e+02
RINT11481 nd414 nd445 5.162291576098e+02
RINT11482 nd415 nd446 5.162291576098e+02
RINT11483 nd416 nd447 5.162291576098e+02
RINT11484 nd417 nd448 5.162291576098e+02
RINT11485 nd418 nd449 5.162291576098e+02
RINT11486 nd419 nd450 1.147175905800e+02
RINT11487 nd420 nd451 1.147175905800e+02
RINT11488 nd421 nd452 2.378239980062e+03
RINT11489 nd422 nd453 1.710562544657e+02
RINT11490 nd423 nd454 3.794284308432e+03
RINT11491 nd424 nd455 1.580951795180e+01
RINT11492 nd425 nd456 1.580951795180e+01
RINT11493 nd426 nd457 1.580951795180e+01
RINT11494 nd427 nd458 1.580951795180e+01
RINT11495 nd428 nd459 1.580951795180e+01
RINT11496 nd429 nd460 1.580951795180e+01
RINT11497 nd430 nd461 1.580951795180e+01
RINT11498 nd431 nd462 1.580951795180e+01
RINT11499 nd432 nd463 1.580951795180e+01
RINT11500 nd433 nd464 1.580951795180e+01
RINT11501 nd434 nd465 2.541382658025e+01
RINT11502 nd435 nd466 2.194496418989e+01
RINT11503 nd436 nd467 2.194496418989e+01
RINT11504 nd437 nd468 1.273216781123e+03
RINT11505 nd438 nd469 4.516646665065e+01
RINT11506 nd439 nd470 4.548592577541e+01
RINT11507 nd440 nd471 4.548592577541e+01
RINT11508 nd441 nd472 1.806802051634e+03
RINT11509 nd442 nd473 3.011336752724e+02
RINT11510 nd443 nd474 5.162291576098e+02
RINT11511 nd444 nd475 5.162291576098e+02
RINT11512 nd445 nd476 5.162291576098e+02
RINT11513 nd446 nd477 5.162291576098e+02
RINT11514 nd447 nd478 5.162291576098e+02
RINT11515 nd448 nd479 5.162291576098e+02
RINT11516 nd449 nd480 5.162291576098e+02
RINT11517 nd450 nd481 1.147175905800e+02
RINT11518 nd451 nd482 1.147175905800e+02
RINT11519 nd452 nd483 2.378239980062e+03
RINT11520 nd453 nd484 1.710562544658e+02
RINT11521 nd454 nd485 3.794284308432e+03
RINT11522 nd455 nd486 1.580951795180e+01
RINT11523 nd456 nd487 1.580951795180e+01
RINT11524 nd457 nd488 1.580951795180e+01
RINT11525 nd458 nd489 1.580951795180e+01
RINT11526 nd459 nd490 1.580951795180e+01
RINT11527 nd460 nd491 1.580951795180e+01
RINT11528 nd461 nd492 1.580951795180e+01
RINT11529 nd462 nd493 1.580951795180e+01
RINT11530 nd463 nd494 1.580951795180e+01
RINT11531 nd464 nd495 1.580951795180e+01
RINT11532 nd465 nd496 2.541382658025e+01
RINT11533 nd466 nd497 2.194496418989e+01
RINT11534 nd467 nd498 2.194496418989e+01
RINT11535 nd468 nd499 1.273216781123e+03
RINT11536 nd469 nd500 4.516646665065e+01
RINT11537 nd470 nd501 4.548592577541e+01
RINT11538 nd471 nd502 4.548592577541e+01
RINT11539 nd472 nd503 1.806802051634e+03
RINT11540 nd473 nd504 3.011336752724e+02
RINT11541 nd474 nd505 5.162291576098e+02
RINT11542 nd475 nd506 5.162291576098e+02
RINT11543 nd476 nd507 5.162291576098e+02
RINT11544 nd477 nd508 5.162291576098e+02
RINT11545 nd478 nd509 5.162291576098e+02
RINT11546 nd479 nd510 5.162291576098e+02
RINT11547 nd480 nd511 5.162291576098e+02
RINT11548 nd481 nd512 1.147175905800e+02
RINT11549 nd482 nd513 1.147175905800e+02
RINT11550 nd483 nd514 2.378239980062e+03
RINT11551 nd484 nd515 1.710562544658e+02
RINT11552 nd485 nd516 3.794284308432e+03
RINT11553 nd486 nd517 1.580951795180e+01
RINT11554 nd487 nd518 1.580951795180e+01
RINT11555 nd488 nd519 1.580951795180e+01
RINT11556 nd489 nd520 1.580951795180e+01
RINT11557 nd490 nd521 1.580951795180e+01
RINT11558 nd491 nd522 1.580951795180e+01
RINT11559 nd492 nd523 1.580951795180e+01
RINT11560 nd493 nd524 1.580951795180e+01
RINT11561 nd494 nd525 1.580951795180e+01
RINT11562 nd495 nd526 1.580951795180e+01
RINT11563 nd496 nd527 1.403404290740e+01
RINT11564 nd497 nd528 1.211846504381e+01
RINT11565 nd498 nd529 1.211846504381e+01
RINT11566 nd499 nd530 7.030967524816e+02
RINT11567 nd500 nd531 2.494186103574e+01
RINT11568 nd501 nd532 2.511827299990e+01
RINT11569 nd502 nd533 2.511827299990e+01
RINT11570 nd503 nd534 9.977536219406e+02
RINT11571 nd504 nd535 1.662922703234e+02
RINT11572 nd505 nd536 2.850724634116e+02
RINT11573 nd506 nd537 2.850724634116e+02
RINT11574 nd507 nd538 2.850724634116e+02
RINT11575 nd508 nd539 2.850724634116e+02
RINT11576 nd509 nd540 2.850724634116e+02
RINT11577 nd510 nd541 2.850724634116e+02
RINT11578 nd511 nd542 2.850724634116e+02
RINT11579 nd512 nd543 6.334943631369e+01
RINT11580 nd513 nd544 6.334943631369e+01
RINT11581 nd514 nd545 1.313313515338e+03
RINT11582 nd515 nd546 9.446081672003e+01
RINT11583 nd516 nd547 2.095282606075e+03
RINT11584 nd517 nd548 8.730344191980e+00
RINT11585 nd518 nd549 8.730344191980e+00
RINT11586 nd519 nd550 8.730344191980e+00
RINT11587 nd520 nd551 8.730344191980e+00
RINT11588 nd521 nd552 8.730344191980e+00
RINT11589 nd522 nd553 8.730344191980e+00
RINT11590 nd523 nd554 8.730344191980e+00
RINT11591 nd524 nd555 8.730344191980e+00
RINT11592 nd525 nd556 8.730344191980e+00
RINT11593 nd526 nd557 8.730344191980e+00
RINT11594 nd527 nd558 1.108308062214e+01
RINT11595 nd528 nd559 9.570294603156e+00
RINT11596 nd529 nd560 9.570294603156e+00
RINT11597 nd530 nd561 5.552553917880e+02
RINT11598 nd531 nd562 1.969729311426e+01
RINT11599 nd532 nd563 1.983661063200e+01
RINT11600 nd533 nd564 1.983661063200e+01
RINT11601 nd534 nd565 7.879542556598e+02
RINT11602 nd535 nd566 1.313257092766e+02
RINT11603 nd536 nd567 2.251297873314e+02
RINT11604 nd537 nd568 2.251297873314e+02
RINT11605 nd538 nd569 2.251297873314e+02
RINT11606 nd539 nd570 2.251297873314e+02
RINT11607 nd540 nd571 2.251297873314e+02
RINT11608 nd541 nd572 2.251297873314e+02
RINT11609 nd542 nd573 2.251297873314e+02
RINT11610 nd543 nd574 5.002884162920e+01
RINT11611 nd544 nd575 5.002884162920e+01
RINT11612 nd545 nd576 1.037160828756e+03
RINT11613 nd546 nd577 7.459837868880e+01
RINT11614 nd547 nd578 1.654703936886e+03
RINT11615 nd548 nd579 6.894599737024e+00
RINT11616 nd549 nd580 6.894599737024e+00
RINT11617 nd550 nd581 6.894599737024e+00
RINT11618 nd551 nd582 6.894599737024e+00
RINT11619 nd552 nd583 6.894599737024e+00
RINT11620 nd553 nd584 6.894599737024e+00
RINT11621 nd554 nd585 6.894599737024e+00
RINT11622 nd555 nd586 6.894599737024e+00
RINT11623 nd556 nd587 6.894599737024e+00
RINT11624 nd557 nd588 6.894599737024e+00
RINT11625 nd558 nd589 1.951190200973e+01
RINT11626 nd559 nd590 1.684862330858e+01
RINT11627 nd560 nd591 1.684862330858e+01
RINT11628 nd561 nd592 9.775340597358e+02
RINT11629 nd562 nd593 3.467733080771e+01
RINT11630 nd563 nd594 3.492260103959e+01
RINT11631 nd564 nd595 3.492260103959e+01
RINT11632 nd565 nd596 1.387203319073e+03
RINT11633 nd566 nd597 2.312005531788e+02
RINT11634 nd567 nd598 3.963438054494e+02
RINT11635 nd568 nd599 3.963438054493e+02
RINT11636 nd569 nd600 3.963438054494e+02
RINT11637 nd570 nd601 3.963438054493e+02
RINT11638 nd571 nd602 3.963438054494e+02
RINT11639 nd572 nd603 3.963438054494e+02
RINT11640 nd573 nd604 3.963438054493e+02
RINT11641 nd574 nd605 8.807640121097e+01
RINT11642 nd575 nd606 8.807640121097e+01
RINT11643 nd576 nd607 1.825934606898e+03
RINT11644 nd577 nd608 1.313313784033e+02
RINT11645 nd578 nd609 2.913126970053e+03
RINT11646 nd579 nd610 1.213802904189e+01
RINT11647 nd580 nd611 1.213802904189e+01
RINT11648 nd581 nd612 1.213802904189e+01
RINT11649 nd582 nd613 1.213802904189e+01
RINT11650 nd583 nd614 1.213802904189e+01
RINT11651 nd584 nd615 1.213802904189e+01
RINT11652 nd585 nd616 1.213802904189e+01
RINT11653 nd586 nd617 1.213802904189e+01
RINT11654 nd587 nd618 1.213802904189e+01
RINT11655 nd588 nd619 1.213802904189e+01
RINT11656 nd589 nd620 1.951190200973e+01
RINT11657 nd590 nd621 1.684862330858e+01
RINT11658 nd591 nd622 1.684862330858e+01
RINT11659 nd592 nd623 9.775340597358e+02
RINT11660 nd593 nd624 3.467733080771e+01
RINT11661 nd594 nd625 3.492260103959e+01
RINT11662 nd595 nd626 3.492260103959e+01
RINT11663 nd596 nd627 1.387203319073e+03
RINT11664 nd597 nd628 2.312005531788e+02
RINT11665 nd598 nd629 3.963438054494e+02
RINT11666 nd599 nd630 3.963438054493e+02
RINT11667 nd600 nd631 3.963438054494e+02
RINT11668 nd601 nd632 3.963438054493e+02
RINT11669 nd602 nd633 3.963438054494e+02
RINT11670 nd603 nd634 3.963438054494e+02
RINT11671 nd604 nd635 3.963438054493e+02
RINT11672 nd605 nd636 8.807640121097e+01
RINT11673 nd606 nd637 8.807640121097e+01
RINT11674 nd607 nd638 1.825934606898e+03
RINT11675 nd608 nd639 1.313313784033e+02
RINT11676 nd609 nd640 2.913126970053e+03
RINT11677 nd610 nd641 1.213802904189e+01
RINT11678 nd611 nd642 1.213802904189e+01
RINT11679 nd612 nd643 1.213802904189e+01
RINT11680 nd613 nd644 1.213802904189e+01
RINT11681 nd614 nd645 1.213802904189e+01
RINT11682 nd615 nd646 1.213802904189e+01
RINT11683 nd616 nd647 1.213802904189e+01
RINT11684 nd617 nd648 1.213802904189e+01
RINT11685 nd618 nd649 1.213802904189e+01
RINT11686 nd619 nd650 1.213802904189e+01
RINT11687 nd651 nd682 9.847510605046e+01
RINT11688 nd652 nd683 8.503373819163e+01
RINT11689 nd653 nd684 8.503373819163e+01
RINT11690 nd654 nd685 4.933541084432e+03
RINT11691 nd655 nd686 1.750138877867e+02
RINT11692 nd656 nd687 1.762517482517e+02
RINT11693 nd657 nd688 1.762517482517e+02
RINT11694 nd658 nd689 7.001111111111e+03
RINT11695 nd659 nd690 1.166851851852e+03
RINT11696 nd660 nd691 2.000317460317e+03
RINT11697 nd661 nd692 2.000317460317e+03
RINT11698 nd662 nd693 2.000317460317e+03
RINT11699 nd663 nd694 2.000317460317e+03
RINT11700 nd664 nd695 2.000317460317e+03
RINT11701 nd665 nd696 2.000317460317e+03
RINT11702 nd666 nd697 2.000317460317e+03
RINT11703 nd667 nd698 4.445149911817e+02
RINT11704 nd668 nd699 4.445149911817e+02
RINT11705 nd669 nd700 9.215355015920e+03
RINT11706 nd670 nd701 6.628196169481e+02
RINT11707 nd671 nd702 1.470233333333e+04
RINT11708 nd672 nd703 6.125972222222e+01
RINT11709 nd673 nd704 6.125972222222e+01
RINT11710 nd674 nd705 6.125972222222e+01
RINT11711 nd675 nd706 6.125972222222e+01
RINT11712 nd676 nd707 6.125972222222e+01
RINT11713 nd677 nd708 6.125972222222e+01
RINT11714 nd678 nd709 6.125972222222e+01
RINT11715 nd679 nd710 6.125972222222e+01
RINT11716 nd680 nd711 6.125972222222e+01
RINT11717 nd681 nd712 6.125972222222e+01
RINT11718 nd682 nd713 9.847510605046e+01
RINT11719 nd683 nd714 8.503373819163e+01
RINT11720 nd684 nd715 8.503373819163e+01
RINT11721 nd685 nd716 4.933541084432e+03
RINT11722 nd686 nd717 1.750138877867e+02
RINT11723 nd687 nd718 1.762517482517e+02
RINT11724 nd688 nd719 1.762517482517e+02
RINT11725 nd689 nd720 7.001111111111e+03
RINT11726 nd690 nd721 1.166851851852e+03
RINT11727 nd691 nd722 2.000317460317e+03
RINT11728 nd692 nd723 2.000317460317e+03
RINT11729 nd693 nd724 2.000317460317e+03
RINT11730 nd694 nd725 2.000317460317e+03
RINT11731 nd695 nd726 2.000317460317e+03
RINT11732 nd696 nd727 2.000317460317e+03
RINT11733 nd697 nd728 2.000317460317e+03
RINT11734 nd698 nd729 4.445149911817e+02
RINT11735 nd699 nd730 4.445149911817e+02
RINT11736 nd700 nd731 9.215355015920e+03
RINT11737 nd701 nd732 6.628196169481e+02
RINT11738 nd702 nd733 1.470233333333e+04
RINT11739 nd703 nd734 6.125972222222e+01
RINT11740 nd704 nd735 6.125972222222e+01
RINT11741 nd705 nd736 6.125972222222e+01
RINT11742 nd706 nd737 6.125972222222e+01
RINT11743 nd707 nd738 6.125972222222e+01
RINT11744 nd708 nd739 6.125972222222e+01
RINT11745 nd709 nd740 6.125972222222e+01
RINT11746 nd710 nd741 6.125972222222e+01
RINT11747 nd711 nd742 6.125972222222e+01
RINT11748 nd712 nd743 6.125972222222e+01
RINT11749 nd713 nd744 5.593547666890e+01
RINT11750 nd714 nd745 4.830055909003e+01
RINT11751 nd715 nd746 4.830055909003e+01
RINT11752 nd716 nd747 2.802332318199e+03
RINT11753 nd717 nd748 9.941076105071e+01
RINT11754 nd718 nd749 1.001138861139e+02
RINT11755 nd719 nd750 1.001138861139e+02
RINT11756 nd720 nd751 3.475055555556e+04
RINT11757 nd721 nd752 5.791759259259e+03
RINT11758 nd722 nd753 9.928730158730e+03
RINT11759 nd723 nd754 9.928730158730e+03
RINT11760 nd724 nd755 9.928730158730e+03
RINT11761 nd725 nd756 9.928730158730e+03
RINT11762 nd726 nd757 9.928730158730e+03
RINT11763 nd727 nd758 9.928730158730e+03
RINT11764 nd728 nd759 9.928730158730e+03
RINT11765 nd729 nd760 2.206384479718e+03
RINT11766 nd730 nd761 2.206384479718e+03
RINT11767 nd731 nd762 5.234472915668e+03
RINT11768 nd732 nd763 3.764924223640e+02
RINT11769 nd733 nd764 8.351166666667e+03
RINT11770 nd734 nd765 3.479652777778e+01
RINT11771 nd735 nd766 3.479652777778e+01
RINT11772 nd736 nd767 3.479652777778e+01
RINT11773 nd737 nd768 3.479652777778e+01
RINT11774 nd738 nd769 3.479652777778e+01
RINT11775 nd739 nd770 3.479652777778e+01
RINT11776 nd740 nd771 3.479652777778e+01
RINT11777 nd741 nd772 3.479652777778e+01
RINT11778 nd742 nd773 3.479652777778e+01
RINT11779 nd743 nd774 3.479652777778e+01
RINT11780 nd744 nd775 7.082876200045e+01
RINT11781 nd745 nd776 6.116098419125e+01
RINT11782 nd746 nd777 6.116098419125e+01
RINT11783 nd747 nd778 3.548476577518e+03
RINT11784 nd748 nd779 1.258797020078e+02
RINT11785 nd749 nd780 1.267700399600e+02
RINT11786 nd750 nd781 1.267700399600e+02
RINT11787 nd751 nd782 3.304604427083e+05
RINT11788 nd752 nd783 5.507674045139e+04
RINT11789 nd753 nd784 9.441726934524e+04
RINT11790 nd754 nd785 9.441726934524e+04
RINT11791 nd755 nd786 9.441726934524e+04
RINT11792 nd756 nd787 9.441726934524e+04
RINT11793 nd757 nd788 9.441726934524e+04
RINT11794 nd758 nd789 9.441726934524e+04
RINT11795 nd759 nd790 9.441726934524e+04
RINT11796 nd760 nd791 2.098161541005e+04
RINT11797 nd761 nd792 2.098161541005e+04
RINT11798 nd762 nd793 6.628194813396e+03
RINT11799 nd763 nd794 4.767366574247e+02
RINT11800 nd764 nd795 1.057473416667e+04
RINT11801 nd765 nd796 4.406139236111e+01
RINT11802 nd766 nd797 4.406139236111e+01
RINT11803 nd767 nd798 4.406139236111e+01
RINT11804 nd768 nd799 4.406139236111e+01
RINT11805 nd769 nd800 4.406139236111e+01
RINT11806 nd770 nd801 4.406139236111e+01
RINT11807 nd771 nd802 4.406139236111e+01
RINT11808 nd772 nd803 4.406139236111e+01
RINT11809 nd773 nd804 4.406139236111e+01
RINT11810 nd774 nd805 4.406139236111e+01
RINT11811 nd775 nd806 1.282616767136e+02
RINT11812 nd776 nd807 1.107545883941e+02
RINT11813 nd777 nd808 1.107545883941e+02
RINT11814 nd778 nd809 6.425829603070e+03
RINT11815 nd779 nd810 2.279517697008e+02
RINT11816 nd780 nd811 2.295640559441e+02
RINT11817 nd781 nd812 2.295640559441e+02
RINT11818 nd782 nd813 5.984208854167e+05
RINT11819 nd783 nd814 9.973681423611e+04
RINT11820 nd784 nd815 1.709773958333e+05
RINT11821 nd785 nd816 1.709773958333e+05
RINT11822 nd786 nd817 1.709773958333e+05
RINT11823 nd787 nd818 1.709773958333e+05
RINT11824 nd788 nd819 1.709773958333e+05
RINT11825 nd789 nd820 1.709773958333e+05
RINT11826 nd790 nd821 1.709773958333e+05
RINT11827 nd791 nd822 3.799497685185e+04
RINT11828 nd792 nd823 3.799497685185e+04
RINT11829 nd793 nd824 1.200279881138e+04
RINT11830 nd794 nd825 8.633080870696e+02
RINT11831 nd795 nd826 1.914946833333e+04
RINT11832 nd796 nd827 7.978945138889e+01
RINT11833 nd797 nd828 7.978945138889e+01
RINT11834 nd798 nd829 7.978945138889e+01
RINT11835 nd799 nd830 7.978945138889e+01
RINT11836 nd800 nd831 7.978945138889e+01
RINT11837 nd801 nd832 7.978945138889e+01
RINT11838 nd802 nd833 7.978945138889e+01
RINT11839 nd803 nd834 7.978945138889e+01
RINT11840 nd804 nd835 7.978945138889e+01
RINT11841 nd805 nd836 7.978945138889e+01
RINT11842 nd806 nd837 1.282616767136e+02
RINT11843 nd807 nd838 1.107545883941e+02
RINT11844 nd808 nd839 1.107545883941e+02
RINT11845 nd809 nd840 6.425829603070e+03
RINT11846 nd810 nd841 2.279517697008e+02
RINT11847 nd811 nd842 2.295640559441e+02
RINT11848 nd812 nd843 2.295640559441e+02
RINT11849 nd813 nd844 5.984208854167e+05
RINT11850 nd814 nd845 9.973681423611e+04
RINT11851 nd815 nd846 1.709773958333e+05
RINT11852 nd816 nd847 1.709773958333e+05
RINT11853 nd817 nd848 1.709773958333e+05
RINT11854 nd818 nd849 1.709773958333e+05
RINT11855 nd819 nd850 1.709773958333e+05
RINT11856 nd820 nd851 1.709773958333e+05
RINT11857 nd821 nd852 1.709773958333e+05
RINT11858 nd822 nd853 3.799497685185e+04
RINT11859 nd823 nd854 3.799497685185e+04
RINT11860 nd824 nd855 1.200279881138e+04
RINT11861 nd825 nd856 8.633080870696e+02
RINT11862 nd826 nd857 1.914946833333e+04
RINT11863 nd827 nd858 7.978945138889e+01
RINT11864 nd828 nd859 7.978945138889e+01
RINT11865 nd829 nd860 7.978945138889e+01
RINT11866 nd830 nd861 7.978945138889e+01
RINT11867 nd831 nd862 7.978945138889e+01
RINT11868 nd832 nd863 7.978945138889e+01
RINT11869 nd833 nd864 7.978945138889e+01
RINT11870 nd834 nd865 7.978945138889e+01
RINT11871 nd835 nd866 7.978945138889e+01
RINT11872 nd836 nd867 7.978945138889e+01
RINT11873 nd837 nd868 1.282616767136e+02
RINT11874 nd838 nd869 1.107545883941e+02
RINT11875 nd839 nd870 1.107545883941e+02
RINT11876 nd840 nd871 6.425829603070e+03
RINT11877 nd841 nd872 2.279517697008e+02
RINT11878 nd842 nd873 2.295640559441e+02
RINT11879 nd843 nd874 2.295640559441e+02
RINT11880 nd844 nd875 5.984208854167e+05
RINT11881 nd845 nd876 9.973681423611e+04
RINT11882 nd846 nd877 1.709773958333e+05
RINT11883 nd847 nd878 1.709773958333e+05
RINT11884 nd848 nd879 1.709773958333e+05
RINT11885 nd849 nd880 1.709773958333e+05
RINT11886 nd850 nd881 1.709773958333e+05
RINT11887 nd851 nd882 1.709773958333e+05
RINT11888 nd852 nd883 1.709773958333e+05
RINT11889 nd853 nd884 3.799497685185e+04
RINT11890 nd854 nd885 3.799497685185e+04
RINT11891 nd855 nd886 1.200279881138e+04
RINT11892 nd856 nd887 8.633080870696e+02
RINT11893 nd857 nd888 1.914946833333e+04
RINT11894 nd858 nd889 7.978945138889e+01
RINT11895 nd859 nd890 7.978945138889e+01
RINT11896 nd860 nd891 7.978945138889e+01
RINT11897 nd861 nd892 7.978945138889e+01
RINT11898 nd862 nd893 7.978945138889e+01
RINT11899 nd863 nd894 7.978945138889e+01
RINT11900 nd864 nd895 7.978945138889e+01
RINT11901 nd865 nd896 7.978945138889e+01
RINT11902 nd866 nd897 7.978945138889e+01
RINT11903 nd867 nd898 7.978945138889e+01
RINT11904 nd868 nd899 1.282616767136e+02
RINT11905 nd869 nd900 1.107545883941e+02
RINT11906 nd870 nd901 1.107545883941e+02
RINT11907 nd871 nd902 6.425829603070e+03
RINT11908 nd872 nd903 2.279517697008e+02
RINT11909 nd873 nd904 2.295640559441e+02
RINT11910 nd874 nd905 2.295640559441e+02
RINT11911 nd875 nd906 5.984208854167e+05
RINT11912 nd876 nd907 9.973681423611e+04
RINT11913 nd877 nd908 1.709773958333e+05
RINT11914 nd878 nd909 1.709773958333e+05
RINT11915 nd879 nd910 1.709773958333e+05
RINT11916 nd880 nd911 1.709773958333e+05
RINT11917 nd881 nd912 1.709773958333e+05
RINT11918 nd882 nd913 1.709773958333e+05
RINT11919 nd883 nd914 1.709773958333e+05
RINT11920 nd884 nd915 3.799497685185e+04
RINT11921 nd885 nd916 3.799497685185e+04
RINT11922 nd886 nd917 1.200279881138e+04
RINT11923 nd887 nd918 8.633080870696e+02
RINT11924 nd888 nd919 1.914946833333e+04
RINT11925 nd889 nd920 7.978945138889e+01
RINT11926 nd890 nd921 7.978945138889e+01
RINT11927 nd891 nd922 7.978945138889e+01
RINT11928 nd892 nd923 7.978945138889e+01
RINT11929 nd893 nd924 7.978945138889e+01
RINT11930 nd894 nd925 7.978945138889e+01
RINT11931 nd895 nd926 7.978945138889e+01
RINT11932 nd896 nd927 7.978945138889e+01
RINT11933 nd897 nd928 7.978945138889e+01
RINT11934 nd898 nd929 7.978945138889e+01
RINT11935 nd899 nd930 1.282616767136e+02
RINT11936 nd900 nd931 1.107545883941e+02
RINT11937 nd901 nd932 1.107545883941e+02
RINT11938 nd902 nd933 6.425829603070e+03
RINT11939 nd903 nd934 2.279517697008e+02
RINT11940 nd904 nd935 2.295640559441e+02
RINT11941 nd905 nd936 2.295640559441e+02
RINT11942 nd906 nd937 5.984208854167e+05
RINT11943 nd907 nd938 9.973681423611e+04
RINT11944 nd908 nd939 1.709773958333e+05
RINT11945 nd909 nd940 1.709773958333e+05
RINT11946 nd910 nd941 1.709773958333e+05
RINT11947 nd911 nd942 1.709773958333e+05
RINT11948 nd912 nd943 1.709773958333e+05
RINT11949 nd913 nd944 1.709773958333e+05
RINT11950 nd914 nd945 1.709773958333e+05
RINT11951 nd915 nd946 3.799497685185e+04
RINT11952 nd916 nd947 3.799497685185e+04
RINT11953 nd917 nd948 1.200279881138e+04
RINT11954 nd918 nd949 8.633080870696e+02
RINT11955 nd919 nd950 1.914946833333e+04
RINT11956 nd920 nd951 7.978945138889e+01
RINT11957 nd921 nd952 7.978945138889e+01
RINT11958 nd922 nd953 7.978945138889e+01
RINT11959 nd923 nd954 7.978945138889e+01
RINT11960 nd924 nd955 7.978945138889e+01
RINT11961 nd925 nd956 7.978945138889e+01
RINT11962 nd926 nd957 7.978945138889e+01
RINT11963 nd927 nd958 7.978945138889e+01
RINT11964 nd928 nd959 7.978945138889e+01
RINT11965 nd929 nd960 7.978945138889e+01
RINT11966 nd930 nd961 7.082876200045e+01
RINT11967 nd931 nd962 6.116098419125e+01
RINT11968 nd932 nd963 6.116098419125e+01
RINT11969 nd933 nd964 3.548476577518e+03
RINT11970 nd934 nd965 1.258797020078e+02
RINT11971 nd935 nd966 1.267700399600e+02
RINT11972 nd936 nd967 1.267700399600e+02
RINT11973 nd937 nd968 3.304604427083e+05
RINT11974 nd938 nd969 5.507674045139e+04
RINT11975 nd939 nd970 9.441726934524e+04
RINT11976 nd940 nd971 9.441726934524e+04
RINT11977 nd941 nd972 9.441726934524e+04
RINT11978 nd942 nd973 9.441726934524e+04
RINT11979 nd943 nd974 9.441726934524e+04
RINT11980 nd944 nd975 9.441726934524e+04
RINT11981 nd945 nd976 9.441726934524e+04
RINT11982 nd946 nd977 2.098161541005e+04
RINT11983 nd947 nd978 2.098161541005e+04
RINT11984 nd948 nd979 6.628194813396e+03
RINT11985 nd949 nd980 4.767366574247e+02
RINT11986 nd950 nd981 1.057473416667e+04
RINT11987 nd951 nd982 4.406139236111e+01
RINT11988 nd952 nd983 4.406139236111e+01
RINT11989 nd953 nd984 4.406139236111e+01
RINT11990 nd954 nd985 4.406139236111e+01
RINT11991 nd955 nd986 4.406139236111e+01
RINT11992 nd956 nd987 4.406139236111e+01
RINT11993 nd957 nd988 4.406139236111e+01
RINT11994 nd958 nd989 4.406139236111e+01
RINT11995 nd959 nd990 4.406139236111e+01
RINT11996 nd960 nd991 4.406139236111e+01
RINT11997 nd961 nd992 7.082876200045e+01
RINT11998 nd962 nd993 6.116098419125e+01
RINT11999 nd963 nd994 6.116098419125e+01
RINT12000 nd964 nd995 3.548476577518e+03
RINT12001 nd965 nd996 1.258797020078e+02
RINT12002 nd966 nd997 1.267700399600e+02
RINT12003 nd967 nd998 1.267700399600e+02
RINT12004 nd968 nd999 3.304604427083e+05
RINT12005 nd969 nd1000 5.507674045139e+04
RINT12006 nd970 nd1001 9.441726934524e+04
RINT12007 nd971 nd1002 9.441726934524e+04
RINT12008 nd972 nd1003 9.441726934524e+04
RINT12009 nd973 nd1004 9.441726934524e+04
RINT12010 nd974 nd1005 9.441726934524e+04
RINT12011 nd975 nd1006 9.441726934524e+04
RINT12012 nd976 nd1007 9.441726934524e+04
RINT12013 nd977 nd1008 2.098161541005e+04
RINT12014 nd978 nd1009 2.098161541005e+04
RINT12015 nd979 nd1010 6.628194813396e+03
RINT12016 nd980 nd1011 4.767366574247e+02
RINT12017 nd981 nd1012 1.057473416667e+04
RINT12018 nd982 nd1013 4.406139236111e+01
RINT12019 nd983 nd1014 4.406139236111e+01
RINT12020 nd984 nd1015 4.406139236111e+01
RINT12021 nd985 nd1016 4.406139236111e+01
RINT12022 nd986 nd1017 4.406139236111e+01
RINT12023 nd987 nd1018 4.406139236111e+01
RINT12024 nd988 nd1019 4.406139236111e+01
RINT12025 nd989 nd1020 4.406139236111e+01
RINT12026 nd990 nd1021 4.406139236111e+01
RINT12027 nd991 nd1022 4.406139236111e+01
RINT12028 nd992 nd1023 1.282616767136e+02
RINT12029 nd993 nd1024 1.107545883941e+02
RINT12030 nd994 nd1025 1.107545883941e+02
RINT12031 nd995 nd1026 6.425829603070e+03
RINT12032 nd996 nd1027 2.279517697008e+02
RINT12033 nd997 nd1028 2.295640559441e+02
RINT12034 nd998 nd1029 2.295640559441e+02
RINT12035 nd999 nd1030 5.984208854167e+05
RINT12036 nd1000 nd1031 9.973681423611e+04
RINT12037 nd1001 nd1032 1.709773958333e+05
RINT12038 nd1002 nd1033 1.709773958333e+05
RINT12039 nd1003 nd1034 1.709773958333e+05
RINT12040 nd1004 nd1035 1.709773958333e+05
RINT12041 nd1005 nd1036 1.709773958333e+05
RINT12042 nd1006 nd1037 1.709773958333e+05
RINT12043 nd1007 nd1038 1.709773958333e+05
RINT12044 nd1008 nd1039 3.799497685185e+04
RINT12045 nd1009 nd1040 3.799497685185e+04
RINT12046 nd1010 nd1041 1.200279881138e+04
RINT12047 nd1011 nd1042 8.633080870696e+02
RINT12048 nd1012 nd1043 1.914946833333e+04
RINT12049 nd1013 nd1044 7.978945138889e+01
RINT12050 nd1014 nd1045 7.978945138889e+01
RINT12051 nd1015 nd1046 7.978945138889e+01
RINT12052 nd1016 nd1047 7.978945138889e+01
RINT12053 nd1017 nd1048 7.978945138889e+01
RINT12054 nd1018 nd1049 7.978945138889e+01
RINT12055 nd1019 nd1050 7.978945138889e+01
RINT12056 nd1020 nd1051 7.978945138889e+01
RINT12057 nd1021 nd1052 7.978945138889e+01
RINT12058 nd1022 nd1053 7.978945138889e+01
RINT12059 nd1023 nd1054 1.282616767136e+02
RINT12060 nd1024 nd1055 1.107545883941e+02
RINT12061 nd1025 nd1056 1.107545883941e+02
RINT12062 nd1026 nd1057 6.425829603070e+03
RINT12063 nd1027 nd1058 2.279517697008e+02
RINT12064 nd1028 nd1059 2.295640559441e+02
RINT12065 nd1029 nd1060 2.295640559441e+02
RINT12066 nd1030 nd1061 5.984208854167e+05
RINT12067 nd1031 nd1062 9.973681423611e+04
RINT12068 nd1032 nd1063 1.709773958333e+05
RINT12069 nd1033 nd1064 1.709773958333e+05
RINT12070 nd1034 nd1065 1.709773958333e+05
RINT12071 nd1035 nd1066 1.709773958333e+05
RINT12072 nd1036 nd1067 1.709773958333e+05
RINT12073 nd1037 nd1068 1.709773958333e+05
RINT12074 nd1038 nd1069 1.709773958333e+05
RINT12075 nd1039 nd1070 3.799497685185e+04
RINT12076 nd1040 nd1071 3.799497685185e+04
RINT12077 nd1041 nd1072 1.200279881138e+04
RINT12078 nd1042 nd1073 8.633080870696e+02
RINT12079 nd1043 nd1074 1.914946833333e+04
RINT12080 nd1044 nd1075 7.978945138889e+01
RINT12081 nd1045 nd1076 7.978945138889e+01
RINT12082 nd1046 nd1077 7.978945138889e+01
RINT12083 nd1047 nd1078 7.978945138889e+01
RINT12084 nd1048 nd1079 7.978945138889e+01
RINT12085 nd1049 nd1080 7.978945138889e+01
RINT12086 nd1050 nd1081 7.978945138889e+01
RINT12087 nd1051 nd1082 7.978945138889e+01
RINT12088 nd1052 nd1083 7.978945138889e+01
RINT12089 nd1053 nd1084 7.978945138889e+01
RINT12090 nd1054 nd1085 1.282616767136e+02
RINT12091 nd1055 nd1086 1.107545883941e+02
RINT12092 nd1056 nd1087 1.107545883941e+02
RINT12093 nd1057 nd1088 6.425829603070e+03
RINT12094 nd1058 nd1089 2.279517697008e+02
RINT12095 nd1059 nd1090 2.295640559441e+02
RINT12096 nd1060 nd1091 2.295640559441e+02
RINT12097 nd1061 nd1092 5.984208854167e+05
RINT12098 nd1062 nd1093 9.973681423611e+04
RINT12099 nd1063 nd1094 1.709773958333e+05
RINT12100 nd1064 nd1095 1.709773958333e+05
RINT12101 nd1065 nd1096 1.709773958333e+05
RINT12102 nd1066 nd1097 1.709773958333e+05
RINT12103 nd1067 nd1098 1.709773958333e+05
RINT12104 nd1068 nd1099 1.709773958333e+05
RINT12105 nd1069 nd1100 1.709773958333e+05
RINT12106 nd1070 nd1101 3.799497685185e+04
RINT12107 nd1071 nd1102 3.799497685185e+04
RINT12108 nd1072 nd1103 1.200279881138e+04
RINT12109 nd1073 nd1104 8.633080870696e+02
RINT12110 nd1074 nd1105 1.914946833333e+04
RINT12111 nd1075 nd1106 7.978945138889e+01
RINT12112 nd1076 nd1107 7.978945138889e+01
RINT12113 nd1077 nd1108 7.978945138889e+01
RINT12114 nd1078 nd1109 7.978945138889e+01
RINT12115 nd1079 nd1110 7.978945138889e+01
RINT12116 nd1080 nd1111 7.978945138889e+01
RINT12117 nd1081 nd1112 7.978945138889e+01
RINT12118 nd1082 nd1113 7.978945138889e+01
RINT12119 nd1083 nd1114 7.978945138889e+01
RINT12120 nd1084 nd1115 7.978945138889e+01
RINT12121 nd1085 nd1116 1.282616767136e+02
RINT12122 nd1086 nd1117 1.107545883941e+02
RINT12123 nd1087 nd1118 1.107545883941e+02
RINT12124 nd1088 nd1119 6.425829603070e+03
RINT12125 nd1089 nd1120 2.279517697008e+02
RINT12126 nd1090 nd1121 2.295640559441e+02
RINT12127 nd1091 nd1122 2.295640559441e+02
RINT12128 nd1092 nd1123 5.984208854167e+05
RINT12129 nd1093 nd1124 9.973681423611e+04
RINT12130 nd1094 nd1125 1.709773958333e+05
RINT12131 nd1095 nd1126 1.709773958333e+05
RINT12132 nd1096 nd1127 1.709773958333e+05
RINT12133 nd1097 nd1128 1.709773958333e+05
RINT12134 nd1098 nd1129 1.709773958333e+05
RINT12135 nd1099 nd1130 1.709773958333e+05
RINT12136 nd1100 nd1131 1.709773958333e+05
RINT12137 nd1101 nd1132 3.799497685185e+04
RINT12138 nd1102 nd1133 3.799497685185e+04
RINT12139 nd1103 nd1134 1.200279881138e+04
RINT12140 nd1104 nd1135 8.633080870696e+02
RINT12141 nd1105 nd1136 1.914946833333e+04
RINT12142 nd1106 nd1137 7.978945138889e+01
RINT12143 nd1107 nd1138 7.978945138889e+01
RINT12144 nd1108 nd1139 7.978945138889e+01
RINT12145 nd1109 nd1140 7.978945138889e+01
RINT12146 nd1110 nd1141 7.978945138889e+01
RINT12147 nd1111 nd1142 7.978945138889e+01
RINT12148 nd1112 nd1143 7.978945138889e+01
RINT12149 nd1113 nd1144 7.978945138889e+01
RINT12150 nd1114 nd1145 7.978945138889e+01
RINT12151 nd1115 nd1146 7.978945138889e+01
RINT12152 nd1116 nd1147 1.282616767136e+02
RINT12153 nd1117 nd1148 1.107545883941e+02
RINT12154 nd1118 nd1149 1.107545883941e+02
RINT12155 nd1119 nd1150 6.425829603070e+03
RINT12156 nd1120 nd1151 2.279517697008e+02
RINT12157 nd1121 nd1152 2.295640559441e+02
RINT12158 nd1122 nd1153 2.295640559441e+02
RINT12159 nd1123 nd1154 5.984208854167e+05
RINT12160 nd1124 nd1155 9.973681423611e+04
RINT12161 nd1125 nd1156 1.709773958333e+05
RINT12162 nd1126 nd1157 1.709773958333e+05
RINT12163 nd1127 nd1158 1.709773958333e+05
RINT12164 nd1128 nd1159 1.709773958333e+05
RINT12165 nd1129 nd1160 1.709773958333e+05
RINT12166 nd1130 nd1161 1.709773958333e+05
RINT12167 nd1131 nd1162 1.709773958333e+05
RINT12168 nd1132 nd1163 3.799497685185e+04
RINT12169 nd1133 nd1164 3.799497685185e+04
RINT12170 nd1134 nd1165 1.200279881138e+04
RINT12171 nd1135 nd1166 8.633080870696e+02
RINT12172 nd1136 nd1167 1.914946833333e+04
RINT12173 nd1137 nd1168 7.978945138889e+01
RINT12174 nd1138 nd1169 7.978945138889e+01
RINT12175 nd1139 nd1170 7.978945138889e+01
RINT12176 nd1140 nd1171 7.978945138889e+01
RINT12177 nd1141 nd1172 7.978945138889e+01
RINT12178 nd1142 nd1173 7.978945138889e+01
RINT12179 nd1143 nd1174 7.978945138889e+01
RINT12180 nd1144 nd1175 7.978945138889e+01
RINT12181 nd1145 nd1176 7.978945138889e+01
RINT12182 nd1146 nd1177 7.978945138889e+01
RINT12183 nd1147 nd1178 7.082876200045e+01
RINT12184 nd1148 nd1179 6.116098419125e+01
RINT12185 nd1149 nd1180 6.116098419125e+01
RINT12186 nd1150 nd1181 3.548476577518e+03
RINT12187 nd1151 nd1182 1.258797020078e+02
RINT12188 nd1152 nd1183 1.267700399600e+02
RINT12189 nd1153 nd1184 1.267700399600e+02
RINT12190 nd1154 nd1185 3.304604427083e+05
RINT12191 nd1155 nd1186 5.507674045139e+04
RINT12192 nd1156 nd1187 9.441726934524e+04
RINT12193 nd1157 nd1188 9.441726934524e+04
RINT12194 nd1158 nd1189 9.441726934524e+04
RINT12195 nd1159 nd1190 9.441726934524e+04
RINT12196 nd1160 nd1191 9.441726934524e+04
RINT12197 nd1161 nd1192 9.441726934524e+04
RINT12198 nd1162 nd1193 9.441726934524e+04
RINT12199 nd1163 nd1194 2.098161541005e+04
RINT12200 nd1164 nd1195 2.098161541005e+04
RINT12201 nd1165 nd1196 6.628194813396e+03
RINT12202 nd1166 nd1197 4.767366574247e+02
RINT12203 nd1167 nd1198 1.057473416667e+04
RINT12204 nd1168 nd1199 4.406139236111e+01
RINT12205 nd1169 nd1200 4.406139236111e+01
RINT12206 nd1170 nd1201 4.406139236111e+01
RINT12207 nd1171 nd1202 4.406139236111e+01
RINT12208 nd1172 nd1203 4.406139236111e+01
RINT12209 nd1173 nd1204 4.406139236111e+01
RINT12210 nd1174 nd1205 4.406139236111e+01
RINT12211 nd1175 nd1206 4.406139236111e+01
RINT12212 nd1176 nd1207 4.406139236111e+01
RINT12213 nd1177 nd1208 4.406139236111e+01
RINT12214 nd1178 nd1209 5.593547666890e+01
RINT12215 nd1179 nd1210 4.830055909003e+01
RINT12216 nd1180 nd1211 4.830055909003e+01
RINT12217 nd1181 nd1212 2.802332318199e+03
RINT12218 nd1182 nd1213 9.941076105071e+01
RINT12219 nd1183 nd1214 1.001138861139e+02
RINT12220 nd1184 nd1215 1.001138861139e+02
RINT12221 nd1185 nd1216 3.475055555556e+04
RINT12222 nd1186 nd1217 5.791759259259e+03
RINT12223 nd1187 nd1218 9.928730158730e+03
RINT12224 nd1188 nd1219 9.928730158730e+03
RINT12225 nd1189 nd1220 9.928730158730e+03
RINT12226 nd1190 nd1221 9.928730158730e+03
RINT12227 nd1191 nd1222 9.928730158730e+03
RINT12228 nd1192 nd1223 9.928730158730e+03
RINT12229 nd1193 nd1224 9.928730158730e+03
RINT12230 nd1194 nd1225 2.206384479718e+03
RINT12231 nd1195 nd1226 2.206384479718e+03
RINT12232 nd1196 nd1227 5.234472915668e+03
RINT12233 nd1197 nd1228 3.764924223640e+02
RINT12234 nd1198 nd1229 8.351166666667e+03
RINT12235 nd1199 nd1230 3.479652777778e+01
RINT12236 nd1200 nd1231 3.479652777778e+01
RINT12237 nd1201 nd1232 3.479652777778e+01
RINT12238 nd1202 nd1233 3.479652777778e+01
RINT12239 nd1203 nd1234 3.479652777778e+01
RINT12240 nd1204 nd1235 3.479652777778e+01
RINT12241 nd1205 nd1236 3.479652777778e+01
RINT12242 nd1206 nd1237 3.479652777778e+01
RINT12243 nd1207 nd1238 3.479652777778e+01
RINT12244 nd1208 nd1239 3.479652777778e+01
RINT12245 nd1209 nd1240 9.847510605046e+01
RINT12246 nd1210 nd1241 8.503373819163e+01
RINT12247 nd1211 nd1242 8.503373819163e+01
RINT12248 nd1212 nd1243 4.933541084432e+03
RINT12249 nd1213 nd1244 1.750138877867e+02
RINT12250 nd1214 nd1245 1.762517482517e+02
RINT12251 nd1215 nd1246 1.762517482517e+02
RINT12252 nd1216 nd1247 7.001111111111e+03
RINT12253 nd1217 nd1248 1.166851851852e+03
RINT12254 nd1218 nd1249 2.000317460317e+03
RINT12255 nd1219 nd1250 2.000317460317e+03
RINT12256 nd1220 nd1251 2.000317460317e+03
RINT12257 nd1221 nd1252 2.000317460317e+03
RINT12258 nd1222 nd1253 2.000317460317e+03
RINT12259 nd1223 nd1254 2.000317460317e+03
RINT12260 nd1224 nd1255 2.000317460317e+03
RINT12261 nd1225 nd1256 4.445149911817e+02
RINT12262 nd1226 nd1257 4.445149911817e+02
RINT12263 nd1227 nd1258 9.215355015920e+03
RINT12264 nd1228 nd1259 6.628196169481e+02
RINT12265 nd1229 nd1260 1.470233333333e+04
RINT12266 nd1230 nd1261 6.125972222222e+01
RINT12267 nd1231 nd1262 6.125972222222e+01
RINT12268 nd1232 nd1263 6.125972222222e+01
RINT12269 nd1233 nd1264 6.125972222222e+01
RINT12270 nd1234 nd1265 6.125972222222e+01
RINT12271 nd1235 nd1266 6.125972222222e+01
RINT12272 nd1236 nd1267 6.125972222222e+01
RINT12273 nd1237 nd1268 6.125972222222e+01
RINT12274 nd1238 nd1269 6.125972222222e+01
RINT12275 nd1239 nd1270 6.125972222222e+01
RINT12276 nd1240 nd1271 9.847510605046e+01
RINT12277 nd1241 nd1272 8.503373819163e+01
RINT12278 nd1242 nd1273 8.503373819163e+01
RINT12279 nd1243 nd1274 4.933541084432e+03
RINT12280 nd1244 nd1275 1.750138877867e+02
RINT12281 nd1245 nd1276 1.762517482517e+02
RINT12282 nd1246 nd1277 1.762517482517e+02
RINT12283 nd1247 nd1278 7.001111111111e+03
RINT12284 nd1248 nd1279 1.166851851852e+03
RINT12285 nd1249 nd1280 2.000317460317e+03
RINT12286 nd1250 nd1281 2.000317460317e+03
RINT12287 nd1251 nd1282 2.000317460317e+03
RINT12288 nd1252 nd1283 2.000317460317e+03
RINT12289 nd1253 nd1284 2.000317460317e+03
RINT12290 nd1254 nd1285 2.000317460317e+03
RINT12291 nd1255 nd1286 2.000317460317e+03
RINT12292 nd1256 nd1287 4.445149911817e+02
RINT12293 nd1257 nd1288 4.445149911817e+02
RINT12294 nd1258 nd1289 9.215355015920e+03
RINT12295 nd1259 nd1290 6.628196169481e+02
RINT12296 nd1260 nd1291 1.470233333333e+04
RINT12297 nd1261 nd1292 6.125972222222e+01
RINT12298 nd1262 nd1293 6.125972222222e+01
RINT12299 nd1263 nd1294 6.125972222222e+01
RINT12300 nd1264 nd1295 6.125972222222e+01
RINT12301 nd1265 nd1296 6.125972222222e+01
RINT12302 nd1266 nd1297 6.125972222222e+01
RINT12303 nd1267 nd1298 6.125972222222e+01
RINT12304 nd1268 nd1299 6.125972222222e+01
RINT12305 nd1269 nd1300 6.125972222222e+01
RINT12306 nd1270 nd1301 6.125972222222e+01
RINT12307 nd1302 nd1333 1.042035668855e+01
RINT12308 nd1303 nd1334 8.998029228461e+00
RINT12309 nd1304 nd1335 8.998029228461e+00
RINT12310 nd1305 nd1336 5.220533381408e+02
RINT12311 nd1306 nd1337 1.851947369575e+01
RINT12312 nd1307 nd1338 1.865046058263e+01
RINT12313 nd1308 nd1339 1.865046058263e+01
RINT12314 nd1309 nd1340 7.408377398100e+02
RINT12315 nd1310 nd1341 1.234729566350e+02
RINT12316 nd1311 nd1342 2.116679256600e+02
RINT12317 nd1312 nd1343 2.116679256600e+02
RINT12318 nd1313 nd1344 2.116679256600e+02
RINT12319 nd1314 nd1345 2.116679256600e+02
RINT12320 nd1315 nd1346 2.116679256600e+02
RINT12321 nd1316 nd1347 2.116679256600e+02
RINT12322 nd1317 nd1348 2.116679256600e+02
RINT12323 nd1318 nd1349 4.703731681333e+01
RINT12324 nd1319 nd1350 4.703731681333e+01
RINT12325 nd1320 nd1351 9.751427556557e+02
RINT12326 nd1321 nd1352 7.013769373582e+01
RINT12327 nd1322 nd1353 1.555759253601e+03
RINT12328 nd1323 nd1354 6.482330223337e+00
RINT12329 nd1324 nd1355 6.482330223337e+00
RINT12330 nd1325 nd1356 6.482330223337e+00
RINT12331 nd1326 nd1357 6.482330223337e+00
RINT12332 nd1327 nd1358 6.482330223337e+00
RINT12333 nd1328 nd1359 6.482330223337e+00
RINT12334 nd1329 nd1360 6.482330223337e+00
RINT12335 nd1330 nd1361 6.482330223337e+00
RINT12336 nd1331 nd1362 6.482330223337e+00
RINT12337 nd1332 nd1363 6.482330223337e+00
RINT12338 nd1333 nd1364 1.042035668855e+01
RINT12339 nd1334 nd1365 8.998029228461e+00
RINT12340 nd1335 nd1366 8.998029228461e+00
RINT12341 nd1336 nd1367 5.220533381408e+02
RINT12342 nd1337 nd1368 1.851947369575e+01
RINT12343 nd1338 nd1369 1.865046058263e+01
RINT12344 nd1339 nd1370 1.865046058263e+01
RINT12345 nd1340 nd1371 7.408377398100e+02
RINT12346 nd1341 nd1372 1.234729566350e+02
RINT12347 nd1342 nd1373 2.116679256600e+02
RINT12348 nd1343 nd1374 2.116679256600e+02
RINT12349 nd1344 nd1375 2.116679256600e+02
RINT12350 nd1345 nd1376 2.116679256600e+02
RINT12351 nd1346 nd1377 2.116679256600e+02
RINT12352 nd1347 nd1378 2.116679256600e+02
RINT12353 nd1348 nd1379 2.116679256600e+02
RINT12354 nd1349 nd1380 4.703731681333e+01
RINT12355 nd1350 nd1381 4.703731681333e+01
RINT12356 nd1351 nd1382 9.751427556557e+02
RINT12357 nd1352 nd1383 7.013769373582e+01
RINT12358 nd1353 nd1384 1.555759253601e+03
RINT12359 nd1354 nd1385 6.482330223337e+00
RINT12360 nd1355 nd1386 6.482330223337e+00
RINT12361 nd1356 nd1387 6.482330223337e+00
RINT12362 nd1357 nd1388 6.482330223337e+00
RINT12363 nd1358 nd1389 6.482330223337e+00
RINT12364 nd1359 nd1390 6.482330223337e+00
RINT12365 nd1360 nd1391 6.482330223337e+00
RINT12366 nd1361 nd1392 6.482330223337e+00
RINT12367 nd1362 nd1393 6.482330223337e+00
RINT12368 nd1363 nd1394 6.482330223337e+00
RINT12369 nd1364 nd1395 5.918933645377e+00
RINT12370 nd1365 nd1396 5.111028301069e+00
RINT12371 nd1366 nd1397 5.111028301069e+00
RINT12372 nd1367 nd1398 2.965348653754e+02
RINT12373 nd1368 nd1399 1.051936504946e+01
RINT12374 nd1369 nd1400 1.059376775131e+01
RINT12375 nd1370 nd1401 1.059376775131e+01
RINT12376 nd1371 nd1402 3.677205321604e+03
RINT12377 nd1372 nd1403 6.128675536007e+02
RINT12378 nd1373 nd1404 1.050630091887e+03
RINT12379 nd1374 nd1405 1.050630091887e+03
RINT12380 nd1375 nd1406 1.050630091887e+03
RINT12381 nd1376 nd1407 1.050630091887e+03
RINT12382 nd1377 nd1408 1.050630091887e+03
RINT12383 nd1378 nd1409 1.050630091887e+03
RINT12384 nd1379 nd1410 1.050630091887e+03
RINT12385 nd1380 nd1411 2.334733537526e+02
RINT12386 nd1381 nd1412 2.334733537526e+02
RINT12387 nd1382 nd1413 5.538970918181e+02
RINT12388 nd1383 nd1414 3.983936132610e+01
RINT12389 nd1384 nd1415 8.836967932549e+02
RINT12390 nd1385 nd1416 3.682069971895e+00
RINT12391 nd1386 nd1417 3.682069971895e+00
RINT12392 nd1387 nd1418 3.682069971895e+00
RINT12393 nd1388 nd1419 3.682069971895e+00
RINT12394 nd1389 nd1420 3.682069971895e+00
RINT12395 nd1390 nd1421 3.682069971895e+00
RINT12396 nd1391 nd1422 3.682069971895e+00
RINT12397 nd1392 nd1423 3.682069971895e+00
RINT12398 nd1393 nd1424 3.682069971895e+00
RINT12399 nd1394 nd1425 3.682069971895e+00
RINT12400 nd1395 nd1426 7.494898898358e+00
RINT12401 nd1396 nd1427 6.471882044678e+00
RINT12402 nd1397 nd1428 6.471882044678e+00
RINT12403 nd1398 nd1429 3.754897366627e+02
RINT12404 nd1399 nd1430 1.332023338058e+01
RINT12405 nd1400 nd1431 1.341444641988e+01
RINT12406 nd1401 nd1432 1.341444641988e+01
RINT12407 nd1402 nd1433 3.942767563891e+03
RINT12408 nd1403 nd1434 6.216370766103e+02
RINT12409 nd1404 nd1435 1.083955004199e+03
RINT12410 nd1405 nd1436 1.083955004199e+03
RINT12411 nd1406 nd1437 1.083955004199e+03
RINT12412 nd1407 nd1438 1.083955004199e+03
RINT12413 nd1408 nd1439 1.083955004199e+03
RINT12414 nd1409 nd1440 1.083955004199e+03
RINT12415 nd1410 nd1441 1.083955004199e+03
RINT12416 nd1411 nd1442 2.368141244230e+02
RINT12417 nd1412 nd1443 2.376222816265e+02
RINT12418 nd1413 nd1444 7.013767938611e+02
RINT12419 nd1414 nd1445 5.044692223361e+01
RINT12420 nd1415 nd1446 1.118988405525e+03
RINT12421 nd1416 nd1447 4.662451689687e+00
RINT12422 nd1417 nd1448 4.662451689687e+00
RINT12423 nd1418 nd1449 4.662451689687e+00
RINT12424 nd1419 nd1450 4.662451689687e+00
RINT12425 nd1420 nd1451 4.662451689687e+00
RINT12426 nd1421 nd1452 4.662451689687e+00
RINT12427 nd1422 nd1453 4.662451689687e+00
RINT12428 nd1423 nd1454 4.662451689687e+00
RINT12429 nd1424 nd1455 4.662451689687e+00
RINT12430 nd1425 nd1456 4.662451689687e+00
RINT12431 nd1426 nd1457 1.357228719451e+01
RINT12432 nd1427 nd1458 1.171973671568e+01
RINT12433 nd1428 nd1459 1.171973671568e+01
RINT12434 nd1429 nd1460 6.799630807155e+02
RINT12435 nd1430 nd1461 2.412121035800e+01
RINT12436 nd1431 nd1462 2.429181791977e+01
RINT12437 nd1432 nd1463 2.429181791977e+01
RINT12438 nd1433 nd1464 1.271962224384e+03
RINT12439 nd1434 nd1465 1.410120026542e+02
RINT12440 nd1435 nd1466 2.783177502845e+02
RINT12441 nd1436 nd1467 2.783177502845e+02
RINT12442 nd1437 nd1468 2.783177502845e+02
RINT12443 nd1438 nd1469 2.783177502845e+02
RINT12444 nd1439 nd1470 2.783177502845e+02
RINT12445 nd1440 nd1471 2.783177502845e+02
RINT12446 nd1441 nd1472 2.783177502845e+02
RINT12447 nd1442 nd1473 5.371885815399e+01
RINT12448 nd1443 nd1474 5.533517256115e+01
RINT12449 nd1444 nd1475 1.270102159742e+03
RINT12450 nd1445 nd1476 9.135281555084e+01
RINT12451 nd1446 nd1477 2.026342478141e+03
RINT12452 nd1447 nd1478 8.443093658921e+00
RINT12453 nd1448 nd1479 8.443093658921e+00
RINT12454 nd1449 nd1480 8.443093658921e+00
RINT12455 nd1450 nd1481 8.443093658921e+00
RINT12456 nd1451 nd1482 8.443093658921e+00
RINT12457 nd1452 nd1483 8.443093658921e+00
RINT12458 nd1453 nd1484 8.443093658921e+00
RINT12459 nd1454 nd1485 8.443093658921e+00
RINT12460 nd1455 nd1486 8.443093658921e+00
RINT12461 nd1456 nd1487 8.443093658921e+00
RINT12462 nd1457 nd1488 1.357228719451e+01
RINT12463 nd1458 nd1489 1.171973671568e+01
RINT12464 nd1459 nd1490 1.171973671568e+01
RINT12465 nd1460 nd1491 6.799630807155e+02
RINT12466 nd1461 nd1492 2.412121035800e+01
RINT12467 nd1462 nd1493 2.429181791977e+01
RINT12468 nd1463 nd1494 2.429181791977e+01
RINT12469 nd1464 nd1495 1.271962224384e+03
RINT12470 nd1465 nd1496 1.410120026542e+02
RINT12471 nd1466 nd1497 2.783177502845e+02
RINT12472 nd1467 nd1498 2.783177502845e+02
RINT12473 nd1468 nd1499 2.783177502845e+02
RINT12474 nd1469 nd1500 2.783177502845e+02
RINT12475 nd1470 nd1501 2.783177502845e+02
RINT12476 nd1471 nd1502 2.783177502845e+02
RINT12477 nd1472 nd1503 2.783177502845e+02
RINT12478 nd1473 nd1504 5.371885815399e+01
RINT12479 nd1474 nd1505 5.533517256115e+01
RINT12480 nd1475 nd1506 1.270102159742e+03
RINT12481 nd1476 nd1507 9.135281555084e+01
RINT12482 nd1477 nd1508 2.026342478141e+03
RINT12483 nd1478 nd1509 8.443093658921e+00
RINT12484 nd1479 nd1510 8.443093658921e+00
RINT12485 nd1480 nd1511 8.443093658921e+00
RINT12486 nd1481 nd1512 8.443093658921e+00
RINT12487 nd1482 nd1513 8.443093658921e+00
RINT12488 nd1483 nd1514 8.443093658921e+00
RINT12489 nd1484 nd1515 8.443093658921e+00
RINT12490 nd1485 nd1516 8.443093658921e+00
RINT12491 nd1486 nd1517 8.443093658921e+00
RINT12492 nd1487 nd1518 8.443093658921e+00
RINT12493 nd1488 nd1519 1.357228719451e+01
RINT12494 nd1489 nd1520 1.171973671568e+01
RINT12495 nd1490 nd1521 1.171973671568e+01
RINT12496 nd1491 nd1522 6.799630807155e+02
RINT12497 nd1492 nd1523 2.412121035800e+01
RINT12498 nd1493 nd1524 2.429181791977e+01
RINT12499 nd1494 nd1525 2.429181791977e+01
RINT12500 nd1495 nd1526 1.271962224384e+03
RINT12501 nd1496 nd1527 1.410120026542e+02
RINT12502 nd1497 nd1528 2.783177502845e+02
RINT12503 nd1498 nd1529 2.783177502845e+02
RINT12504 nd1499 nd1530 2.783177502845e+02
RINT12505 nd1500 nd1531 2.783177502845e+02
RINT12506 nd1501 nd1532 2.783177502845e+02
RINT12507 nd1502 nd1533 2.783177502845e+02
RINT12508 nd1503 nd1534 2.783177502845e+02
RINT12509 nd1504 nd1535 5.371885815399e+01
RINT12510 nd1505 nd1536 5.533517256115e+01
RINT12511 nd1506 nd1537 1.270102159742e+03
RINT12512 nd1507 nd1538 9.135281555084e+01
RINT12513 nd1508 nd1539 2.026342478141e+03
RINT12514 nd1509 nd1540 8.443093658921e+00
RINT12515 nd1510 nd1541 8.443093658921e+00
RINT12516 nd1511 nd1542 8.443093658921e+00
RINT12517 nd1512 nd1543 8.443093658921e+00
RINT12518 nd1513 nd1544 8.443093658921e+00
RINT12519 nd1514 nd1545 8.443093658921e+00
RINT12520 nd1515 nd1546 8.443093658921e+00
RINT12521 nd1516 nd1547 8.443093658921e+00
RINT12522 nd1517 nd1548 8.443093658921e+00
RINT12523 nd1518 nd1549 8.443093658921e+00
RINT12524 nd1519 nd1550 1.357228719451e+01
RINT12525 nd1520 nd1551 1.171973671568e+01
RINT12526 nd1521 nd1552 1.171973671568e+01
RINT12527 nd1522 nd1553 6.799630807155e+02
RINT12528 nd1523 nd1554 2.412121035800e+01
RINT12529 nd1524 nd1555 2.429181791977e+01
RINT12530 nd1525 nd1556 2.429181791977e+01
RINT12531 nd1526 nd1557 1.271962224384e+03
RINT12532 nd1527 nd1558 1.410120026542e+02
RINT12533 nd1528 nd1559 2.783177502845e+02
RINT12534 nd1529 nd1560 2.783177502845e+02
RINT12535 nd1530 nd1561 2.783177502845e+02
RINT12536 nd1531 nd1562 2.783177502845e+02
RINT12537 nd1532 nd1563 2.783177502845e+02
RINT12538 nd1533 nd1564 2.783177502845e+02
RINT12539 nd1534 nd1565 2.783177502845e+02
RINT12540 nd1535 nd1566 5.371885815399e+01
RINT12541 nd1536 nd1567 5.533517256115e+01
RINT12542 nd1537 nd1568 1.270102159742e+03
RINT12543 nd1538 nd1569 9.135281555084e+01
RINT12544 nd1539 nd1570 2.026342478141e+03
RINT12545 nd1540 nd1571 8.443093658921e+00
RINT12546 nd1541 nd1572 8.443093658921e+00
RINT12547 nd1542 nd1573 8.443093658921e+00
RINT12548 nd1543 nd1574 8.443093658921e+00
RINT12549 nd1544 nd1575 8.443093658921e+00
RINT12550 nd1545 nd1576 8.443093658921e+00
RINT12551 nd1546 nd1577 8.443093658921e+00
RINT12552 nd1547 nd1578 8.443093658921e+00
RINT12553 nd1548 nd1579 8.443093658921e+00
RINT12554 nd1549 nd1580 8.443093658921e+00
RINT12555 nd1550 nd1581 1.357228719451e+01
RINT12556 nd1551 nd1582 1.171973671568e+01
RINT12557 nd1552 nd1583 1.171973671568e+01
RINT12558 nd1553 nd1584 6.799630807155e+02
RINT12559 nd1554 nd1585 2.412121035800e+01
RINT12560 nd1555 nd1586 2.429181791977e+01
RINT12561 nd1556 nd1587 2.429181791977e+01
RINT12562 nd1557 nd1588 1.271962224384e+03
RINT12563 nd1558 nd1589 1.410120026542e+02
RINT12564 nd1559 nd1590 2.783177502845e+02
RINT12565 nd1560 nd1591 2.783177502845e+02
RINT12566 nd1561 nd1592 2.783177502845e+02
RINT12567 nd1562 nd1593 2.783177502845e+02
RINT12568 nd1563 nd1594 2.783177502845e+02
RINT12569 nd1564 nd1595 2.783177502845e+02
RINT12570 nd1565 nd1596 2.783177502845e+02
RINT12571 nd1566 nd1597 5.371885815399e+01
RINT12572 nd1567 nd1598 5.533517256115e+01
RINT12573 nd1568 nd1599 1.270102159742e+03
RINT12574 nd1569 nd1600 9.135281555084e+01
RINT12575 nd1570 nd1601 2.026342478141e+03
RINT12576 nd1571 nd1602 8.443093658921e+00
RINT12577 nd1572 nd1603 8.443093658921e+00
RINT12578 nd1573 nd1604 8.443093658921e+00
RINT12579 nd1574 nd1605 8.443093658921e+00
RINT12580 nd1575 nd1606 8.443093658921e+00
RINT12581 nd1576 nd1607 8.443093658921e+00
RINT12582 nd1577 nd1608 8.443093658921e+00
RINT12583 nd1578 nd1609 8.443093658921e+00
RINT12584 nd1579 nd1610 8.443093658921e+00
RINT12585 nd1580 nd1611 8.443093658921e+00
RINT12586 nd1581 nd1612 7.494898898358e+00
RINT12587 nd1582 nd1613 6.471882044678e+00
RINT12588 nd1583 nd1614 6.471882044678e+00
RINT12589 nd1584 nd1615 3.754897366627e+02
RINT12590 nd1585 nd1616 1.332023338058e+01
RINT12591 nd1586 nd1617 1.341444641988e+01
RINT12592 nd1587 nd1618 1.341444641988e+01
RINT12593 nd1588 nd1619 3.942767563891e+03
RINT12594 nd1589 nd1620 6.216370766103e+02
RINT12595 nd1590 nd1621 1.083955004199e+03
RINT12596 nd1591 nd1622 1.083955004199e+03
RINT12597 nd1592 nd1623 1.083955004199e+03
RINT12598 nd1593 nd1624 1.083955004199e+03
RINT12599 nd1594 nd1625 1.083955004199e+03
RINT12600 nd1595 nd1626 1.083955004199e+03
RINT12601 nd1596 nd1627 1.083955004199e+03
RINT12602 nd1597 nd1628 2.368141244230e+02
RINT12603 nd1598 nd1629 2.376222816266e+02
RINT12604 nd1599 nd1630 7.013767938611e+02
RINT12605 nd1600 nd1631 5.044692223361e+01
RINT12606 nd1601 nd1632 1.118988405525e+03
RINT12607 nd1602 nd1633 4.662451689687e+00
RINT12608 nd1603 nd1634 4.662451689687e+00
RINT12609 nd1604 nd1635 4.662451689687e+00
RINT12610 nd1605 nd1636 4.662451689687e+00
RINT12611 nd1606 nd1637 4.662451689687e+00
RINT12612 nd1607 nd1638 4.662451689687e+00
RINT12613 nd1608 nd1639 4.662451689687e+00
RINT12614 nd1609 nd1640 4.662451689687e+00
RINT12615 nd1610 nd1641 4.662451689687e+00
RINT12616 nd1611 nd1642 4.662451689687e+00
RINT12617 nd1612 nd1643 7.494898898358e+00
RINT12618 nd1613 nd1644 6.471882044678e+00
RINT12619 nd1614 nd1645 6.471882044678e+00
RINT12620 nd1615 nd1646 3.754897366627e+02
RINT12621 nd1616 nd1647 1.332023338058e+01
RINT12622 nd1617 nd1648 1.341444641988e+01
RINT12623 nd1618 nd1649 1.341444641988e+01
RINT12624 nd1619 nd1650 3.942767563891e+03
RINT12625 nd1620 nd1651 6.216370766103e+02
RINT12626 nd1621 nd1652 1.083955004199e+03
RINT12627 nd1622 nd1653 1.083955004199e+03
RINT12628 nd1623 nd1654 1.083955004199e+03
RINT12629 nd1624 nd1655 1.083955004199e+03
RINT12630 nd1625 nd1656 1.083955004199e+03
RINT12631 nd1626 nd1657 1.083955004199e+03
RINT12632 nd1627 nd1658 1.083955004199e+03
RINT12633 nd1628 nd1659 2.368141244230e+02
RINT12634 nd1629 nd1660 2.376222816266e+02
RINT12635 nd1630 nd1661 7.013767938611e+02
RINT12636 nd1631 nd1662 5.044692223361e+01
RINT12637 nd1632 nd1663 1.118988405525e+03
RINT12638 nd1633 nd1664 4.662451689687e+00
RINT12639 nd1634 nd1665 4.662451689687e+00
RINT12640 nd1635 nd1666 4.662451689687e+00
RINT12641 nd1636 nd1667 4.662451689687e+00
RINT12642 nd1637 nd1668 4.662451689687e+00
RINT12643 nd1638 nd1669 4.662451689687e+00
RINT12644 nd1639 nd1670 4.662451689687e+00
RINT12645 nd1640 nd1671 4.662451689687e+00
RINT12646 nd1641 nd1672 4.662451689687e+00
RINT12647 nd1642 nd1673 4.662451689687e+00
RINT12648 nd1643 nd1674 1.357228719451e+01
RINT12649 nd1644 nd1675 1.171973671568e+01
RINT12650 nd1645 nd1676 1.171973671568e+01
RINT12651 nd1646 nd1677 6.799630807155e+02
RINT12652 nd1647 nd1678 2.412121035800e+01
RINT12653 nd1648 nd1679 2.429181791977e+01
RINT12654 nd1649 nd1680 2.429181791977e+01
RINT12655 nd1650 nd1681 1.271962224384e+03
RINT12656 nd1651 nd1682 1.410120026542e+02
RINT12657 nd1652 nd1683 2.783177502845e+02
RINT12658 nd1653 nd1684 2.783177502845e+02
RINT12659 nd1654 nd1685 2.783177502845e+02
RINT12660 nd1655 nd1686 2.783177502845e+02
RINT12661 nd1656 nd1687 2.783177502845e+02
RINT12662 nd1657 nd1688 2.783177502845e+02
RINT12663 nd1658 nd1689 2.783177502845e+02
RINT12664 nd1659 nd1690 5.371885815399e+01
RINT12665 nd1660 nd1691 5.533517256115e+01
RINT12666 nd1661 nd1692 1.270102159742e+03
RINT12667 nd1662 nd1693 9.135281555084e+01
RINT12668 nd1663 nd1694 2.026342478141e+03
RINT12669 nd1664 nd1695 8.443093658921e+00
RINT12670 nd1665 nd1696 8.443093658921e+00
RINT12671 nd1666 nd1697 8.443093658921e+00
RINT12672 nd1667 nd1698 8.443093658921e+00
RINT12673 nd1668 nd1699 8.443093658921e+00
RINT12674 nd1669 nd1700 8.443093658921e+00
RINT12675 nd1670 nd1701 8.443093658921e+00
RINT12676 nd1671 nd1702 8.443093658921e+00
RINT12677 nd1672 nd1703 8.443093658921e+00
RINT12678 nd1673 nd1704 8.443093658921e+00
RINT12679 nd1674 nd1705 1.357228719451e+01
RINT12680 nd1675 nd1706 1.171973671568e+01
RINT12681 nd1676 nd1707 1.171973671568e+01
RINT12682 nd1677 nd1708 6.799630807155e+02
RINT12683 nd1678 nd1709 2.412121035800e+01
RINT12684 nd1679 nd1710 2.429181791977e+01
RINT12685 nd1680 nd1711 2.429181791977e+01
RINT12686 nd1681 nd1712 1.271962224384e+03
RINT12687 nd1682 nd1713 1.410120026542e+02
RINT12688 nd1683 nd1714 2.783177502845e+02
RINT12689 nd1684 nd1715 2.783177502845e+02
RINT12690 nd1685 nd1716 2.783177502845e+02
RINT12691 nd1686 nd1717 2.783177502845e+02
RINT12692 nd1687 nd1718 2.783177502845e+02
RINT12693 nd1688 nd1719 2.783177502845e+02
RINT12694 nd1689 nd1720 2.783177502845e+02
RINT12695 nd1690 nd1721 5.371885815399e+01
RINT12696 nd1691 nd1722 5.533517256115e+01
RINT12697 nd1692 nd1723 1.270102159742e+03
RINT12698 nd1693 nd1724 9.135281555084e+01
RINT12699 nd1694 nd1725 2.026342478141e+03
RINT12700 nd1695 nd1726 8.443093658921e+00
RINT12701 nd1696 nd1727 8.443093658921e+00
RINT12702 nd1697 nd1728 8.443093658921e+00
RINT12703 nd1698 nd1729 8.443093658921e+00
RINT12704 nd1699 nd1730 8.443093658921e+00
RINT12705 nd1700 nd1731 8.443093658921e+00
RINT12706 nd1701 nd1732 8.443093658921e+00
RINT12707 nd1702 nd1733 8.443093658921e+00
RINT12708 nd1703 nd1734 8.443093658921e+00
RINT12709 nd1704 nd1735 8.443093658921e+00
RINT12710 nd1705 nd1736 1.357228719451e+01
RINT12711 nd1706 nd1737 1.171973671568e+01
RINT12712 nd1707 nd1738 1.171973671568e+01
RINT12713 nd1708 nd1739 6.799630807155e+02
RINT12714 nd1709 nd1740 2.412121035800e+01
RINT12715 nd1710 nd1741 2.429181791977e+01
RINT12716 nd1711 nd1742 2.429181791977e+01
RINT12717 nd1712 nd1743 1.271962224384e+03
RINT12718 nd1713 nd1744 1.410120026542e+02
RINT12719 nd1714 nd1745 2.783177502845e+02
RINT12720 nd1715 nd1746 2.783177502845e+02
RINT12721 nd1716 nd1747 2.783177502845e+02
RINT12722 nd1717 nd1748 2.783177502845e+02
RINT12723 nd1718 nd1749 2.783177502845e+02
RINT12724 nd1719 nd1750 2.783177502845e+02
RINT12725 nd1720 nd1751 2.783177502845e+02
RINT12726 nd1721 nd1752 5.371885815399e+01
RINT12727 nd1722 nd1753 5.533517256115e+01
RINT12728 nd1723 nd1754 1.270102159742e+03
RINT12729 nd1724 nd1755 9.135281555084e+01
RINT12730 nd1725 nd1756 2.026342478141e+03
RINT12731 nd1726 nd1757 8.443093658921e+00
RINT12732 nd1727 nd1758 8.443093658921e+00
RINT12733 nd1728 nd1759 8.443093658921e+00
RINT12734 nd1729 nd1760 8.443093658921e+00
RINT12735 nd1730 nd1761 8.443093658921e+00
RINT12736 nd1731 nd1762 8.443093658921e+00
RINT12737 nd1732 nd1763 8.443093658921e+00
RINT12738 nd1733 nd1764 8.443093658921e+00
RINT12739 nd1734 nd1765 8.443093658921e+00
RINT12740 nd1735 nd1766 8.443093658921e+00
RINT12741 nd1736 nd1767 1.357228719451e+01
RINT12742 nd1737 nd1768 1.171973671568e+01
RINT12743 nd1738 nd1769 1.171973671568e+01
RINT12744 nd1739 nd1770 6.799630807155e+02
RINT12745 nd1740 nd1771 2.412121035800e+01
RINT12746 nd1741 nd1772 2.429181791977e+01
RINT12747 nd1742 nd1773 2.429181791977e+01
RINT12748 nd1743 nd1774 1.271962224384e+03
RINT12749 nd1744 nd1775 1.410120026542e+02
RINT12750 nd1745 nd1776 2.783177502845e+02
RINT12751 nd1746 nd1777 2.783177502845e+02
RINT12752 nd1747 nd1778 2.783177502845e+02
RINT12753 nd1748 nd1779 2.783177502845e+02
RINT12754 nd1749 nd1780 2.783177502845e+02
RINT12755 nd1750 nd1781 2.783177502845e+02
RINT12756 nd1751 nd1782 2.783177502845e+02
RINT12757 nd1752 nd1783 5.371885815399e+01
RINT12758 nd1753 nd1784 5.533517256115e+01
RINT12759 nd1754 nd1785 1.270102159742e+03
RINT12760 nd1755 nd1786 9.135281555084e+01
RINT12761 nd1756 nd1787 2.026342478141e+03
RINT12762 nd1757 nd1788 8.443093658921e+00
RINT12763 nd1758 nd1789 8.443093658921e+00
RINT12764 nd1759 nd1790 8.443093658921e+00
RINT12765 nd1760 nd1791 8.443093658921e+00
RINT12766 nd1761 nd1792 8.443093658921e+00
RINT12767 nd1762 nd1793 8.443093658921e+00
RINT12768 nd1763 nd1794 8.443093658921e+00
RINT12769 nd1764 nd1795 8.443093658921e+00
RINT12770 nd1765 nd1796 8.443093658921e+00
RINT12771 nd1766 nd1797 8.443093658921e+00
RINT12772 nd1767 nd1798 1.357228719451e+01
RINT12773 nd1768 nd1799 1.171973671568e+01
RINT12774 nd1769 nd1800 1.171973671568e+01
RINT12775 nd1770 nd1801 6.799630807155e+02
RINT12776 nd1771 nd1802 2.412121035800e+01
RINT12777 nd1772 nd1803 2.429181791977e+01
RINT12778 nd1773 nd1804 2.429181791977e+01
RINT12779 nd1774 nd1805 1.271962224384e+03
RINT12780 nd1775 nd1806 1.410120026542e+02
RINT12781 nd1776 nd1807 2.783177502845e+02
RINT12782 nd1777 nd1808 2.783177502845e+02
RINT12783 nd1778 nd1809 2.783177502845e+02
RINT12784 nd1779 nd1810 2.783177502845e+02
RINT12785 nd1780 nd1811 2.783177502845e+02
RINT12786 nd1781 nd1812 2.783177502845e+02
RINT12787 nd1782 nd1813 2.783177502845e+02
RINT12788 nd1783 nd1814 5.371885815399e+01
RINT12789 nd1784 nd1815 5.533517256115e+01
RINT12790 nd1785 nd1816 1.270102159742e+03
RINT12791 nd1786 nd1817 9.135281555084e+01
RINT12792 nd1787 nd1818 2.026342478141e+03
RINT12793 nd1788 nd1819 8.443093658921e+00
RINT12794 nd1789 nd1820 8.443093658921e+00
RINT12795 nd1790 nd1821 8.443093658921e+00
RINT12796 nd1791 nd1822 8.443093658921e+00
RINT12797 nd1792 nd1823 8.443093658921e+00
RINT12798 nd1793 nd1824 8.443093658921e+00
RINT12799 nd1794 nd1825 8.443093658921e+00
RINT12800 nd1795 nd1826 8.443093658921e+00
RINT12801 nd1796 nd1827 8.443093658921e+00
RINT12802 nd1797 nd1828 8.443093658921e+00
RINT12803 nd1798 nd1829 7.494898898358e+00
RINT12804 nd1799 nd1830 6.471882044678e+00
RINT12805 nd1800 nd1831 6.471882044678e+00
RINT12806 nd1801 nd1832 3.754897366627e+02
RINT12807 nd1802 nd1833 1.332023338058e+01
RINT12808 nd1803 nd1834 1.341444641988e+01
RINT12809 nd1804 nd1835 1.341444641988e+01
RINT12810 nd1805 nd1836 3.942767563891e+03
RINT12811 nd1806 nd1837 6.216370766103e+02
RINT12812 nd1807 nd1838 1.083955004199e+03
RINT12813 nd1808 nd1839 1.083955004199e+03
RINT12814 nd1809 nd1840 1.083955004199e+03
RINT12815 nd1810 nd1841 1.083955004199e+03
RINT12816 nd1811 nd1842 1.083955004199e+03
RINT12817 nd1812 nd1843 1.083955004199e+03
RINT12818 nd1813 nd1844 1.083955004199e+03
RINT12819 nd1814 nd1845 2.368141244230e+02
RINT12820 nd1815 nd1846 2.376222816266e+02
RINT12821 nd1816 nd1847 7.013767938611e+02
RINT12822 nd1817 nd1848 5.044692223361e+01
RINT12823 nd1818 nd1849 1.118988405525e+03
RINT12824 nd1819 nd1850 4.662451689687e+00
RINT12825 nd1820 nd1851 4.662451689687e+00
RINT12826 nd1821 nd1852 4.662451689687e+00
RINT12827 nd1822 nd1853 4.662451689687e+00
RINT12828 nd1823 nd1854 4.662451689687e+00
RINT12829 nd1824 nd1855 4.662451689687e+00
RINT12830 nd1825 nd1856 4.662451689687e+00
RINT12831 nd1826 nd1857 4.662451689687e+00
RINT12832 nd1827 nd1858 4.662451689687e+00
RINT12833 nd1828 nd1859 4.662451689687e+00
RINT12834 nd1829 nd1860 5.918933645378e+00
RINT12835 nd1830 nd1861 5.111028301069e+00
RINT12836 nd1831 nd1862 5.111028301069e+00
RINT12837 nd1832 nd1863 2.965348653754e+02
RINT12838 nd1833 nd1864 1.051936504946e+01
RINT12839 nd1834 nd1865 1.059376775131e+01
RINT12840 nd1835 nd1866 1.059376775131e+01
RINT12841 nd1836 nd1867 3.677205321604e+03
RINT12842 nd1837 nd1868 6.128675536007e+02
RINT12843 nd1838 nd1869 1.050630091887e+03
RINT12844 nd1839 nd1870 1.050630091887e+03
RINT12845 nd1840 nd1871 1.050630091887e+03
RINT12846 nd1841 nd1872 1.050630091887e+03
RINT12847 nd1842 nd1873 1.050630091887e+03
RINT12848 nd1843 nd1874 1.050630091887e+03
RINT12849 nd1844 nd1875 1.050630091887e+03
RINT12850 nd1845 nd1876 2.334733537526e+02
RINT12851 nd1846 nd1877 2.334733537526e+02
RINT12852 nd1847 nd1878 5.538970918181e+02
RINT12853 nd1848 nd1879 3.983936132610e+01
RINT12854 nd1849 nd1880 8.836967932549e+02
RINT12855 nd1850 nd1881 3.682069971895e+00
RINT12856 nd1851 nd1882 3.682069971895e+00
RINT12857 nd1852 nd1883 3.682069971895e+00
RINT12858 nd1853 nd1884 3.682069971895e+00
RINT12859 nd1854 nd1885 3.682069971895e+00
RINT12860 nd1855 nd1886 3.682069971895e+00
RINT12861 nd1856 nd1887 3.682069971895e+00
RINT12862 nd1857 nd1888 3.682069971895e+00
RINT12863 nd1858 nd1889 3.682069971895e+00
RINT12864 nd1859 nd1890 3.682069971895e+00
RINT12865 nd1860 nd1891 1.042035668855e+01
RINT12866 nd1861 nd1892 8.998029228461e+00
RINT12867 nd1862 nd1893 8.998029228461e+00
RINT12868 nd1863 nd1894 5.220533381408e+02
RINT12869 nd1864 nd1895 1.851947369575e+01
RINT12870 nd1865 nd1896 1.865046058263e+01
RINT12871 nd1866 nd1897 1.865046058263e+01
RINT12872 nd1867 nd1898 7.408377398100e+02
RINT12873 nd1868 nd1899 1.234729566350e+02
RINT12874 nd1869 nd1900 2.116679256600e+02
RINT12875 nd1870 nd1901 2.116679256600e+02
RINT12876 nd1871 nd1902 2.116679256600e+02
RINT12877 nd1872 nd1903 2.116679256600e+02
RINT12878 nd1873 nd1904 2.116679256600e+02
RINT12879 nd1874 nd1905 2.116679256600e+02
RINT12880 nd1875 nd1906 2.116679256600e+02
RINT12881 nd1876 nd1907 4.703731681333e+01
RINT12882 nd1877 nd1908 4.703731681333e+01
RINT12883 nd1878 nd1909 9.751427556557e+02
RINT12884 nd1879 nd1910 7.013769373582e+01
RINT12885 nd1880 nd1911 1.555759253601e+03
RINT12886 nd1881 nd1912 6.482330223337e+00
RINT12887 nd1882 nd1913 6.482330223337e+00
RINT12888 nd1883 nd1914 6.482330223337e+00
RINT12889 nd1884 nd1915 6.482330223337e+00
RINT12890 nd1885 nd1916 6.482330223337e+00
RINT12891 nd1886 nd1917 6.482330223337e+00
RINT12892 nd1887 nd1918 6.482330223337e+00
RINT12893 nd1888 nd1919 6.482330223337e+00
RINT12894 nd1889 nd1920 6.482330223337e+00
RINT12895 nd1890 nd1921 6.482330223337e+00
RINT12896 nd1891 nd1922 1.042035668855e+01
RINT12897 nd1892 nd1923 8.998029228461e+00
RINT12898 nd1893 nd1924 8.998029228461e+00
RINT12899 nd1894 nd1925 5.220533381408e+02
RINT12900 nd1895 nd1926 1.851947369575e+01
RINT12901 nd1896 nd1927 1.865046058263e+01
RINT12902 nd1897 nd1928 1.865046058263e+01
RINT12903 nd1898 nd1929 7.408377398100e+02
RINT12904 nd1899 nd1930 1.234729566350e+02
RINT12905 nd1900 nd1931 2.116679256600e+02
RINT12906 nd1901 nd1932 2.116679256600e+02
RINT12907 nd1902 nd1933 2.116679256600e+02
RINT12908 nd1903 nd1934 2.116679256600e+02
RINT12909 nd1904 nd1935 2.116679256600e+02
RINT12910 nd1905 nd1936 2.116679256600e+02
RINT12911 nd1906 nd1937 2.116679256600e+02
RINT12912 nd1907 nd1938 4.703731681333e+01
RINT12913 nd1908 nd1939 4.703731681333e+01
RINT12914 nd1909 nd1940 9.751427556557e+02
RINT12915 nd1910 nd1941 7.013769373582e+01
RINT12916 nd1911 nd1942 1.555759253601e+03
RINT12917 nd1912 nd1943 6.482330223337e+00
RINT12918 nd1913 nd1944 6.482330223337e+00
RINT12919 nd1914 nd1945 6.482330223337e+00
RINT12920 nd1915 nd1946 6.482330223337e+00
RINT12921 nd1916 nd1947 6.482330223337e+00
RINT12922 nd1917 nd1948 6.482330223337e+00
RINT12923 nd1918 nd1949 6.482330223337e+00
RINT12924 nd1919 nd1950 6.482330223337e+00
RINT12925 nd1920 nd1951 6.482330223337e+00
RINT12926 nd1921 nd1952 6.482330223337e+00
RINT12927 nd1953 nd1984 1.042035668855e+01
RINT12928 nd1954 nd1985 8.998029228461e+00
RINT12929 nd1955 nd1986 8.998029228461e+00
RINT12930 nd1956 nd1987 5.220533381408e+02
RINT12931 nd1957 nd1988 1.851947369575e+01
RINT12932 nd1958 nd1989 1.865046058263e+01
RINT12933 nd1959 nd1990 1.865046058263e+01
RINT12934 nd1960 nd1991 7.408377398100e+02
RINT12935 nd1961 nd1992 1.234729566350e+02
RINT12936 nd1962 nd1993 2.116679256600e+02
RINT12937 nd1963 nd1994 2.116679256600e+02
RINT12938 nd1964 nd1995 2.116679256600e+02
RINT12939 nd1965 nd1996 2.116679256600e+02
RINT12940 nd1966 nd1997 2.116679256600e+02
RINT12941 nd1967 nd1998 2.116679256600e+02
RINT12942 nd1968 nd1999 2.116679256600e+02
RINT12943 nd1969 nd2000 4.703731681333e+01
RINT12944 nd1970 nd2001 4.703731681333e+01
RINT12945 nd1971 nd2002 9.751427556557e+02
RINT12946 nd1972 nd2003 7.013769373582e+01
RINT12947 nd1973 nd2004 1.555759253601e+03
RINT12948 nd1974 nd2005 6.482330223337e+00
RINT12949 nd1975 nd2006 6.482330223337e+00
RINT12950 nd1976 nd2007 6.482330223337e+00
RINT12951 nd1977 nd2008 6.482330223337e+00
RINT12952 nd1978 nd2009 6.482330223337e+00
RINT12953 nd1979 nd2010 6.482330223337e+00
RINT12954 nd1980 nd2011 6.482330223337e+00
RINT12955 nd1981 nd2012 6.482330223337e+00
RINT12956 nd1982 nd2013 6.482330223337e+00
RINT12957 nd1983 nd2014 6.482330223337e+00
RINT12958 nd1984 nd2015 1.042035668855e+01
RINT12959 nd1985 nd2016 8.998029228461e+00
RINT12960 nd1986 nd2017 8.998029228461e+00
RINT12961 nd1987 nd2018 5.220533381408e+02
RINT12962 nd1988 nd2019 1.851947369575e+01
RINT12963 nd1989 nd2020 1.865046058263e+01
RINT12964 nd1990 nd2021 1.865046058263e+01
RINT12965 nd1991 nd2022 7.408377398100e+02
RINT12966 nd1992 nd2023 1.234729566350e+02
RINT12967 nd1993 nd2024 2.116679256600e+02
RINT12968 nd1994 nd2025 2.116679256600e+02
RINT12969 nd1995 nd2026 2.116679256600e+02
RINT12970 nd1996 nd2027 2.116679256600e+02
RINT12971 nd1997 nd2028 2.116679256600e+02
RINT12972 nd1998 nd2029 2.116679256600e+02
RINT12973 nd1999 nd2030 2.116679256600e+02
RINT12974 nd2000 nd2031 4.703731681333e+01
RINT12975 nd2001 nd2032 4.703731681333e+01
RINT12976 nd2002 nd2033 9.751427556557e+02
RINT12977 nd2003 nd2034 7.013769373582e+01
RINT12978 nd2004 nd2035 1.555759253601e+03
RINT12979 nd2005 nd2036 6.482330223337e+00
RINT12980 nd2006 nd2037 6.482330223337e+00
RINT12981 nd2007 nd2038 6.482330223337e+00
RINT12982 nd2008 nd2039 6.482330223337e+00
RINT12983 nd2009 nd2040 6.482330223337e+00
RINT12984 nd2010 nd2041 6.482330223337e+00
RINT12985 nd2011 nd2042 6.482330223337e+00
RINT12986 nd2012 nd2043 6.482330223337e+00
RINT12987 nd2013 nd2044 6.482330223337e+00
RINT12988 nd2014 nd2045 6.482330223337e+00
RINT12989 nd2015 nd2046 5.918933645377e+00
RINT12990 nd2016 nd2047 5.111028301069e+00
RINT12991 nd2017 nd2048 5.111028301069e+00
RINT12992 nd2018 nd2049 2.965348653754e+02
RINT12993 nd2019 nd2050 1.051936504946e+01
RINT12994 nd2020 nd2051 1.059376775131e+01
RINT12995 nd2021 nd2052 1.059376775131e+01
RINT12996 nd2022 nd2053 3.677205321604e+03
RINT12997 nd2023 nd2054 6.128675536007e+02
RINT12998 nd2024 nd2055 1.050630091887e+03
RINT12999 nd2025 nd2056 1.050630091887e+03
RINT13000 nd2026 nd2057 1.050630091887e+03
RINT13001 nd2027 nd2058 1.050630091887e+03
RINT13002 nd2028 nd2059 1.050630091887e+03
RINT13003 nd2029 nd2060 1.050630091887e+03
RINT13004 nd2030 nd2061 1.050630091887e+03
RINT13005 nd2031 nd2062 2.334733537526e+02
RINT13006 nd2032 nd2063 2.334733537526e+02
RINT13007 nd2033 nd2064 5.538970918181e+02
RINT13008 nd2034 nd2065 3.983936132610e+01
RINT13009 nd2035 nd2066 8.836967932549e+02
RINT13010 nd2036 nd2067 3.682069971895e+00
RINT13011 nd2037 nd2068 3.682069971895e+00
RINT13012 nd2038 nd2069 3.682069971895e+00
RINT13013 nd2039 nd2070 3.682069971895e+00
RINT13014 nd2040 nd2071 3.682069971895e+00
RINT13015 nd2041 nd2072 3.682069971895e+00
RINT13016 nd2042 nd2073 3.682069971895e+00
RINT13017 nd2043 nd2074 3.682069971895e+00
RINT13018 nd2044 nd2075 3.682069971895e+00
RINT13019 nd2045 nd2076 3.682069971895e+00
RINT13020 nd2046 nd2077 7.494898898358e+00
RINT13021 nd2047 nd2078 6.471882044678e+00
RINT13022 nd2048 nd2079 6.471882044678e+00
RINT13023 nd2049 nd2080 3.754897366627e+02
RINT13024 nd2050 nd2081 1.332023338058e+01
RINT13025 nd2051 nd2082 1.341444641988e+01
RINT13026 nd2052 nd2083 1.341444641988e+01
RINT13027 nd2053 nd2084 3.942767563891e+03
RINT13028 nd2054 nd2085 6.216370766103e+02
RINT13029 nd2055 nd2086 1.083955004199e+03
RINT13030 nd2056 nd2087 1.083955004199e+03
RINT13031 nd2057 nd2088 1.083955004199e+03
RINT13032 nd2058 nd2089 1.083955004199e+03
RINT13033 nd2059 nd2090 1.083955004199e+03
RINT13034 nd2060 nd2091 1.083955004199e+03
RINT13035 nd2061 nd2092 1.083955004199e+03
RINT13036 nd2062 nd2093 2.368141244230e+02
RINT13037 nd2063 nd2094 2.376222816265e+02
RINT13038 nd2064 nd2095 7.013767938611e+02
RINT13039 nd2065 nd2096 5.044692223361e+01
RINT13040 nd2066 nd2097 1.118988405525e+03
RINT13041 nd2067 nd2098 4.662451689687e+00
RINT13042 nd2068 nd2099 4.662451689687e+00
RINT13043 nd2069 nd2100 4.662451689687e+00
RINT13044 nd2070 nd2101 4.662451689687e+00
RINT13045 nd2071 nd2102 4.662451689687e+00
RINT13046 nd2072 nd2103 4.662451689687e+00
RINT13047 nd2073 nd2104 4.662451689687e+00
RINT13048 nd2074 nd2105 4.662451689687e+00
RINT13049 nd2075 nd2106 4.662451689687e+00
RINT13050 nd2076 nd2107 4.662451689687e+00
RINT13051 nd2077 nd2108 1.357228719451e+01
RINT13052 nd2078 nd2109 1.171973671568e+01
RINT13053 nd2079 nd2110 1.171973671568e+01
RINT13054 nd2080 nd2111 6.799630807155e+02
RINT13055 nd2081 nd2112 2.412121035800e+01
RINT13056 nd2082 nd2113 2.429181791977e+01
RINT13057 nd2083 nd2114 2.429181791977e+01
RINT13058 nd2084 nd2115 1.271962224384e+03
RINT13059 nd2085 nd2116 1.410120026542e+02
RINT13060 nd2086 nd2117 2.783177502845e+02
RINT13061 nd2087 nd2118 2.783177502845e+02
RINT13062 nd2088 nd2119 2.783177502845e+02
RINT13063 nd2089 nd2120 2.783177502845e+02
RINT13064 nd2090 nd2121 2.783177502845e+02
RINT13065 nd2091 nd2122 2.783177502845e+02
RINT13066 nd2092 nd2123 2.783177502845e+02
RINT13067 nd2093 nd2124 5.371885815399e+01
RINT13068 nd2094 nd2125 5.533517256115e+01
RINT13069 nd2095 nd2126 1.270102159742e+03
RINT13070 nd2096 nd2127 9.135281555084e+01
RINT13071 nd2097 nd2128 2.026342478141e+03
RINT13072 nd2098 nd2129 8.443093658921e+00
RINT13073 nd2099 nd2130 8.443093658921e+00
RINT13074 nd2100 nd2131 8.443093658921e+00
RINT13075 nd2101 nd2132 8.443093658921e+00
RINT13076 nd2102 nd2133 8.443093658921e+00
RINT13077 nd2103 nd2134 8.443093658921e+00
RINT13078 nd2104 nd2135 8.443093658921e+00
RINT13079 nd2105 nd2136 8.443093658921e+00
RINT13080 nd2106 nd2137 8.443093658921e+00
RINT13081 nd2107 nd2138 8.443093658921e+00
RINT13082 nd2108 nd2139 1.357228719451e+01
RINT13083 nd2109 nd2140 1.171973671568e+01
RINT13084 nd2110 nd2141 1.171973671568e+01
RINT13085 nd2111 nd2142 6.799630807155e+02
RINT13086 nd2112 nd2143 2.412121035800e+01
RINT13087 nd2113 nd2144 2.429181791977e+01
RINT13088 nd2114 nd2145 2.429181791977e+01
RINT13089 nd2115 nd2146 1.271962224384e+03
RINT13090 nd2116 nd2147 1.410120026542e+02
RINT13091 nd2117 nd2148 2.783177502845e+02
RINT13092 nd2118 nd2149 2.783177502845e+02
RINT13093 nd2119 nd2150 2.783177502845e+02
RINT13094 nd2120 nd2151 2.783177502845e+02
RINT13095 nd2121 nd2152 2.783177502845e+02
RINT13096 nd2122 nd2153 2.783177502845e+02
RINT13097 nd2123 nd2154 2.783177502845e+02
RINT13098 nd2124 nd2155 5.371885815399e+01
RINT13099 nd2125 nd2156 5.533517256115e+01
RINT13100 nd2126 nd2157 1.270102159742e+03
RINT13101 nd2127 nd2158 9.135281555084e+01
RINT13102 nd2128 nd2159 2.026342478141e+03
RINT13103 nd2129 nd2160 8.443093658921e+00
RINT13104 nd2130 nd2161 8.443093658921e+00
RINT13105 nd2131 nd2162 8.443093658921e+00
RINT13106 nd2132 nd2163 8.443093658921e+00
RINT13107 nd2133 nd2164 8.443093658921e+00
RINT13108 nd2134 nd2165 8.443093658921e+00
RINT13109 nd2135 nd2166 8.443093658921e+00
RINT13110 nd2136 nd2167 8.443093658921e+00
RINT13111 nd2137 nd2168 8.443093658921e+00
RINT13112 nd2138 nd2169 8.443093658921e+00
RINT13113 nd2139 nd2170 1.357228719451e+01
RINT13114 nd2140 nd2171 1.171973671568e+01
RINT13115 nd2141 nd2172 1.171973671568e+01
RINT13116 nd2142 nd2173 6.799630807155e+02
RINT13117 nd2143 nd2174 2.412121035800e+01
RINT13118 nd2144 nd2175 2.429181791977e+01
RINT13119 nd2145 nd2176 2.429181791977e+01
RINT13120 nd2146 nd2177 1.271962224384e+03
RINT13121 nd2147 nd2178 1.410120026542e+02
RINT13122 nd2148 nd2179 2.783177502845e+02
RINT13123 nd2149 nd2180 2.783177502845e+02
RINT13124 nd2150 nd2181 2.783177502845e+02
RINT13125 nd2151 nd2182 2.783177502845e+02
RINT13126 nd2152 nd2183 2.783177502845e+02
RINT13127 nd2153 nd2184 2.783177502845e+02
RINT13128 nd2154 nd2185 2.783177502845e+02
RINT13129 nd2155 nd2186 5.371885815399e+01
RINT13130 nd2156 nd2187 5.533517256115e+01
RINT13131 nd2157 nd2188 1.270102159742e+03
RINT13132 nd2158 nd2189 9.135281555084e+01
RINT13133 nd2159 nd2190 2.026342478141e+03
RINT13134 nd2160 nd2191 8.443093658921e+00
RINT13135 nd2161 nd2192 8.443093658921e+00
RINT13136 nd2162 nd2193 8.443093658921e+00
RINT13137 nd2163 nd2194 8.443093658921e+00
RINT13138 nd2164 nd2195 8.443093658921e+00
RINT13139 nd2165 nd2196 8.443093658921e+00
RINT13140 nd2166 nd2197 8.443093658921e+00
RINT13141 nd2167 nd2198 8.443093658921e+00
RINT13142 nd2168 nd2199 8.443093658921e+00
RINT13143 nd2169 nd2200 8.443093658921e+00
RINT13144 nd2170 nd2201 1.357228719451e+01
RINT13145 nd2171 nd2202 1.171973671568e+01
RINT13146 nd2172 nd2203 1.171973671568e+01
RINT13147 nd2173 nd2204 6.799630807155e+02
RINT13148 nd2174 nd2205 2.412121035800e+01
RINT13149 nd2175 nd2206 2.429181791977e+01
RINT13150 nd2176 nd2207 2.429181791977e+01
RINT13151 nd2177 nd2208 1.271962224384e+03
RINT13152 nd2178 nd2209 1.410120026542e+02
RINT13153 nd2179 nd2210 2.783177502845e+02
RINT13154 nd2180 nd2211 2.783177502845e+02
RINT13155 nd2181 nd2212 2.783177502845e+02
RINT13156 nd2182 nd2213 2.783177502845e+02
RINT13157 nd2183 nd2214 2.783177502845e+02
RINT13158 nd2184 nd2215 2.783177502845e+02
RINT13159 nd2185 nd2216 2.783177502845e+02
RINT13160 nd2186 nd2217 5.371885815399e+01
RINT13161 nd2187 nd2218 5.533517256115e+01
RINT13162 nd2188 nd2219 1.270102159742e+03
RINT13163 nd2189 nd2220 9.135281555084e+01
RINT13164 nd2190 nd2221 2.026342478141e+03
RINT13165 nd2191 nd2222 8.443093658921e+00
RINT13166 nd2192 nd2223 8.443093658921e+00
RINT13167 nd2193 nd2224 8.443093658921e+00
RINT13168 nd2194 nd2225 8.443093658921e+00
RINT13169 nd2195 nd2226 8.443093658921e+00
RINT13170 nd2196 nd2227 8.443093658921e+00
RINT13171 nd2197 nd2228 8.443093658921e+00
RINT13172 nd2198 nd2229 8.443093658921e+00
RINT13173 nd2199 nd2230 8.443093658921e+00
RINT13174 nd2200 nd2231 8.443093658921e+00
RINT13175 nd2201 nd2232 1.357228719451e+01
RINT13176 nd2202 nd2233 1.171973671568e+01
RINT13177 nd2203 nd2234 1.171973671568e+01
RINT13178 nd2204 nd2235 6.799630807155e+02
RINT13179 nd2205 nd2236 2.412121035800e+01
RINT13180 nd2206 nd2237 2.429181791977e+01
RINT13181 nd2207 nd2238 2.429181791977e+01
RINT13182 nd2208 nd2239 1.271962224384e+03
RINT13183 nd2209 nd2240 1.410120026542e+02
RINT13184 nd2210 nd2241 2.783177502845e+02
RINT13185 nd2211 nd2242 2.783177502845e+02
RINT13186 nd2212 nd2243 2.783177502845e+02
RINT13187 nd2213 nd2244 2.783177502845e+02
RINT13188 nd2214 nd2245 2.783177502845e+02
RINT13189 nd2215 nd2246 2.783177502845e+02
RINT13190 nd2216 nd2247 2.783177502845e+02
RINT13191 nd2217 nd2248 5.371885815399e+01
RINT13192 nd2218 nd2249 5.533517256115e+01
RINT13193 nd2219 nd2250 1.270102159742e+03
RINT13194 nd2220 nd2251 9.135281555084e+01
RINT13195 nd2221 nd2252 2.026342478141e+03
RINT13196 nd2222 nd2253 8.443093658921e+00
RINT13197 nd2223 nd2254 8.443093658921e+00
RINT13198 nd2224 nd2255 8.443093658921e+00
RINT13199 nd2225 nd2256 8.443093658921e+00
RINT13200 nd2226 nd2257 8.443093658921e+00
RINT13201 nd2227 nd2258 8.443093658921e+00
RINT13202 nd2228 nd2259 8.443093658921e+00
RINT13203 nd2229 nd2260 8.443093658921e+00
RINT13204 nd2230 nd2261 8.443093658921e+00
RINT13205 nd2231 nd2262 8.443093658921e+00
RINT13206 nd2232 nd2263 7.494898898358e+00
RINT13207 nd2233 nd2264 6.471882044678e+00
RINT13208 nd2234 nd2265 6.471882044678e+00
RINT13209 nd2235 nd2266 3.754897366627e+02
RINT13210 nd2236 nd2267 1.332023338058e+01
RINT13211 nd2237 nd2268 1.341444641988e+01
RINT13212 nd2238 nd2269 1.341444641988e+01
RINT13213 nd2239 nd2270 3.942767563891e+03
RINT13214 nd2240 nd2271 6.216370766103e+02
RINT13215 nd2241 nd2272 1.083955004199e+03
RINT13216 nd2242 nd2273 1.083955004199e+03
RINT13217 nd2243 nd2274 1.083955004199e+03
RINT13218 nd2244 nd2275 1.083955004199e+03
RINT13219 nd2245 nd2276 1.083955004199e+03
RINT13220 nd2246 nd2277 1.083955004199e+03
RINT13221 nd2247 nd2278 1.083955004199e+03
RINT13222 nd2248 nd2279 2.368141244230e+02
RINT13223 nd2249 nd2280 2.376222816266e+02
RINT13224 nd2250 nd2281 7.013767938611e+02
RINT13225 nd2251 nd2282 5.044692223361e+01
RINT13226 nd2252 nd2283 1.118988405525e+03
RINT13227 nd2253 nd2284 4.662451689687e+00
RINT13228 nd2254 nd2285 4.662451689687e+00
RINT13229 nd2255 nd2286 4.662451689687e+00
RINT13230 nd2256 nd2287 4.662451689687e+00
RINT13231 nd2257 nd2288 4.662451689687e+00
RINT13232 nd2258 nd2289 4.662451689687e+00
RINT13233 nd2259 nd2290 4.662451689687e+00
RINT13234 nd2260 nd2291 4.662451689687e+00
RINT13235 nd2261 nd2292 4.662451689687e+00
RINT13236 nd2262 nd2293 4.662451689687e+00
RINT13237 nd2263 nd2294 7.494898898358e+00
RINT13238 nd2264 nd2295 6.471882044678e+00
RINT13239 nd2265 nd2296 6.471882044678e+00
RINT13240 nd2266 nd2297 3.754897366627e+02
RINT13241 nd2267 nd2298 1.332023338058e+01
RINT13242 nd2268 nd2299 1.341444641988e+01
RINT13243 nd2269 nd2300 1.341444641988e+01
RINT13244 nd2270 nd2301 3.942767563891e+03
RINT13245 nd2271 nd2302 6.216370766103e+02
RINT13246 nd2272 nd2303 1.083955004199e+03
RINT13247 nd2273 nd2304 1.083955004199e+03
RINT13248 nd2274 nd2305 1.083955004199e+03
RINT13249 nd2275 nd2306 1.083955004199e+03
RINT13250 nd2276 nd2307 1.083955004199e+03
RINT13251 nd2277 nd2308 1.083955004199e+03
RINT13252 nd2278 nd2309 1.083955004199e+03
RINT13253 nd2279 nd2310 2.368141244230e+02
RINT13254 nd2280 nd2311 2.376222816266e+02
RINT13255 nd2281 nd2312 7.013767938611e+02
RINT13256 nd2282 nd2313 5.044692223361e+01
RINT13257 nd2283 nd2314 1.118988405525e+03
RINT13258 nd2284 nd2315 4.662451689687e+00
RINT13259 nd2285 nd2316 4.662451689687e+00
RINT13260 nd2286 nd2317 4.662451689687e+00
RINT13261 nd2287 nd2318 4.662451689687e+00
RINT13262 nd2288 nd2319 4.662451689687e+00
RINT13263 nd2289 nd2320 4.662451689687e+00
RINT13264 nd2290 nd2321 4.662451689687e+00
RINT13265 nd2291 nd2322 4.662451689687e+00
RINT13266 nd2292 nd2323 4.662451689687e+00
RINT13267 nd2293 nd2324 4.662451689687e+00
RINT13268 nd2294 nd2325 1.357228719451e+01
RINT13269 nd2295 nd2326 1.171973671568e+01
RINT13270 nd2296 nd2327 1.171973671568e+01
RINT13271 nd2297 nd2328 6.799630807155e+02
RINT13272 nd2298 nd2329 2.412121035800e+01
RINT13273 nd2299 nd2330 2.429181791977e+01
RINT13274 nd2300 nd2331 2.429181791977e+01
RINT13275 nd2301 nd2332 1.271962224384e+03
RINT13276 nd2302 nd2333 1.410120026542e+02
RINT13277 nd2303 nd2334 2.783177502845e+02
RINT13278 nd2304 nd2335 2.783177502845e+02
RINT13279 nd2305 nd2336 2.783177502845e+02
RINT13280 nd2306 nd2337 2.783177502845e+02
RINT13281 nd2307 nd2338 2.783177502845e+02
RINT13282 nd2308 nd2339 2.783177502845e+02
RINT13283 nd2309 nd2340 2.783177502845e+02
RINT13284 nd2310 nd2341 5.371885815399e+01
RINT13285 nd2311 nd2342 5.533517256115e+01
RINT13286 nd2312 nd2343 1.270102159742e+03
RINT13287 nd2313 nd2344 9.135281555084e+01
RINT13288 nd2314 nd2345 2.026342478141e+03
RINT13289 nd2315 nd2346 8.443093658921e+00
RINT13290 nd2316 nd2347 8.443093658921e+00
RINT13291 nd2317 nd2348 8.443093658921e+00
RINT13292 nd2318 nd2349 8.443093658921e+00
RINT13293 nd2319 nd2350 8.443093658921e+00
RINT13294 nd2320 nd2351 8.443093658921e+00
RINT13295 nd2321 nd2352 8.443093658921e+00
RINT13296 nd2322 nd2353 8.443093658921e+00
RINT13297 nd2323 nd2354 8.443093658921e+00
RINT13298 nd2324 nd2355 8.443093658921e+00
RINT13299 nd2325 nd2356 1.357228719451e+01
RINT13300 nd2326 nd2357 1.171973671568e+01
RINT13301 nd2327 nd2358 1.171973671568e+01
RINT13302 nd2328 nd2359 6.799630807155e+02
RINT13303 nd2329 nd2360 2.412121035800e+01
RINT13304 nd2330 nd2361 2.429181791977e+01
RINT13305 nd2331 nd2362 2.429181791977e+01
RINT13306 nd2332 nd2363 1.271962224384e+03
RINT13307 nd2333 nd2364 1.410120026542e+02
RINT13308 nd2334 nd2365 2.783177502845e+02
RINT13309 nd2335 nd2366 2.783177502845e+02
RINT13310 nd2336 nd2367 2.783177502845e+02
RINT13311 nd2337 nd2368 2.783177502845e+02
RINT13312 nd2338 nd2369 2.783177502845e+02
RINT13313 nd2339 nd2370 2.783177502845e+02
RINT13314 nd2340 nd2371 2.783177502845e+02
RINT13315 nd2341 nd2372 5.371885815399e+01
RINT13316 nd2342 nd2373 5.533517256115e+01
RINT13317 nd2343 nd2374 1.270102159742e+03
RINT13318 nd2344 nd2375 9.135281555084e+01
RINT13319 nd2345 nd2376 2.026342478141e+03
RINT13320 nd2346 nd2377 8.443093658921e+00
RINT13321 nd2347 nd2378 8.443093658921e+00
RINT13322 nd2348 nd2379 8.443093658921e+00
RINT13323 nd2349 nd2380 8.443093658921e+00
RINT13324 nd2350 nd2381 8.443093658921e+00
RINT13325 nd2351 nd2382 8.443093658921e+00
RINT13326 nd2352 nd2383 8.443093658921e+00
RINT13327 nd2353 nd2384 8.443093658921e+00
RINT13328 nd2354 nd2385 8.443093658921e+00
RINT13329 nd2355 nd2386 8.443093658921e+00
RINT13330 nd2356 nd2387 1.357228719451e+01
RINT13331 nd2357 nd2388 1.171973671568e+01
RINT13332 nd2358 nd2389 1.171973671568e+01
RINT13333 nd2359 nd2390 6.799630807155e+02
RINT13334 nd2360 nd2391 2.412121035800e+01
RINT13335 nd2361 nd2392 2.429181791977e+01
RINT13336 nd2362 nd2393 2.429181791977e+01
RINT13337 nd2363 nd2394 1.271962224384e+03
RINT13338 nd2364 nd2395 1.410120026542e+02
RINT13339 nd2365 nd2396 2.783177502845e+02
RINT13340 nd2366 nd2397 2.783177502845e+02
RINT13341 nd2367 nd2398 2.783177502845e+02
RINT13342 nd2368 nd2399 2.783177502845e+02
RINT13343 nd2369 nd2400 2.783177502845e+02
RINT13344 nd2370 nd2401 2.783177502845e+02
RINT13345 nd2371 nd2402 2.783177502845e+02
RINT13346 nd2372 nd2403 5.371885815399e+01
RINT13347 nd2373 nd2404 5.533517256115e+01
RINT13348 nd2374 nd2405 1.270102159742e+03
RINT13349 nd2375 nd2406 9.135281555084e+01
RINT13350 nd2376 nd2407 2.026342478141e+03
RINT13351 nd2377 nd2408 8.443093658921e+00
RINT13352 nd2378 nd2409 8.443093658921e+00
RINT13353 nd2379 nd2410 8.443093658921e+00
RINT13354 nd2380 nd2411 8.443093658921e+00
RINT13355 nd2381 nd2412 8.443093658921e+00
RINT13356 nd2382 nd2413 8.443093658921e+00
RINT13357 nd2383 nd2414 8.443093658921e+00
RINT13358 nd2384 nd2415 8.443093658921e+00
RINT13359 nd2385 nd2416 8.443093658921e+00
RINT13360 nd2386 nd2417 8.443093658921e+00
RINT13361 nd2387 nd2418 1.357228719451e+01
RINT13362 nd2388 nd2419 1.171973671568e+01
RINT13363 nd2389 nd2420 1.171973671568e+01
RINT13364 nd2390 nd2421 6.799630807155e+02
RINT13365 nd2391 nd2422 2.412121035800e+01
RINT13366 nd2392 nd2423 2.429181791977e+01
RINT13367 nd2393 nd2424 2.429181791977e+01
RINT13368 nd2394 nd2425 1.271962224384e+03
RINT13369 nd2395 nd2426 1.410120026542e+02
RINT13370 nd2396 nd2427 2.783177502845e+02
RINT13371 nd2397 nd2428 2.783177502845e+02
RINT13372 nd2398 nd2429 2.783177502845e+02
RINT13373 nd2399 nd2430 2.783177502845e+02
RINT13374 nd2400 nd2431 2.783177502845e+02
RINT13375 nd2401 nd2432 2.783177502845e+02
RINT13376 nd2402 nd2433 2.783177502845e+02
RINT13377 nd2403 nd2434 5.371885815399e+01
RINT13378 nd2404 nd2435 5.533517256115e+01
RINT13379 nd2405 nd2436 1.270102159742e+03
RINT13380 nd2406 nd2437 9.135281555084e+01
RINT13381 nd2407 nd2438 2.026342478141e+03
RINT13382 nd2408 nd2439 8.443093658921e+00
RINT13383 nd2409 nd2440 8.443093658921e+00
RINT13384 nd2410 nd2441 8.443093658921e+00
RINT13385 nd2411 nd2442 8.443093658921e+00
RINT13386 nd2412 nd2443 8.443093658921e+00
RINT13387 nd2413 nd2444 8.443093658921e+00
RINT13388 nd2414 nd2445 8.443093658921e+00
RINT13389 nd2415 nd2446 8.443093658921e+00
RINT13390 nd2416 nd2447 8.443093658921e+00
RINT13391 nd2417 nd2448 8.443093658921e+00
RINT13392 nd2418 nd2449 1.357228719451e+01
RINT13393 nd2419 nd2450 1.171973671568e+01
RINT13394 nd2420 nd2451 1.171973671568e+01
RINT13395 nd2421 nd2452 6.799630807155e+02
RINT13396 nd2422 nd2453 2.412121035800e+01
RINT13397 nd2423 nd2454 2.429181791977e+01
RINT13398 nd2424 nd2455 2.429181791977e+01
RINT13399 nd2425 nd2456 1.271962224384e+03
RINT13400 nd2426 nd2457 1.410120026542e+02
RINT13401 nd2427 nd2458 2.783177502845e+02
RINT13402 nd2428 nd2459 2.783177502845e+02
RINT13403 nd2429 nd2460 2.783177502845e+02
RINT13404 nd2430 nd2461 2.783177502845e+02
RINT13405 nd2431 nd2462 2.783177502845e+02
RINT13406 nd2432 nd2463 2.783177502845e+02
RINT13407 nd2433 nd2464 2.783177502845e+02
RINT13408 nd2434 nd2465 5.371885815399e+01
RINT13409 nd2435 nd2466 5.533517256115e+01
RINT13410 nd2436 nd2467 1.270102159742e+03
RINT13411 nd2437 nd2468 9.135281555084e+01
RINT13412 nd2438 nd2469 2.026342478141e+03
RINT13413 nd2439 nd2470 8.443093658921e+00
RINT13414 nd2440 nd2471 8.443093658921e+00
RINT13415 nd2441 nd2472 8.443093658921e+00
RINT13416 nd2442 nd2473 8.443093658921e+00
RINT13417 nd2443 nd2474 8.443093658921e+00
RINT13418 nd2444 nd2475 8.443093658921e+00
RINT13419 nd2445 nd2476 8.443093658921e+00
RINT13420 nd2446 nd2477 8.443093658921e+00
RINT13421 nd2447 nd2478 8.443093658921e+00
RINT13422 nd2448 nd2479 8.443093658921e+00
RINT13423 nd2449 nd2480 7.494898898358e+00
RINT13424 nd2450 nd2481 6.471882044678e+00
RINT13425 nd2451 nd2482 6.471882044678e+00
RINT13426 nd2452 nd2483 3.754897366627e+02
RINT13427 nd2453 nd2484 1.332023338058e+01
RINT13428 nd2454 nd2485 1.341444641988e+01
RINT13429 nd2455 nd2486 1.341444641988e+01
RINT13430 nd2456 nd2487 3.942767563891e+03
RINT13431 nd2457 nd2488 6.216370766103e+02
RINT13432 nd2458 nd2489 1.083955004199e+03
RINT13433 nd2459 nd2490 1.083955004199e+03
RINT13434 nd2460 nd2491 1.083955004199e+03
RINT13435 nd2461 nd2492 1.083955004199e+03
RINT13436 nd2462 nd2493 1.083955004199e+03
RINT13437 nd2463 nd2494 1.083955004199e+03
RINT13438 nd2464 nd2495 1.083955004199e+03
RINT13439 nd2465 nd2496 2.368141244230e+02
RINT13440 nd2466 nd2497 2.376222816266e+02
RINT13441 nd2467 nd2498 7.013767938611e+02
RINT13442 nd2468 nd2499 5.044692223361e+01
RINT13443 nd2469 nd2500 1.118988405525e+03
RINT13444 nd2470 nd2501 4.662451689687e+00
RINT13445 nd2471 nd2502 4.662451689687e+00
RINT13446 nd2472 nd2503 4.662451689687e+00
RINT13447 nd2473 nd2504 4.662451689687e+00
RINT13448 nd2474 nd2505 4.662451689687e+00
RINT13449 nd2475 nd2506 4.662451689687e+00
RINT13450 nd2476 nd2507 4.662451689687e+00
RINT13451 nd2477 nd2508 4.662451689687e+00
RINT13452 nd2478 nd2509 4.662451689687e+00
RINT13453 nd2479 nd2510 4.662451689687e+00
RINT13454 nd2480 nd2511 5.918933645378e+00
RINT13455 nd2481 nd2512 5.111028301069e+00
RINT13456 nd2482 nd2513 5.111028301069e+00
RINT13457 nd2483 nd2514 2.965348653754e+02
RINT13458 nd2484 nd2515 1.051936504946e+01
RINT13459 nd2485 nd2516 1.059376775131e+01
RINT13460 nd2486 nd2517 1.059376775131e+01
RINT13461 nd2487 nd2518 3.677205321604e+03
RINT13462 nd2488 nd2519 6.128675536007e+02
RINT13463 nd2489 nd2520 1.050630091887e+03
RINT13464 nd2490 nd2521 1.050630091887e+03
RINT13465 nd2491 nd2522 1.050630091887e+03
RINT13466 nd2492 nd2523 1.050630091887e+03
RINT13467 nd2493 nd2524 1.050630091887e+03
RINT13468 nd2494 nd2525 1.050630091887e+03
RINT13469 nd2495 nd2526 1.050630091887e+03
RINT13470 nd2496 nd2527 2.334733537526e+02
RINT13471 nd2497 nd2528 2.334733537526e+02
RINT13472 nd2498 nd2529 5.538970918181e+02
RINT13473 nd2499 nd2530 3.983936132610e+01
RINT13474 nd2500 nd2531 8.836967932549e+02
RINT13475 nd2501 nd2532 3.682069971895e+00
RINT13476 nd2502 nd2533 3.682069971895e+00
RINT13477 nd2503 nd2534 3.682069971895e+00
RINT13478 nd2504 nd2535 3.682069971895e+00
RINT13479 nd2505 nd2536 3.682069971895e+00
RINT13480 nd2506 nd2537 3.682069971895e+00
RINT13481 nd2507 nd2538 3.682069971895e+00
RINT13482 nd2508 nd2539 3.682069971895e+00
RINT13483 nd2509 nd2540 3.682069971895e+00
RINT13484 nd2510 nd2541 3.682069971895e+00
RINT13485 nd2511 nd2542 1.042035668855e+01
RINT13486 nd2512 nd2543 8.998029228461e+00
RINT13487 nd2513 nd2544 8.998029228461e+00
RINT13488 nd2514 nd2545 5.220533381408e+02
RINT13489 nd2515 nd2546 1.851947369575e+01
RINT13490 nd2516 nd2547 1.865046058263e+01
RINT13491 nd2517 nd2548 1.865046058263e+01
RINT13492 nd2518 nd2549 7.408377398100e+02
RINT13493 nd2519 nd2550 1.234729566350e+02
RINT13494 nd2520 nd2551 2.116679256600e+02
RINT13495 nd2521 nd2552 2.116679256600e+02
RINT13496 nd2522 nd2553 2.116679256600e+02
RINT13497 nd2523 nd2554 2.116679256600e+02
RINT13498 nd2524 nd2555 2.116679256600e+02
RINT13499 nd2525 nd2556 2.116679256600e+02
RINT13500 nd2526 nd2557 2.116679256600e+02
RINT13501 nd2527 nd2558 4.703731681333e+01
RINT13502 nd2528 nd2559 4.703731681333e+01
RINT13503 nd2529 nd2560 9.751427556557e+02
RINT13504 nd2530 nd2561 7.013769373582e+01
RINT13505 nd2531 nd2562 1.555759253601e+03
RINT13506 nd2532 nd2563 6.482330223337e+00
RINT13507 nd2533 nd2564 6.482330223337e+00
RINT13508 nd2534 nd2565 6.482330223337e+00
RINT13509 nd2535 nd2566 6.482330223337e+00
RINT13510 nd2536 nd2567 6.482330223337e+00
RINT13511 nd2537 nd2568 6.482330223337e+00
RINT13512 nd2538 nd2569 6.482330223337e+00
RINT13513 nd2539 nd2570 6.482330223337e+00
RINT13514 nd2540 nd2571 6.482330223337e+00
RINT13515 nd2541 nd2572 6.482330223337e+00
RINT13516 nd2542 nd2573 1.042035668855e+01
RINT13517 nd2543 nd2574 8.998029228461e+00
RINT13518 nd2544 nd2575 8.998029228461e+00
RINT13519 nd2545 nd2576 5.220533381408e+02
RINT13520 nd2546 nd2577 1.851947369575e+01
RINT13521 nd2547 nd2578 1.865046058263e+01
RINT13522 nd2548 nd2579 1.865046058263e+01
RINT13523 nd2549 nd2580 7.408377398100e+02
RINT13524 nd2550 nd2581 1.234729566350e+02
RINT13525 nd2551 nd2582 2.116679256600e+02
RINT13526 nd2552 nd2583 2.116679256600e+02
RINT13527 nd2553 nd2584 2.116679256600e+02
RINT13528 nd2554 nd2585 2.116679256600e+02
RINT13529 nd2555 nd2586 2.116679256600e+02
RINT13530 nd2556 nd2587 2.116679256600e+02
RINT13531 nd2557 nd2588 2.116679256600e+02
RINT13532 nd2558 nd2589 4.703731681333e+01
RINT13533 nd2559 nd2590 4.703731681333e+01
RINT13534 nd2560 nd2591 9.751427556557e+02
RINT13535 nd2561 nd2592 7.013769373582e+01
RINT13536 nd2562 nd2593 1.555759253601e+03
RINT13537 nd2563 nd2594 6.482330223337e+00
RINT13538 nd2564 nd2595 6.482330223337e+00
RINT13539 nd2565 nd2596 6.482330223337e+00
RINT13540 nd2566 nd2597 6.482330223337e+00
RINT13541 nd2567 nd2598 6.482330223337e+00
RINT13542 nd2568 nd2599 6.482330223337e+00
RINT13543 nd2569 nd2600 6.482330223337e+00
RINT13544 nd2570 nd2601 6.482330223337e+00
RINT13545 nd2571 nd2602 6.482330223337e+00
RINT13546 nd2572 nd2603 6.482330223337e+00
RINT13547 nd2604 nd2635 1.042035668855e+01
RINT13548 nd2605 nd2636 8.998029228461e+00
RINT13549 nd2606 nd2637 8.998029228461e+00
RINT13550 nd2607 nd2638 5.220533381408e+02
RINT13551 nd2608 nd2639 1.851947369575e+01
RINT13552 nd2609 nd2640 1.865046058263e+01
RINT13553 nd2610 nd2641 1.865046058263e+01
RINT13554 nd2611 nd2642 7.408377398100e+02
RINT13555 nd2612 nd2643 1.234729566350e+02
RINT13556 nd2613 nd2644 2.116679256600e+02
RINT13557 nd2614 nd2645 2.116679256600e+02
RINT13558 nd2615 nd2646 2.116679256600e+02
RINT13559 nd2616 nd2647 2.116679256600e+02
RINT13560 nd2617 nd2648 2.116679256600e+02
RINT13561 nd2618 nd2649 2.116679256600e+02
RINT13562 nd2619 nd2650 2.116679256600e+02
RINT13563 nd2620 nd2651 4.703731681333e+01
RINT13564 nd2621 nd2652 4.703731681333e+01
RINT13565 nd2622 nd2653 9.751427556557e+02
RINT13566 nd2623 nd2654 7.013769373582e+01
RINT13567 nd2624 nd2655 1.555759253601e+03
RINT13568 nd2625 nd2656 6.482330223337e+00
RINT13569 nd2626 nd2657 6.482330223337e+00
RINT13570 nd2627 nd2658 6.482330223337e+00
RINT13571 nd2628 nd2659 6.482330223337e+00
RINT13572 nd2629 nd2660 6.482330223337e+00
RINT13573 nd2630 nd2661 6.482330223337e+00
RINT13574 nd2631 nd2662 6.482330223337e+00
RINT13575 nd2632 nd2663 6.482330223337e+00
RINT13576 nd2633 nd2664 6.482330223337e+00
RINT13577 nd2634 nd2665 6.482330223337e+00
RINT13578 nd2635 nd2666 1.042035668855e+01
RINT13579 nd2636 nd2667 8.998029228461e+00
RINT13580 nd2637 nd2668 8.998029228461e+00
RINT13581 nd2638 nd2669 5.220533381408e+02
RINT13582 nd2639 nd2670 1.851947369575e+01
RINT13583 nd2640 nd2671 1.865046058263e+01
RINT13584 nd2641 nd2672 1.865046058263e+01
RINT13585 nd2642 nd2673 7.408377398100e+02
RINT13586 nd2643 nd2674 1.234729566350e+02
RINT13587 nd2644 nd2675 2.116679256600e+02
RINT13588 nd2645 nd2676 2.116679256600e+02
RINT13589 nd2646 nd2677 2.116679256600e+02
RINT13590 nd2647 nd2678 2.116679256600e+02
RINT13591 nd2648 nd2679 2.116679256600e+02
RINT13592 nd2649 nd2680 2.116679256600e+02
RINT13593 nd2650 nd2681 2.116679256600e+02
RINT13594 nd2651 nd2682 4.703731681333e+01
RINT13595 nd2652 nd2683 4.703731681333e+01
RINT13596 nd2653 nd2684 9.751427556557e+02
RINT13597 nd2654 nd2685 7.013769373582e+01
RINT13598 nd2655 nd2686 1.555759253601e+03
RINT13599 nd2656 nd2687 6.482330223337e+00
RINT13600 nd2657 nd2688 6.482330223337e+00
RINT13601 nd2658 nd2689 6.482330223337e+00
RINT13602 nd2659 nd2690 6.482330223337e+00
RINT13603 nd2660 nd2691 6.482330223337e+00
RINT13604 nd2661 nd2692 6.482330223337e+00
RINT13605 nd2662 nd2693 6.482330223337e+00
RINT13606 nd2663 nd2694 6.482330223337e+00
RINT13607 nd2664 nd2695 6.482330223337e+00
RINT13608 nd2665 nd2696 6.482330223337e+00
RINT13609 nd2666 nd2697 5.918933645377e+00
RINT13610 nd2667 nd2698 5.111028301069e+00
RINT13611 nd2668 nd2699 5.111028301069e+00
RINT13612 nd2669 nd2700 2.965348653754e+02
RINT13613 nd2670 nd2701 1.051936504946e+01
RINT13614 nd2671 nd2702 1.059376775131e+01
RINT13615 nd2672 nd2703 1.059376775131e+01
RINT13616 nd2673 nd2704 3.677205321604e+03
RINT13617 nd2674 nd2705 6.128675536007e+02
RINT13618 nd2675 nd2706 1.050630091887e+03
RINT13619 nd2676 nd2707 1.050630091887e+03
RINT13620 nd2677 nd2708 1.050630091887e+03
RINT13621 nd2678 nd2709 1.050630091887e+03
RINT13622 nd2679 nd2710 1.050630091887e+03
RINT13623 nd2680 nd2711 1.050630091887e+03
RINT13624 nd2681 nd2712 1.050630091887e+03
RINT13625 nd2682 nd2713 2.334733537526e+02
RINT13626 nd2683 nd2714 2.334733537526e+02
RINT13627 nd2684 nd2715 5.538970918181e+02
RINT13628 nd2685 nd2716 3.983936132610e+01
RINT13629 nd2686 nd2717 8.836967932549e+02
RINT13630 nd2687 nd2718 3.682069971895e+00
RINT13631 nd2688 nd2719 3.682069971895e+00
RINT13632 nd2689 nd2720 3.682069971895e+00
RINT13633 nd2690 nd2721 3.682069971895e+00
RINT13634 nd2691 nd2722 3.682069971895e+00
RINT13635 nd2692 nd2723 3.682069971895e+00
RINT13636 nd2693 nd2724 3.682069971895e+00
RINT13637 nd2694 nd2725 3.682069971895e+00
RINT13638 nd2695 nd2726 3.682069971895e+00
RINT13639 nd2696 nd2727 3.682069971895e+00
RINT13640 nd2697 nd2728 7.494898898358e+00
RINT13641 nd2698 nd2729 6.471882044678e+00
RINT13642 nd2699 nd2730 6.471882044678e+00
RINT13643 nd2700 nd2731 3.754897366627e+02
RINT13644 nd2701 nd2732 1.332023338058e+01
RINT13645 nd2702 nd2733 1.341444641988e+01
RINT13646 nd2703 nd2734 1.341444641988e+01
RINT13647 nd2704 nd2735 3.942767563891e+03
RINT13648 nd2705 nd2736 6.216370766103e+02
RINT13649 nd2706 nd2737 1.083955004199e+03
RINT13650 nd2707 nd2738 1.083955004199e+03
RINT13651 nd2708 nd2739 1.083955004199e+03
RINT13652 nd2709 nd2740 1.083955004199e+03
RINT13653 nd2710 nd2741 1.083955004199e+03
RINT13654 nd2711 nd2742 1.083955004199e+03
RINT13655 nd2712 nd2743 1.083955004199e+03
RINT13656 nd2713 nd2744 2.368141244230e+02
RINT13657 nd2714 nd2745 2.376222816265e+02
RINT13658 nd2715 nd2746 7.013767938611e+02
RINT13659 nd2716 nd2747 5.044692223361e+01
RINT13660 nd2717 nd2748 1.118988405525e+03
RINT13661 nd2718 nd2749 4.662451689687e+00
RINT13662 nd2719 nd2750 4.662451689687e+00
RINT13663 nd2720 nd2751 4.662451689687e+00
RINT13664 nd2721 nd2752 4.662451689687e+00
RINT13665 nd2722 nd2753 4.662451689687e+00
RINT13666 nd2723 nd2754 4.662451689687e+00
RINT13667 nd2724 nd2755 4.662451689687e+00
RINT13668 nd2725 nd2756 4.662451689687e+00
RINT13669 nd2726 nd2757 4.662451689687e+00
RINT13670 nd2727 nd2758 4.662451689687e+00
RINT13671 nd2728 nd2759 1.357228719451e+01
RINT13672 nd2729 nd2760 1.171973671568e+01
RINT13673 nd2730 nd2761 1.171973671568e+01
RINT13674 nd2731 nd2762 6.799630807155e+02
RINT13675 nd2732 nd2763 2.412121035800e+01
RINT13676 nd2733 nd2764 2.429181791977e+01
RINT13677 nd2734 nd2765 2.429181791977e+01
RINT13678 nd2735 nd2766 1.271962224384e+03
RINT13679 nd2736 nd2767 1.410120026542e+02
RINT13680 nd2737 nd2768 2.783177502845e+02
RINT13681 nd2738 nd2769 2.783177502845e+02
RINT13682 nd2739 nd2770 2.783177502845e+02
RINT13683 nd2740 nd2771 2.783177502845e+02
RINT13684 nd2741 nd2772 2.783177502845e+02
RINT13685 nd2742 nd2773 2.783177502845e+02
RINT13686 nd2743 nd2774 2.783177502845e+02
RINT13687 nd2744 nd2775 5.371885815399e+01
RINT13688 nd2745 nd2776 5.533517256115e+01
RINT13689 nd2746 nd2777 1.270102159742e+03
RINT13690 nd2747 nd2778 9.135281555084e+01
RINT13691 nd2748 nd2779 2.026342478141e+03
RINT13692 nd2749 nd2780 8.443093658921e+00
RINT13693 nd2750 nd2781 8.443093658921e+00
RINT13694 nd2751 nd2782 8.443093658921e+00
RINT13695 nd2752 nd2783 8.443093658921e+00
RINT13696 nd2753 nd2784 8.443093658921e+00
RINT13697 nd2754 nd2785 8.443093658921e+00
RINT13698 nd2755 nd2786 8.443093658921e+00
RINT13699 nd2756 nd2787 8.443093658921e+00
RINT13700 nd2757 nd2788 8.443093658921e+00
RINT13701 nd2758 nd2789 8.443093658921e+00
RINT13702 nd2759 nd2790 1.357228719451e+01
RINT13703 nd2760 nd2791 1.171973671568e+01
RINT13704 nd2761 nd2792 1.171973671568e+01
RINT13705 nd2762 nd2793 6.799630807155e+02
RINT13706 nd2763 nd2794 2.412121035800e+01
RINT13707 nd2764 nd2795 2.429181791977e+01
RINT13708 nd2765 nd2796 2.429181791977e+01
RINT13709 nd2766 nd2797 1.271962224384e+03
RINT13710 nd2767 nd2798 1.410120026542e+02
RINT13711 nd2768 nd2799 2.783177502845e+02
RINT13712 nd2769 nd2800 2.783177502845e+02
RINT13713 nd2770 nd2801 2.783177502845e+02
RINT13714 nd2771 nd2802 2.783177502845e+02
RINT13715 nd2772 nd2803 2.783177502845e+02
RINT13716 nd2773 nd2804 2.783177502845e+02
RINT13717 nd2774 nd2805 2.783177502845e+02
RINT13718 nd2775 nd2806 5.371885815399e+01
RINT13719 nd2776 nd2807 5.533517256115e+01
RINT13720 nd2777 nd2808 1.270102159742e+03
RINT13721 nd2778 nd2809 9.135281555084e+01
RINT13722 nd2779 nd2810 2.026342478141e+03
RINT13723 nd2780 nd2811 8.443093658921e+00
RINT13724 nd2781 nd2812 8.443093658921e+00
RINT13725 nd2782 nd2813 8.443093658921e+00
RINT13726 nd2783 nd2814 8.443093658921e+00
RINT13727 nd2784 nd2815 8.443093658921e+00
RINT13728 nd2785 nd2816 8.443093658921e+00
RINT13729 nd2786 nd2817 8.443093658921e+00
RINT13730 nd2787 nd2818 8.443093658921e+00
RINT13731 nd2788 nd2819 8.443093658921e+00
RINT13732 nd2789 nd2820 8.443093658921e+00
RINT13733 nd2790 nd2821 1.357228719451e+01
RINT13734 nd2791 nd2822 1.171973671568e+01
RINT13735 nd2792 nd2823 1.171973671568e+01
RINT13736 nd2793 nd2824 6.799630807155e+02
RINT13737 nd2794 nd2825 2.412121035800e+01
RINT13738 nd2795 nd2826 2.429181791977e+01
RINT13739 nd2796 nd2827 2.429181791977e+01
RINT13740 nd2797 nd2828 1.271962224384e+03
RINT13741 nd2798 nd2829 1.410120026542e+02
RINT13742 nd2799 nd2830 2.783177502845e+02
RINT13743 nd2800 nd2831 2.783177502845e+02
RINT13744 nd2801 nd2832 2.783177502845e+02
RINT13745 nd2802 nd2833 2.783177502845e+02
RINT13746 nd2803 nd2834 2.783177502845e+02
RINT13747 nd2804 nd2835 2.783177502845e+02
RINT13748 nd2805 nd2836 2.783177502845e+02
RINT13749 nd2806 nd2837 5.371885815399e+01
RINT13750 nd2807 nd2838 5.533517256115e+01
RINT13751 nd2808 nd2839 1.270102159742e+03
RINT13752 nd2809 nd2840 9.135281555084e+01
RINT13753 nd2810 nd2841 2.026342478141e+03
RINT13754 nd2811 nd2842 8.443093658921e+00
RINT13755 nd2812 nd2843 8.443093658921e+00
RINT13756 nd2813 nd2844 8.443093658921e+00
RINT13757 nd2814 nd2845 8.443093658921e+00
RINT13758 nd2815 nd2846 8.443093658921e+00
RINT13759 nd2816 nd2847 8.443093658921e+00
RINT13760 nd2817 nd2848 8.443093658921e+00
RINT13761 nd2818 nd2849 8.443093658921e+00
RINT13762 nd2819 nd2850 8.443093658921e+00
RINT13763 nd2820 nd2851 8.443093658921e+00
RINT13764 nd2821 nd2852 1.357228719451e+01
RINT13765 nd2822 nd2853 1.171973671568e+01
RINT13766 nd2823 nd2854 1.171973671568e+01
RINT13767 nd2824 nd2855 6.799630807155e+02
RINT13768 nd2825 nd2856 2.412121035800e+01
RINT13769 nd2826 nd2857 2.429181791977e+01
RINT13770 nd2827 nd2858 2.429181791977e+01
RINT13771 nd2828 nd2859 1.271962224384e+03
RINT13772 nd2829 nd2860 1.410120026542e+02
RINT13773 nd2830 nd2861 2.783177502845e+02
RINT13774 nd2831 nd2862 2.783177502845e+02
RINT13775 nd2832 nd2863 2.783177502845e+02
RINT13776 nd2833 nd2864 2.783177502845e+02
RINT13777 nd2834 nd2865 2.783177502845e+02
RINT13778 nd2835 nd2866 2.783177502845e+02
RINT13779 nd2836 nd2867 2.783177502845e+02
RINT13780 nd2837 nd2868 5.371885815399e+01
RINT13781 nd2838 nd2869 5.533517256115e+01
RINT13782 nd2839 nd2870 1.270102159742e+03
RINT13783 nd2840 nd2871 9.135281555084e+01
RINT13784 nd2841 nd2872 2.026342478141e+03
RINT13785 nd2842 nd2873 8.443093658921e+00
RINT13786 nd2843 nd2874 8.443093658921e+00
RINT13787 nd2844 nd2875 8.443093658921e+00
RINT13788 nd2845 nd2876 8.443093658921e+00
RINT13789 nd2846 nd2877 8.443093658921e+00
RINT13790 nd2847 nd2878 8.443093658921e+00
RINT13791 nd2848 nd2879 8.443093658921e+00
RINT13792 nd2849 nd2880 8.443093658921e+00
RINT13793 nd2850 nd2881 8.443093658921e+00
RINT13794 nd2851 nd2882 8.443093658921e+00
RINT13795 nd2852 nd2883 1.357228719451e+01
RINT13796 nd2853 nd2884 1.171973671568e+01
RINT13797 nd2854 nd2885 1.171973671568e+01
RINT13798 nd2855 nd2886 6.799630807155e+02
RINT13799 nd2856 nd2887 2.412121035800e+01
RINT13800 nd2857 nd2888 2.429181791977e+01
RINT13801 nd2858 nd2889 2.429181791977e+01
RINT13802 nd2859 nd2890 1.271962224384e+03
RINT13803 nd2860 nd2891 1.410120026542e+02
RINT13804 nd2861 nd2892 2.783177502845e+02
RINT13805 nd2862 nd2893 2.783177502845e+02
RINT13806 nd2863 nd2894 2.783177502845e+02
RINT13807 nd2864 nd2895 2.783177502845e+02
RINT13808 nd2865 nd2896 2.783177502845e+02
RINT13809 nd2866 nd2897 2.783177502845e+02
RINT13810 nd2867 nd2898 2.783177502845e+02
RINT13811 nd2868 nd2899 5.371885815399e+01
RINT13812 nd2869 nd2900 5.533517256115e+01
RINT13813 nd2870 nd2901 1.270102159742e+03
RINT13814 nd2871 nd2902 9.135281555084e+01
RINT13815 nd2872 nd2903 2.026342478141e+03
RINT13816 nd2873 nd2904 8.443093658921e+00
RINT13817 nd2874 nd2905 8.443093658921e+00
RINT13818 nd2875 nd2906 8.443093658921e+00
RINT13819 nd2876 nd2907 8.443093658921e+00
RINT13820 nd2877 nd2908 8.443093658921e+00
RINT13821 nd2878 nd2909 8.443093658921e+00
RINT13822 nd2879 nd2910 8.443093658921e+00
RINT13823 nd2880 nd2911 8.443093658921e+00
RINT13824 nd2881 nd2912 8.443093658921e+00
RINT13825 nd2882 nd2913 8.443093658921e+00
RINT13826 nd2883 nd2914 7.494898898358e+00
RINT13827 nd2884 nd2915 6.471882044678e+00
RINT13828 nd2885 nd2916 6.471882044678e+00
RINT13829 nd2886 nd2917 3.754897366627e+02
RINT13830 nd2887 nd2918 1.332023338058e+01
RINT13831 nd2888 nd2919 1.341444641988e+01
RINT13832 nd2889 nd2920 1.341444641988e+01
RINT13833 nd2890 nd2921 3.942767563891e+03
RINT13834 nd2891 nd2922 6.216370766103e+02
RINT13835 nd2892 nd2923 1.083955004199e+03
RINT13836 nd2893 nd2924 1.083955004199e+03
RINT13837 nd2894 nd2925 1.083955004199e+03
RINT13838 nd2895 nd2926 1.083955004199e+03
RINT13839 nd2896 nd2927 1.083955004199e+03
RINT13840 nd2897 nd2928 1.083955004199e+03
RINT13841 nd2898 nd2929 1.083955004199e+03
RINT13842 nd2899 nd2930 2.368141244230e+02
RINT13843 nd2900 nd2931 2.376222816266e+02
RINT13844 nd2901 nd2932 7.013767938611e+02
RINT13845 nd2902 nd2933 5.044692223361e+01
RINT13846 nd2903 nd2934 1.118988405525e+03
RINT13847 nd2904 nd2935 4.662451689687e+00
RINT13848 nd2905 nd2936 4.662451689687e+00
RINT13849 nd2906 nd2937 4.662451689687e+00
RINT13850 nd2907 nd2938 4.662451689687e+00
RINT13851 nd2908 nd2939 4.662451689687e+00
RINT13852 nd2909 nd2940 4.662451689687e+00
RINT13853 nd2910 nd2941 4.662451689687e+00
RINT13854 nd2911 nd2942 4.662451689687e+00
RINT13855 nd2912 nd2943 4.662451689687e+00
RINT13856 nd2913 nd2944 4.662451689687e+00
RINT13857 nd2914 nd2945 7.494898898358e+00
RINT13858 nd2915 nd2946 6.471882044678e+00
RINT13859 nd2916 nd2947 6.471882044678e+00
RINT13860 nd2917 nd2948 3.754897366627e+02
RINT13861 nd2918 nd2949 1.332023338058e+01
RINT13862 nd2919 nd2950 1.341444641988e+01
RINT13863 nd2920 nd2951 1.341444641988e+01
RINT13864 nd2921 nd2952 3.942767563891e+03
RINT13865 nd2922 nd2953 6.216370766103e+02
RINT13866 nd2923 nd2954 1.083955004199e+03
RINT13867 nd2924 nd2955 1.083955004199e+03
RINT13868 nd2925 nd2956 1.083955004199e+03
RINT13869 nd2926 nd2957 1.083955004199e+03
RINT13870 nd2927 nd2958 1.083955004199e+03
RINT13871 nd2928 nd2959 1.083955004199e+03
RINT13872 nd2929 nd2960 1.083955004199e+03
RINT13873 nd2930 nd2961 2.368141244230e+02
RINT13874 nd2931 nd2962 2.376222816266e+02
RINT13875 nd2932 nd2963 7.013767938611e+02
RINT13876 nd2933 nd2964 5.044692223361e+01
RINT13877 nd2934 nd2965 1.118988405525e+03
RINT13878 nd2935 nd2966 4.662451689687e+00
RINT13879 nd2936 nd2967 4.662451689687e+00
RINT13880 nd2937 nd2968 4.662451689687e+00
RINT13881 nd2938 nd2969 4.662451689687e+00
RINT13882 nd2939 nd2970 4.662451689687e+00
RINT13883 nd2940 nd2971 4.662451689687e+00
RINT13884 nd2941 nd2972 4.662451689687e+00
RINT13885 nd2942 nd2973 4.662451689687e+00
RINT13886 nd2943 nd2974 4.662451689687e+00
RINT13887 nd2944 nd2975 4.662451689687e+00
RINT13888 nd2945 nd2976 1.357228719451e+01
RINT13889 nd2946 nd2977 1.171973671568e+01
RINT13890 nd2947 nd2978 1.171973671568e+01
RINT13891 nd2948 nd2979 6.799630807155e+02
RINT13892 nd2949 nd2980 2.412121035800e+01
RINT13893 nd2950 nd2981 2.429181791977e+01
RINT13894 nd2951 nd2982 2.429181791977e+01
RINT13895 nd2952 nd2983 1.271962224384e+03
RINT13896 nd2953 nd2984 1.410120026542e+02
RINT13897 nd2954 nd2985 2.783177502845e+02
RINT13898 nd2955 nd2986 2.783177502845e+02
RINT13899 nd2956 nd2987 2.783177502845e+02
RINT13900 nd2957 nd2988 2.783177502845e+02
RINT13901 nd2958 nd2989 2.783177502845e+02
RINT13902 nd2959 nd2990 2.783177502845e+02
RINT13903 nd2960 nd2991 2.783177502845e+02
RINT13904 nd2961 nd2992 5.371885815399e+01
RINT13905 nd2962 nd2993 5.533517256115e+01
RINT13906 nd2963 nd2994 1.270102159742e+03
RINT13907 nd2964 nd2995 9.135281555084e+01
RINT13908 nd2965 nd2996 2.026342478141e+03
RINT13909 nd2966 nd2997 8.443093658921e+00
RINT13910 nd2967 nd2998 8.443093658921e+00
RINT13911 nd2968 nd2999 8.443093658921e+00
RINT13912 nd2969 nd3000 8.443093658921e+00
RINT13913 nd2970 nd3001 8.443093658921e+00
RINT13914 nd2971 nd3002 8.443093658921e+00
RINT13915 nd2972 nd3003 8.443093658921e+00
RINT13916 nd2973 nd3004 8.443093658921e+00
RINT13917 nd2974 nd3005 8.443093658921e+00
RINT13918 nd2975 nd3006 8.443093658921e+00
RINT13919 nd2976 nd3007 1.357228719451e+01
RINT13920 nd2977 nd3008 1.171973671568e+01
RINT13921 nd2978 nd3009 1.171973671568e+01
RINT13922 nd2979 nd3010 6.799630807155e+02
RINT13923 nd2980 nd3011 2.412121035800e+01
RINT13924 nd2981 nd3012 2.429181791977e+01
RINT13925 nd2982 nd3013 2.429181791977e+01
RINT13926 nd2983 nd3014 1.271962224384e+03
RINT13927 nd2984 nd3015 1.410120026542e+02
RINT13928 nd2985 nd3016 2.783177502845e+02
RINT13929 nd2986 nd3017 2.783177502845e+02
RINT13930 nd2987 nd3018 2.783177502845e+02
RINT13931 nd2988 nd3019 2.783177502845e+02
RINT13932 nd2989 nd3020 2.783177502845e+02
RINT13933 nd2990 nd3021 2.783177502845e+02
RINT13934 nd2991 nd3022 2.783177502845e+02
RINT13935 nd2992 nd3023 5.371885815399e+01
RINT13936 nd2993 nd3024 5.533517256115e+01
RINT13937 nd2994 nd3025 1.270102159742e+03
RINT13938 nd2995 nd3026 9.135281555084e+01
RINT13939 nd2996 nd3027 2.026342478141e+03
RINT13940 nd2997 nd3028 8.443093658921e+00
RINT13941 nd2998 nd3029 8.443093658921e+00
RINT13942 nd2999 nd3030 8.443093658921e+00
RINT13943 nd3000 nd3031 8.443093658921e+00
RINT13944 nd3001 nd3032 8.443093658921e+00
RINT13945 nd3002 nd3033 8.443093658921e+00
RINT13946 nd3003 nd3034 8.443093658921e+00
RINT13947 nd3004 nd3035 8.443093658921e+00
RINT13948 nd3005 nd3036 8.443093658921e+00
RINT13949 nd3006 nd3037 8.443093658921e+00
RINT13950 nd3007 nd3038 1.357228719451e+01
RINT13951 nd3008 nd3039 1.171973671568e+01
RINT13952 nd3009 nd3040 1.171973671568e+01
RINT13953 nd3010 nd3041 6.799630807155e+02
RINT13954 nd3011 nd3042 2.412121035800e+01
RINT13955 nd3012 nd3043 2.429181791977e+01
RINT13956 nd3013 nd3044 2.429181791977e+01
RINT13957 nd3014 nd3045 1.271962224384e+03
RINT13958 nd3015 nd3046 1.410120026542e+02
RINT13959 nd3016 nd3047 2.783177502845e+02
RINT13960 nd3017 nd3048 2.783177502845e+02
RINT13961 nd3018 nd3049 2.783177502845e+02
RINT13962 nd3019 nd3050 2.783177502845e+02
RINT13963 nd3020 nd3051 2.783177502845e+02
RINT13964 nd3021 nd3052 2.783177502845e+02
RINT13965 nd3022 nd3053 2.783177502845e+02
RINT13966 nd3023 nd3054 5.371885815399e+01
RINT13967 nd3024 nd3055 5.533517256115e+01
RINT13968 nd3025 nd3056 1.270102159742e+03
RINT13969 nd3026 nd3057 9.135281555084e+01
RINT13970 nd3027 nd3058 2.026342478141e+03
RINT13971 nd3028 nd3059 8.443093658921e+00
RINT13972 nd3029 nd3060 8.443093658921e+00
RINT13973 nd3030 nd3061 8.443093658921e+00
RINT13974 nd3031 nd3062 8.443093658921e+00
RINT13975 nd3032 nd3063 8.443093658921e+00
RINT13976 nd3033 nd3064 8.443093658921e+00
RINT13977 nd3034 nd3065 8.443093658921e+00
RINT13978 nd3035 nd3066 8.443093658921e+00
RINT13979 nd3036 nd3067 8.443093658921e+00
RINT13980 nd3037 nd3068 8.443093658921e+00
RINT13981 nd3038 nd3069 1.357228719451e+01
RINT13982 nd3039 nd3070 1.171973671568e+01
RINT13983 nd3040 nd3071 1.171973671568e+01
RINT13984 nd3041 nd3072 6.799630807155e+02
RINT13985 nd3042 nd3073 2.412121035800e+01
RINT13986 nd3043 nd3074 2.429181791977e+01
RINT13987 nd3044 nd3075 2.429181791977e+01
RINT13988 nd3045 nd3076 1.271962224384e+03
RINT13989 nd3046 nd3077 1.410120026542e+02
RINT13990 nd3047 nd3078 2.783177502845e+02
RINT13991 nd3048 nd3079 2.783177502845e+02
RINT13992 nd3049 nd3080 2.783177502845e+02
RINT13993 nd3050 nd3081 2.783177502845e+02
RINT13994 nd3051 nd3082 2.783177502845e+02
RINT13995 nd3052 nd3083 2.783177502845e+02
RINT13996 nd3053 nd3084 2.783177502845e+02
RINT13997 nd3054 nd3085 5.371885815399e+01
RINT13998 nd3055 nd3086 5.533517256115e+01
RINT13999 nd3056 nd3087 1.270102159742e+03
RINT14000 nd3057 nd3088 9.135281555084e+01
RINT14001 nd3058 nd3089 2.026342478141e+03
RINT14002 nd3059 nd3090 8.443093658921e+00
RINT14003 nd3060 nd3091 8.443093658921e+00
RINT14004 nd3061 nd3092 8.443093658921e+00
RINT14005 nd3062 nd3093 8.443093658921e+00
RINT14006 nd3063 nd3094 8.443093658921e+00
RINT14007 nd3064 nd3095 8.443093658921e+00
RINT14008 nd3065 nd3096 8.443093658921e+00
RINT14009 nd3066 nd3097 8.443093658921e+00
RINT14010 nd3067 nd3098 8.443093658921e+00
RINT14011 nd3068 nd3099 8.443093658921e+00
RINT14012 nd3069 nd3100 1.357228719451e+01
RINT14013 nd3070 nd3101 1.171973671568e+01
RINT14014 nd3071 nd3102 1.171973671568e+01
RINT14015 nd3072 nd3103 6.799630807155e+02
RINT14016 nd3073 nd3104 2.412121035800e+01
RINT14017 nd3074 nd3105 2.429181791977e+01
RINT14018 nd3075 nd3106 2.429181791977e+01
RINT14019 nd3076 nd3107 1.271962224384e+03
RINT14020 nd3077 nd3108 1.410120026542e+02
RINT14021 nd3078 nd3109 2.783177502845e+02
RINT14022 nd3079 nd3110 2.783177502845e+02
RINT14023 nd3080 nd3111 2.783177502845e+02
RINT14024 nd3081 nd3112 2.783177502845e+02
RINT14025 nd3082 nd3113 2.783177502845e+02
RINT14026 nd3083 nd3114 2.783177502845e+02
RINT14027 nd3084 nd3115 2.783177502845e+02
RINT14028 nd3085 nd3116 5.371885815399e+01
RINT14029 nd3086 nd3117 5.533517256115e+01
RINT14030 nd3087 nd3118 1.270102159742e+03
RINT14031 nd3088 nd3119 9.135281555084e+01
RINT14032 nd3089 nd3120 2.026342478141e+03
RINT14033 nd3090 nd3121 8.443093658921e+00
RINT14034 nd3091 nd3122 8.443093658921e+00
RINT14035 nd3092 nd3123 8.443093658921e+00
RINT14036 nd3093 nd3124 8.443093658921e+00
RINT14037 nd3094 nd3125 8.443093658921e+00
RINT14038 nd3095 nd3126 8.443093658921e+00
RINT14039 nd3096 nd3127 8.443093658921e+00
RINT14040 nd3097 nd3128 8.443093658921e+00
RINT14041 nd3098 nd3129 8.443093658921e+00
RINT14042 nd3099 nd3130 8.443093658921e+00
RINT14043 nd3100 nd3131 7.494898898358e+00
RINT14044 nd3101 nd3132 6.471882044678e+00
RINT14045 nd3102 nd3133 6.471882044678e+00
RINT14046 nd3103 nd3134 3.754897366627e+02
RINT14047 nd3104 nd3135 1.332023338058e+01
RINT14048 nd3105 nd3136 1.341444641988e+01
RINT14049 nd3106 nd3137 1.341444641988e+01
RINT14050 nd3107 nd3138 3.942767563891e+03
RINT14051 nd3108 nd3139 6.216370766103e+02
RINT14052 nd3109 nd3140 1.083955004199e+03
RINT14053 nd3110 nd3141 1.083955004199e+03
RINT14054 nd3111 nd3142 1.083955004199e+03
RINT14055 nd3112 nd3143 1.083955004199e+03
RINT14056 nd3113 nd3144 1.083955004199e+03
RINT14057 nd3114 nd3145 1.083955004199e+03
RINT14058 nd3115 nd3146 1.083955004199e+03
RINT14059 nd3116 nd3147 2.368141244230e+02
RINT14060 nd3117 nd3148 2.376222816266e+02
RINT14061 nd3118 nd3149 7.013767938611e+02
RINT14062 nd3119 nd3150 5.044692223361e+01
RINT14063 nd3120 nd3151 1.118988405525e+03
RINT14064 nd3121 nd3152 4.662451689687e+00
RINT14065 nd3122 nd3153 4.662451689687e+00
RINT14066 nd3123 nd3154 4.662451689687e+00
RINT14067 nd3124 nd3155 4.662451689687e+00
RINT14068 nd3125 nd3156 4.662451689687e+00
RINT14069 nd3126 nd3157 4.662451689687e+00
RINT14070 nd3127 nd3158 4.662451689687e+00
RINT14071 nd3128 nd3159 4.662451689687e+00
RINT14072 nd3129 nd3160 4.662451689687e+00
RINT14073 nd3130 nd3161 4.662451689687e+00
RINT14074 nd3131 nd3162 5.918933645378e+00
RINT14075 nd3132 nd3163 5.111028301069e+00
RINT14076 nd3133 nd3164 5.111028301069e+00
RINT14077 nd3134 nd3165 2.965348653754e+02
RINT14078 nd3135 nd3166 1.051936504946e+01
RINT14079 nd3136 nd3167 1.059376775131e+01
RINT14080 nd3137 nd3168 1.059376775131e+01
RINT14081 nd3138 nd3169 3.677205321604e+03
RINT14082 nd3139 nd3170 6.128675536007e+02
RINT14083 nd3140 nd3171 1.050630091887e+03
RINT14084 nd3141 nd3172 1.050630091887e+03
RINT14085 nd3142 nd3173 1.050630091887e+03
RINT14086 nd3143 nd3174 1.050630091887e+03
RINT14087 nd3144 nd3175 1.050630091887e+03
RINT14088 nd3145 nd3176 1.050630091887e+03
RINT14089 nd3146 nd3177 1.050630091887e+03
RINT14090 nd3147 nd3178 2.334733537526e+02
RINT14091 nd3148 nd3179 2.334733537526e+02
RINT14092 nd3149 nd3180 5.538970918181e+02
RINT14093 nd3150 nd3181 3.983936132610e+01
RINT14094 nd3151 nd3182 8.836967932549e+02
RINT14095 nd3152 nd3183 3.682069971895e+00
RINT14096 nd3153 nd3184 3.682069971895e+00
RINT14097 nd3154 nd3185 3.682069971895e+00
RINT14098 nd3155 nd3186 3.682069971895e+00
RINT14099 nd3156 nd3187 3.682069971895e+00
RINT14100 nd3157 nd3188 3.682069971895e+00
RINT14101 nd3158 nd3189 3.682069971895e+00
RINT14102 nd3159 nd3190 3.682069971895e+00
RINT14103 nd3160 nd3191 3.682069971895e+00
RINT14104 nd3161 nd3192 3.682069971895e+00
RINT14105 nd3162 nd3193 1.042035668855e+01
RINT14106 nd3163 nd3194 8.998029228461e+00
RINT14107 nd3164 nd3195 8.998029228461e+00
RINT14108 nd3165 nd3196 5.220533381408e+02
RINT14109 nd3166 nd3197 1.851947369575e+01
RINT14110 nd3167 nd3198 1.865046058263e+01
RINT14111 nd3168 nd3199 1.865046058263e+01
RINT14112 nd3169 nd3200 7.408377398100e+02
RINT14113 nd3170 nd3201 1.234729566350e+02
RINT14114 nd3171 nd3202 2.116679256600e+02
RINT14115 nd3172 nd3203 2.116679256600e+02
RINT14116 nd3173 nd3204 2.116679256600e+02
RINT14117 nd3174 nd3205 2.116679256600e+02
RINT14118 nd3175 nd3206 2.116679256600e+02
RINT14119 nd3176 nd3207 2.116679256600e+02
RINT14120 nd3177 nd3208 2.116679256600e+02
RINT14121 nd3178 nd3209 4.703731681333e+01
RINT14122 nd3179 nd3210 4.703731681333e+01
RINT14123 nd3180 nd3211 9.751427556557e+02
RINT14124 nd3181 nd3212 7.013769373582e+01
RINT14125 nd3182 nd3213 1.555759253601e+03
RINT14126 nd3183 nd3214 6.482330223337e+00
RINT14127 nd3184 nd3215 6.482330223337e+00
RINT14128 nd3185 nd3216 6.482330223337e+00
RINT14129 nd3186 nd3217 6.482330223337e+00
RINT14130 nd3187 nd3218 6.482330223337e+00
RINT14131 nd3188 nd3219 6.482330223337e+00
RINT14132 nd3189 nd3220 6.482330223337e+00
RINT14133 nd3190 nd3221 6.482330223337e+00
RINT14134 nd3191 nd3222 6.482330223337e+00
RINT14135 nd3192 nd3223 6.482330223337e+00
RINT14136 nd3193 nd3224 1.042035668855e+01
RINT14137 nd3194 nd3225 8.998029228461e+00
RINT14138 nd3195 nd3226 8.998029228461e+00
RINT14139 nd3196 nd3227 5.220533381408e+02
RINT14140 nd3197 nd3228 1.851947369575e+01
RINT14141 nd3198 nd3229 1.865046058263e+01
RINT14142 nd3199 nd3230 1.865046058263e+01
RINT14143 nd3200 nd3231 7.408377398100e+02
RINT14144 nd3201 nd3232 1.234729566350e+02
RINT14145 nd3202 nd3233 2.116679256600e+02
RINT14146 nd3203 nd3234 2.116679256600e+02
RINT14147 nd3204 nd3235 2.116679256600e+02
RINT14148 nd3205 nd3236 2.116679256600e+02
RINT14149 nd3206 nd3237 2.116679256600e+02
RINT14150 nd3207 nd3238 2.116679256600e+02
RINT14151 nd3208 nd3239 2.116679256600e+02
RINT14152 nd3209 nd3240 4.703731681333e+01
RINT14153 nd3210 nd3241 4.703731681333e+01
RINT14154 nd3211 nd3242 9.751427556557e+02
RINT14155 nd3212 nd3243 7.013769373582e+01
RINT14156 nd3213 nd3244 1.555759253601e+03
RINT14157 nd3214 nd3245 6.482330223337e+00
RINT14158 nd3215 nd3246 6.482330223337e+00
RINT14159 nd3216 nd3247 6.482330223337e+00
RINT14160 nd3217 nd3248 6.482330223337e+00
RINT14161 nd3218 nd3249 6.482330223337e+00
RINT14162 nd3219 nd3250 6.482330223337e+00
RINT14163 nd3220 nd3251 6.482330223337e+00
RINT14164 nd3221 nd3252 6.482330223337e+00
RINT14165 nd3222 nd3253 6.482330223337e+00
RINT14166 nd3223 nd3254 6.482330223337e+00
RINT14167 nd3255 nd3286 1.042035668855e+01
RINT14168 nd3256 nd3287 8.998029228461e+00
RINT14169 nd3257 nd3288 8.998029228461e+00
RINT14170 nd3258 nd3289 5.220533381408e+02
RINT14171 nd3259 nd3290 1.851947369575e+01
RINT14172 nd3260 nd3291 1.865046058263e+01
RINT14173 nd3261 nd3292 1.865046058263e+01
RINT14174 nd3262 nd3293 7.408377398100e+02
RINT14175 nd3263 nd3294 1.234729566350e+02
RINT14176 nd3264 nd3295 2.116679256600e+02
RINT14177 nd3265 nd3296 2.116679256600e+02
RINT14178 nd3266 nd3297 2.116679256600e+02
RINT14179 nd3267 nd3298 2.116679256600e+02
RINT14180 nd3268 nd3299 2.116679256600e+02
RINT14181 nd3269 nd3300 2.116679256600e+02
RINT14182 nd3270 nd3301 2.116679256600e+02
RINT14183 nd3271 nd3302 4.703731681333e+01
RINT14184 nd3272 nd3303 4.703731681333e+01
RINT14185 nd3273 nd3304 9.751427556557e+02
RINT14186 nd3274 nd3305 7.013769373582e+01
RINT14187 nd3275 nd3306 1.555759253601e+03
RINT14188 nd3276 nd3307 6.482330223337e+00
RINT14189 nd3277 nd3308 6.482330223337e+00
RINT14190 nd3278 nd3309 6.482330223337e+00
RINT14191 nd3279 nd3310 6.482330223337e+00
RINT14192 nd3280 nd3311 6.482330223337e+00
RINT14193 nd3281 nd3312 6.482330223337e+00
RINT14194 nd3282 nd3313 6.482330223337e+00
RINT14195 nd3283 nd3314 6.482330223337e+00
RINT14196 nd3284 nd3315 6.482330223337e+00
RINT14197 nd3285 nd3316 6.482330223337e+00
RINT14198 nd3286 nd3317 1.042035668855e+01
RINT14199 nd3287 nd3318 8.998029228461e+00
RINT14200 nd3288 nd3319 8.998029228461e+00
RINT14201 nd3289 nd3320 5.220533381408e+02
RINT14202 nd3290 nd3321 1.851947369575e+01
RINT14203 nd3291 nd3322 1.865046058263e+01
RINT14204 nd3292 nd3323 1.865046058263e+01
RINT14205 nd3293 nd3324 7.408377398100e+02
RINT14206 nd3294 nd3325 1.234729566350e+02
RINT14207 nd3295 nd3326 2.116679256600e+02
RINT14208 nd3296 nd3327 2.116679256600e+02
RINT14209 nd3297 nd3328 2.116679256600e+02
RINT14210 nd3298 nd3329 2.116679256600e+02
RINT14211 nd3299 nd3330 2.116679256600e+02
RINT14212 nd3300 nd3331 2.116679256600e+02
RINT14213 nd3301 nd3332 2.116679256600e+02
RINT14214 nd3302 nd3333 4.703731681333e+01
RINT14215 nd3303 nd3334 4.703731681333e+01
RINT14216 nd3304 nd3335 9.751427556557e+02
RINT14217 nd3305 nd3336 7.013769373582e+01
RINT14218 nd3306 nd3337 1.555759253601e+03
RINT14219 nd3307 nd3338 6.482330223337e+00
RINT14220 nd3308 nd3339 6.482330223337e+00
RINT14221 nd3309 nd3340 6.482330223337e+00
RINT14222 nd3310 nd3341 6.482330223337e+00
RINT14223 nd3311 nd3342 6.482330223337e+00
RINT14224 nd3312 nd3343 6.482330223337e+00
RINT14225 nd3313 nd3344 6.482330223337e+00
RINT14226 nd3314 nd3345 6.482330223337e+00
RINT14227 nd3315 nd3346 6.482330223337e+00
RINT14228 nd3316 nd3347 6.482330223337e+00
RINT14229 nd3317 nd3348 5.918933645377e+00
RINT14230 nd3318 nd3349 5.111028301069e+00
RINT14231 nd3319 nd3350 5.111028301069e+00
RINT14232 nd3320 nd3351 2.965348653754e+02
RINT14233 nd3321 nd3352 1.051936504946e+01
RINT14234 nd3322 nd3353 1.059376775131e+01
RINT14235 nd3323 nd3354 1.059376775131e+01
RINT14236 nd3324 nd3355 3.677205321604e+03
RINT14237 nd3325 nd3356 6.128675536007e+02
RINT14238 nd3326 nd3357 1.050630091887e+03
RINT14239 nd3327 nd3358 1.050630091887e+03
RINT14240 nd3328 nd3359 1.050630091887e+03
RINT14241 nd3329 nd3360 1.050630091887e+03
RINT14242 nd3330 nd3361 1.050630091887e+03
RINT14243 nd3331 nd3362 1.050630091887e+03
RINT14244 nd3332 nd3363 1.050630091887e+03
RINT14245 nd3333 nd3364 2.334733537526e+02
RINT14246 nd3334 nd3365 2.334733537526e+02
RINT14247 nd3335 nd3366 5.538970918181e+02
RINT14248 nd3336 nd3367 3.983936132610e+01
RINT14249 nd3337 nd3368 8.836967932549e+02
RINT14250 nd3338 nd3369 3.682069971895e+00
RINT14251 nd3339 nd3370 3.682069971895e+00
RINT14252 nd3340 nd3371 3.682069971895e+00
RINT14253 nd3341 nd3372 3.682069971895e+00
RINT14254 nd3342 nd3373 3.682069971895e+00
RINT14255 nd3343 nd3374 3.682069971895e+00
RINT14256 nd3344 nd3375 3.682069971895e+00
RINT14257 nd3345 nd3376 3.682069971895e+00
RINT14258 nd3346 nd3377 3.682069971895e+00
RINT14259 nd3347 nd3378 3.682069971895e+00
RINT14260 nd3348 nd3379 7.494898898358e+00
RINT14261 nd3349 nd3380 6.471882044678e+00
RINT14262 nd3350 nd3381 6.471882044678e+00
RINT14263 nd3351 nd3382 3.754897366627e+02
RINT14264 nd3352 nd3383 1.332023338058e+01
RINT14265 nd3353 nd3384 1.341444641988e+01
RINT14266 nd3354 nd3385 1.341444641988e+01
RINT14267 nd3355 nd3386 3.942767563891e+03
RINT14268 nd3356 nd3387 6.216370766103e+02
RINT14269 nd3357 nd3388 1.083955004199e+03
RINT14270 nd3358 nd3389 1.083955004199e+03
RINT14271 nd3359 nd3390 1.083955004199e+03
RINT14272 nd3360 nd3391 1.083955004199e+03
RINT14273 nd3361 nd3392 1.083955004199e+03
RINT14274 nd3362 nd3393 1.083955004199e+03
RINT14275 nd3363 nd3394 1.083955004199e+03
RINT14276 nd3364 nd3395 2.368141244230e+02
RINT14277 nd3365 nd3396 2.376222816265e+02
RINT14278 nd3366 nd3397 7.013767938611e+02
RINT14279 nd3367 nd3398 5.044692223361e+01
RINT14280 nd3368 nd3399 1.118988405525e+03
RINT14281 nd3369 nd3400 4.662451689687e+00
RINT14282 nd3370 nd3401 4.662451689687e+00
RINT14283 nd3371 nd3402 4.662451689687e+00
RINT14284 nd3372 nd3403 4.662451689687e+00
RINT14285 nd3373 nd3404 4.662451689687e+00
RINT14286 nd3374 nd3405 4.662451689687e+00
RINT14287 nd3375 nd3406 4.662451689687e+00
RINT14288 nd3376 nd3407 4.662451689687e+00
RINT14289 nd3377 nd3408 4.662451689687e+00
RINT14290 nd3378 nd3409 4.662451689687e+00
RINT14291 nd3379 nd3410 1.357228719451e+01
RINT14292 nd3380 nd3411 1.171973671568e+01
RINT14293 nd3381 nd3412 1.171973671568e+01
RINT14294 nd3382 nd3413 6.799630807155e+02
RINT14295 nd3383 nd3414 2.412121035800e+01
RINT14296 nd3384 nd3415 2.429181791977e+01
RINT14297 nd3385 nd3416 2.429181791977e+01
RINT14298 nd3386 nd3417 1.271962224384e+03
RINT14299 nd3387 nd3418 1.410120026542e+02
RINT14300 nd3388 nd3419 2.783177502845e+02
RINT14301 nd3389 nd3420 2.783177502845e+02
RINT14302 nd3390 nd3421 2.783177502845e+02
RINT14303 nd3391 nd3422 2.783177502845e+02
RINT14304 nd3392 nd3423 2.783177502845e+02
RINT14305 nd3393 nd3424 2.783177502845e+02
RINT14306 nd3394 nd3425 2.783177502845e+02
RINT14307 nd3395 nd3426 5.371885815399e+01
RINT14308 nd3396 nd3427 5.533517256115e+01
RINT14309 nd3397 nd3428 1.270102159742e+03
RINT14310 nd3398 nd3429 9.135281555084e+01
RINT14311 nd3399 nd3430 2.026342478141e+03
RINT14312 nd3400 nd3431 8.443093658921e+00
RINT14313 nd3401 nd3432 8.443093658921e+00
RINT14314 nd3402 nd3433 8.443093658921e+00
RINT14315 nd3403 nd3434 8.443093658921e+00
RINT14316 nd3404 nd3435 8.443093658921e+00
RINT14317 nd3405 nd3436 8.443093658921e+00
RINT14318 nd3406 nd3437 8.443093658921e+00
RINT14319 nd3407 nd3438 8.443093658921e+00
RINT14320 nd3408 nd3439 8.443093658921e+00
RINT14321 nd3409 nd3440 8.443093658921e+00
RINT14322 nd3410 nd3441 1.357228719451e+01
RINT14323 nd3411 nd3442 1.171973671568e+01
RINT14324 nd3412 nd3443 1.171973671568e+01
RINT14325 nd3413 nd3444 6.799630807155e+02
RINT14326 nd3414 nd3445 2.412121035800e+01
RINT14327 nd3415 nd3446 2.429181791977e+01
RINT14328 nd3416 nd3447 2.429181791977e+01
RINT14329 nd3417 nd3448 1.271962224384e+03
RINT14330 nd3418 nd3449 1.410120026542e+02
RINT14331 nd3419 nd3450 2.783177502845e+02
RINT14332 nd3420 nd3451 2.783177502845e+02
RINT14333 nd3421 nd3452 2.783177502845e+02
RINT14334 nd3422 nd3453 2.783177502845e+02
RINT14335 nd3423 nd3454 2.783177502845e+02
RINT14336 nd3424 nd3455 2.783177502845e+02
RINT14337 nd3425 nd3456 2.783177502845e+02
RINT14338 nd3426 nd3457 5.371885815399e+01
RINT14339 nd3427 nd3458 5.533517256115e+01
RINT14340 nd3428 nd3459 1.270102159742e+03
RINT14341 nd3429 nd3460 9.135281555084e+01
RINT14342 nd3430 nd3461 2.026342478141e+03
RINT14343 nd3431 nd3462 8.443093658921e+00
RINT14344 nd3432 nd3463 8.443093658921e+00
RINT14345 nd3433 nd3464 8.443093658921e+00
RINT14346 nd3434 nd3465 8.443093658921e+00
RINT14347 nd3435 nd3466 8.443093658921e+00
RINT14348 nd3436 nd3467 8.443093658921e+00
RINT14349 nd3437 nd3468 8.443093658921e+00
RINT14350 nd3438 nd3469 8.443093658921e+00
RINT14351 nd3439 nd3470 8.443093658921e+00
RINT14352 nd3440 nd3471 8.443093658921e+00
RINT14353 nd3441 nd3472 1.357228719451e+01
RINT14354 nd3442 nd3473 1.171973671568e+01
RINT14355 nd3443 nd3474 1.171973671568e+01
RINT14356 nd3444 nd3475 6.799630807155e+02
RINT14357 nd3445 nd3476 2.412121035800e+01
RINT14358 nd3446 nd3477 2.429181791977e+01
RINT14359 nd3447 nd3478 2.429181791977e+01
RINT14360 nd3448 nd3479 1.271962224384e+03
RINT14361 nd3449 nd3480 1.410120026542e+02
RINT14362 nd3450 nd3481 2.783177502845e+02
RINT14363 nd3451 nd3482 2.783177502845e+02
RINT14364 nd3452 nd3483 2.783177502845e+02
RINT14365 nd3453 nd3484 2.783177502845e+02
RINT14366 nd3454 nd3485 2.783177502845e+02
RINT14367 nd3455 nd3486 2.783177502845e+02
RINT14368 nd3456 nd3487 2.783177502845e+02
RINT14369 nd3457 nd3488 5.371885815399e+01
RINT14370 nd3458 nd3489 5.533517256115e+01
RINT14371 nd3459 nd3490 1.270102159742e+03
RINT14372 nd3460 nd3491 9.135281555084e+01
RINT14373 nd3461 nd3492 2.026342478141e+03
RINT14374 nd3462 nd3493 8.443093658921e+00
RINT14375 nd3463 nd3494 8.443093658921e+00
RINT14376 nd3464 nd3495 8.443093658921e+00
RINT14377 nd3465 nd3496 8.443093658921e+00
RINT14378 nd3466 nd3497 8.443093658921e+00
RINT14379 nd3467 nd3498 8.443093658921e+00
RINT14380 nd3468 nd3499 8.443093658921e+00
RINT14381 nd3469 nd3500 8.443093658921e+00
RINT14382 nd3470 nd3501 8.443093658921e+00
RINT14383 nd3471 nd3502 8.443093658921e+00
RINT14384 nd3472 nd3503 1.357228719451e+01
RINT14385 nd3473 nd3504 1.171973671568e+01
RINT14386 nd3474 nd3505 1.171973671568e+01
RINT14387 nd3475 nd3506 6.799630807155e+02
RINT14388 nd3476 nd3507 2.412121035800e+01
RINT14389 nd3477 nd3508 2.429181791977e+01
RINT14390 nd3478 nd3509 2.429181791977e+01
RINT14391 nd3479 nd3510 1.271962224384e+03
RINT14392 nd3480 nd3511 1.410120026542e+02
RINT14393 nd3481 nd3512 2.783177502845e+02
RINT14394 nd3482 nd3513 2.783177502845e+02
RINT14395 nd3483 nd3514 2.783177502845e+02
RINT14396 nd3484 nd3515 2.783177502845e+02
RINT14397 nd3485 nd3516 2.783177502845e+02
RINT14398 nd3486 nd3517 2.783177502845e+02
RINT14399 nd3487 nd3518 2.783177502845e+02
RINT14400 nd3488 nd3519 5.371885815399e+01
RINT14401 nd3489 nd3520 5.533517256115e+01
RINT14402 nd3490 nd3521 1.270102159742e+03
RINT14403 nd3491 nd3522 9.135281555084e+01
RINT14404 nd3492 nd3523 2.026342478141e+03
RINT14405 nd3493 nd3524 8.443093658921e+00
RINT14406 nd3494 nd3525 8.443093658921e+00
RINT14407 nd3495 nd3526 8.443093658921e+00
RINT14408 nd3496 nd3527 8.443093658921e+00
RINT14409 nd3497 nd3528 8.443093658921e+00
RINT14410 nd3498 nd3529 8.443093658921e+00
RINT14411 nd3499 nd3530 8.443093658921e+00
RINT14412 nd3500 nd3531 8.443093658921e+00
RINT14413 nd3501 nd3532 8.443093658921e+00
RINT14414 nd3502 nd3533 8.443093658921e+00
RINT14415 nd3503 nd3534 1.357228719451e+01
RINT14416 nd3504 nd3535 1.171973671568e+01
RINT14417 nd3505 nd3536 1.171973671568e+01
RINT14418 nd3506 nd3537 6.799630807155e+02
RINT14419 nd3507 nd3538 2.412121035800e+01
RINT14420 nd3508 nd3539 2.429181791977e+01
RINT14421 nd3509 nd3540 2.429181791977e+01
RINT14422 nd3510 nd3541 1.271962224384e+03
RINT14423 nd3511 nd3542 1.410120026542e+02
RINT14424 nd3512 nd3543 2.783177502845e+02
RINT14425 nd3513 nd3544 2.783177502845e+02
RINT14426 nd3514 nd3545 2.783177502845e+02
RINT14427 nd3515 nd3546 2.783177502845e+02
RINT14428 nd3516 nd3547 2.783177502845e+02
RINT14429 nd3517 nd3548 2.783177502845e+02
RINT14430 nd3518 nd3549 2.783177502845e+02
RINT14431 nd3519 nd3550 5.371885815399e+01
RINT14432 nd3520 nd3551 5.533517256115e+01
RINT14433 nd3521 nd3552 1.270102159742e+03
RINT14434 nd3522 nd3553 9.135281555084e+01
RINT14435 nd3523 nd3554 2.026342478141e+03
RINT14436 nd3524 nd3555 8.443093658921e+00
RINT14437 nd3525 nd3556 8.443093658921e+00
RINT14438 nd3526 nd3557 8.443093658921e+00
RINT14439 nd3527 nd3558 8.443093658921e+00
RINT14440 nd3528 nd3559 8.443093658921e+00
RINT14441 nd3529 nd3560 8.443093658921e+00
RINT14442 nd3530 nd3561 8.443093658921e+00
RINT14443 nd3531 nd3562 8.443093658921e+00
RINT14444 nd3532 nd3563 8.443093658921e+00
RINT14445 nd3533 nd3564 8.443093658921e+00
RINT14446 nd3534 nd3565 7.494898898358e+00
RINT14447 nd3535 nd3566 6.471882044678e+00
RINT14448 nd3536 nd3567 6.471882044678e+00
RINT14449 nd3537 nd3568 3.754897366627e+02
RINT14450 nd3538 nd3569 1.332023338058e+01
RINT14451 nd3539 nd3570 1.341444641988e+01
RINT14452 nd3540 nd3571 1.341444641988e+01
RINT14453 nd3541 nd3572 3.942767563891e+03
RINT14454 nd3542 nd3573 6.216370766103e+02
RINT14455 nd3543 nd3574 1.083955004199e+03
RINT14456 nd3544 nd3575 1.083955004199e+03
RINT14457 nd3545 nd3576 1.083955004199e+03
RINT14458 nd3546 nd3577 1.083955004199e+03
RINT14459 nd3547 nd3578 1.083955004199e+03
RINT14460 nd3548 nd3579 1.083955004199e+03
RINT14461 nd3549 nd3580 1.083955004199e+03
RINT14462 nd3550 nd3581 2.368141244230e+02
RINT14463 nd3551 nd3582 2.376222816266e+02
RINT14464 nd3552 nd3583 7.013767938611e+02
RINT14465 nd3553 nd3584 5.044692223361e+01
RINT14466 nd3554 nd3585 1.118988405525e+03
RINT14467 nd3555 nd3586 4.662451689687e+00
RINT14468 nd3556 nd3587 4.662451689687e+00
RINT14469 nd3557 nd3588 4.662451689687e+00
RINT14470 nd3558 nd3589 4.662451689687e+00
RINT14471 nd3559 nd3590 4.662451689687e+00
RINT14472 nd3560 nd3591 4.662451689687e+00
RINT14473 nd3561 nd3592 4.662451689687e+00
RINT14474 nd3562 nd3593 4.662451689687e+00
RINT14475 nd3563 nd3594 4.662451689687e+00
RINT14476 nd3564 nd3595 4.662451689687e+00
RINT14477 nd3565 nd3596 7.494898898358e+00
RINT14478 nd3566 nd3597 6.471882044678e+00
RINT14479 nd3567 nd3598 6.471882044678e+00
RINT14480 nd3568 nd3599 3.754897366627e+02
RINT14481 nd3569 nd3600 1.332023338058e+01
RINT14482 nd3570 nd3601 1.341444641988e+01
RINT14483 nd3571 nd3602 1.341444641988e+01
RINT14484 nd3572 nd3603 3.942767563891e+03
RINT14485 nd3573 nd3604 6.216370766103e+02
RINT14486 nd3574 nd3605 1.083955004199e+03
RINT14487 nd3575 nd3606 1.083955004199e+03
RINT14488 nd3576 nd3607 1.083955004199e+03
RINT14489 nd3577 nd3608 1.083955004199e+03
RINT14490 nd3578 nd3609 1.083955004199e+03
RINT14491 nd3579 nd3610 1.083955004199e+03
RINT14492 nd3580 nd3611 1.083955004199e+03
RINT14493 nd3581 nd3612 2.368141244230e+02
RINT14494 nd3582 nd3613 2.376222816266e+02
RINT14495 nd3583 nd3614 7.013767938611e+02
RINT14496 nd3584 nd3615 5.044692223361e+01
RINT14497 nd3585 nd3616 1.118988405525e+03
RINT14498 nd3586 nd3617 4.662451689687e+00
RINT14499 nd3587 nd3618 4.662451689687e+00
RINT14500 nd3588 nd3619 4.662451689687e+00
RINT14501 nd3589 nd3620 4.662451689687e+00
RINT14502 nd3590 nd3621 4.662451689687e+00
RINT14503 nd3591 nd3622 4.662451689687e+00
RINT14504 nd3592 nd3623 4.662451689687e+00
RINT14505 nd3593 nd3624 4.662451689687e+00
RINT14506 nd3594 nd3625 4.662451689687e+00
RINT14507 nd3595 nd3626 4.662451689687e+00
RINT14508 nd3596 nd3627 1.357228719451e+01
RINT14509 nd3597 nd3628 1.171973671568e+01
RINT14510 nd3598 nd3629 1.171973671568e+01
RINT14511 nd3599 nd3630 6.799630807155e+02
RINT14512 nd3600 nd3631 2.412121035800e+01
RINT14513 nd3601 nd3632 2.429181791977e+01
RINT14514 nd3602 nd3633 2.429181791977e+01
RINT14515 nd3603 nd3634 1.271962224384e+03
RINT14516 nd3604 nd3635 1.410120026542e+02
RINT14517 nd3605 nd3636 2.783177502845e+02
RINT14518 nd3606 nd3637 2.783177502845e+02
RINT14519 nd3607 nd3638 2.783177502845e+02
RINT14520 nd3608 nd3639 2.783177502845e+02
RINT14521 nd3609 nd3640 2.783177502845e+02
RINT14522 nd3610 nd3641 2.783177502845e+02
RINT14523 nd3611 nd3642 2.783177502845e+02
RINT14524 nd3612 nd3643 5.371885815399e+01
RINT14525 nd3613 nd3644 5.533517256115e+01
RINT14526 nd3614 nd3645 1.270102159742e+03
RINT14527 nd3615 nd3646 9.135281555084e+01
RINT14528 nd3616 nd3647 2.026342478141e+03
RINT14529 nd3617 nd3648 8.443093658921e+00
RINT14530 nd3618 nd3649 8.443093658921e+00
RINT14531 nd3619 nd3650 8.443093658921e+00
RINT14532 nd3620 nd3651 8.443093658921e+00
RINT14533 nd3621 nd3652 8.443093658921e+00
RINT14534 nd3622 nd3653 8.443093658921e+00
RINT14535 nd3623 nd3654 8.443093658921e+00
RINT14536 nd3624 nd3655 8.443093658921e+00
RINT14537 nd3625 nd3656 8.443093658921e+00
RINT14538 nd3626 nd3657 8.443093658921e+00
RINT14539 nd3627 nd3658 1.357228719451e+01
RINT14540 nd3628 nd3659 1.171973671568e+01
RINT14541 nd3629 nd3660 1.171973671568e+01
RINT14542 nd3630 nd3661 6.799630807155e+02
RINT14543 nd3631 nd3662 2.412121035800e+01
RINT14544 nd3632 nd3663 2.429181791977e+01
RINT14545 nd3633 nd3664 2.429181791977e+01
RINT14546 nd3634 nd3665 1.271962224384e+03
RINT14547 nd3635 nd3666 1.410120026542e+02
RINT14548 nd3636 nd3667 2.783177502845e+02
RINT14549 nd3637 nd3668 2.783177502845e+02
RINT14550 nd3638 nd3669 2.783177502845e+02
RINT14551 nd3639 nd3670 2.783177502845e+02
RINT14552 nd3640 nd3671 2.783177502845e+02
RINT14553 nd3641 nd3672 2.783177502845e+02
RINT14554 nd3642 nd3673 2.783177502845e+02
RINT14555 nd3643 nd3674 5.371885815399e+01
RINT14556 nd3644 nd3675 5.533517256115e+01
RINT14557 nd3645 nd3676 1.270102159742e+03
RINT14558 nd3646 nd3677 9.135281555084e+01
RINT14559 nd3647 nd3678 2.026342478141e+03
RINT14560 nd3648 nd3679 8.443093658921e+00
RINT14561 nd3649 nd3680 8.443093658921e+00
RINT14562 nd3650 nd3681 8.443093658921e+00
RINT14563 nd3651 nd3682 8.443093658921e+00
RINT14564 nd3652 nd3683 8.443093658921e+00
RINT14565 nd3653 nd3684 8.443093658921e+00
RINT14566 nd3654 nd3685 8.443093658921e+00
RINT14567 nd3655 nd3686 8.443093658921e+00
RINT14568 nd3656 nd3687 8.443093658921e+00
RINT14569 nd3657 nd3688 8.443093658921e+00
RINT14570 nd3658 nd3689 1.357228719451e+01
RINT14571 nd3659 nd3690 1.171973671568e+01
RINT14572 nd3660 nd3691 1.171973671568e+01
RINT14573 nd3661 nd3692 6.799630807155e+02
RINT14574 nd3662 nd3693 2.412121035800e+01
RINT14575 nd3663 nd3694 2.429181791977e+01
RINT14576 nd3664 nd3695 2.429181791977e+01
RINT14577 nd3665 nd3696 1.271962224384e+03
RINT14578 nd3666 nd3697 1.410120026542e+02
RINT14579 nd3667 nd3698 2.783177502845e+02
RINT14580 nd3668 nd3699 2.783177502845e+02
RINT14581 nd3669 nd3700 2.783177502845e+02
RINT14582 nd3670 nd3701 2.783177502845e+02
RINT14583 nd3671 nd3702 2.783177502845e+02
RINT14584 nd3672 nd3703 2.783177502845e+02
RINT14585 nd3673 nd3704 2.783177502845e+02
RINT14586 nd3674 nd3705 5.371885815399e+01
RINT14587 nd3675 nd3706 5.533517256115e+01
RINT14588 nd3676 nd3707 1.270102159742e+03
RINT14589 nd3677 nd3708 9.135281555084e+01
RINT14590 nd3678 nd3709 2.026342478141e+03
RINT14591 nd3679 nd3710 8.443093658921e+00
RINT14592 nd3680 nd3711 8.443093658921e+00
RINT14593 nd3681 nd3712 8.443093658921e+00
RINT14594 nd3682 nd3713 8.443093658921e+00
RINT14595 nd3683 nd3714 8.443093658921e+00
RINT14596 nd3684 nd3715 8.443093658921e+00
RINT14597 nd3685 nd3716 8.443093658921e+00
RINT14598 nd3686 nd3717 8.443093658921e+00
RINT14599 nd3687 nd3718 8.443093658921e+00
RINT14600 nd3688 nd3719 8.443093658921e+00
RINT14601 nd3689 nd3720 1.357228719451e+01
RINT14602 nd3690 nd3721 1.171973671568e+01
RINT14603 nd3691 nd3722 1.171973671568e+01
RINT14604 nd3692 nd3723 6.799630807155e+02
RINT14605 nd3693 nd3724 2.412121035800e+01
RINT14606 nd3694 nd3725 2.429181791977e+01
RINT14607 nd3695 nd3726 2.429181791977e+01
RINT14608 nd3696 nd3727 1.271962224384e+03
RINT14609 nd3697 nd3728 1.410120026542e+02
RINT14610 nd3698 nd3729 2.783177502845e+02
RINT14611 nd3699 nd3730 2.783177502845e+02
RINT14612 nd3700 nd3731 2.783177502845e+02
RINT14613 nd3701 nd3732 2.783177502845e+02
RINT14614 nd3702 nd3733 2.783177502845e+02
RINT14615 nd3703 nd3734 2.783177502845e+02
RINT14616 nd3704 nd3735 2.783177502845e+02
RINT14617 nd3705 nd3736 5.371885815399e+01
RINT14618 nd3706 nd3737 5.533517256115e+01
RINT14619 nd3707 nd3738 1.270102159742e+03
RINT14620 nd3708 nd3739 9.135281555084e+01
RINT14621 nd3709 nd3740 2.026342478141e+03
RINT14622 nd3710 nd3741 8.443093658921e+00
RINT14623 nd3711 nd3742 8.443093658921e+00
RINT14624 nd3712 nd3743 8.443093658921e+00
RINT14625 nd3713 nd3744 8.443093658921e+00
RINT14626 nd3714 nd3745 8.443093658921e+00
RINT14627 nd3715 nd3746 8.443093658921e+00
RINT14628 nd3716 nd3747 8.443093658921e+00
RINT14629 nd3717 nd3748 8.443093658921e+00
RINT14630 nd3718 nd3749 8.443093658921e+00
RINT14631 nd3719 nd3750 8.443093658921e+00
RINT14632 nd3720 nd3751 1.357228719451e+01
RINT14633 nd3721 nd3752 1.171973671568e+01
RINT14634 nd3722 nd3753 1.171973671568e+01
RINT14635 nd3723 nd3754 6.799630807155e+02
RINT14636 nd3724 nd3755 2.412121035800e+01
RINT14637 nd3725 nd3756 2.429181791977e+01
RINT14638 nd3726 nd3757 2.429181791977e+01
RINT14639 nd3727 nd3758 1.271962224384e+03
RINT14640 nd3728 nd3759 1.410120026542e+02
RINT14641 nd3729 nd3760 2.783177502845e+02
RINT14642 nd3730 nd3761 2.783177502845e+02
RINT14643 nd3731 nd3762 2.783177502845e+02
RINT14644 nd3732 nd3763 2.783177502845e+02
RINT14645 nd3733 nd3764 2.783177502845e+02
RINT14646 nd3734 nd3765 2.783177502845e+02
RINT14647 nd3735 nd3766 2.783177502845e+02
RINT14648 nd3736 nd3767 5.371885815399e+01
RINT14649 nd3737 nd3768 5.533517256115e+01
RINT14650 nd3738 nd3769 1.270102159742e+03
RINT14651 nd3739 nd3770 9.135281555084e+01
RINT14652 nd3740 nd3771 2.026342478141e+03
RINT14653 nd3741 nd3772 8.443093658921e+00
RINT14654 nd3742 nd3773 8.443093658921e+00
RINT14655 nd3743 nd3774 8.443093658921e+00
RINT14656 nd3744 nd3775 8.443093658921e+00
RINT14657 nd3745 nd3776 8.443093658921e+00
RINT14658 nd3746 nd3777 8.443093658921e+00
RINT14659 nd3747 nd3778 8.443093658921e+00
RINT14660 nd3748 nd3779 8.443093658921e+00
RINT14661 nd3749 nd3780 8.443093658921e+00
RINT14662 nd3750 nd3781 8.443093658921e+00
RINT14663 nd3751 nd3782 7.494898898358e+00
RINT14664 nd3752 nd3783 6.471882044678e+00
RINT14665 nd3753 nd3784 6.471882044678e+00
RINT14666 nd3754 nd3785 3.754897366627e+02
RINT14667 nd3755 nd3786 1.332023338058e+01
RINT14668 nd3756 nd3787 1.341444641988e+01
RINT14669 nd3757 nd3788 1.341444641988e+01
RINT14670 nd3758 nd3789 3.942767563891e+03
RINT14671 nd3759 nd3790 6.216370766103e+02
RINT14672 nd3760 nd3791 1.083955004199e+03
RINT14673 nd3761 nd3792 1.083955004199e+03
RINT14674 nd3762 nd3793 1.083955004199e+03
RINT14675 nd3763 nd3794 1.083955004199e+03
RINT14676 nd3764 nd3795 1.083955004199e+03
RINT14677 nd3765 nd3796 1.083955004199e+03
RINT14678 nd3766 nd3797 1.083955004199e+03
RINT14679 nd3767 nd3798 2.368141244230e+02
RINT14680 nd3768 nd3799 2.376222816266e+02
RINT14681 nd3769 nd3800 7.013767938611e+02
RINT14682 nd3770 nd3801 5.044692223361e+01
RINT14683 nd3771 nd3802 1.118988405525e+03
RINT14684 nd3772 nd3803 4.662451689687e+00
RINT14685 nd3773 nd3804 4.662451689687e+00
RINT14686 nd3774 nd3805 4.662451689687e+00
RINT14687 nd3775 nd3806 4.662451689687e+00
RINT14688 nd3776 nd3807 4.662451689687e+00
RINT14689 nd3777 nd3808 4.662451689687e+00
RINT14690 nd3778 nd3809 4.662451689687e+00
RINT14691 nd3779 nd3810 4.662451689687e+00
RINT14692 nd3780 nd3811 4.662451689687e+00
RINT14693 nd3781 nd3812 4.662451689687e+00
RINT14694 nd3782 nd3813 5.918933645378e+00
RINT14695 nd3783 nd3814 5.111028301069e+00
RINT14696 nd3784 nd3815 5.111028301069e+00
RINT14697 nd3785 nd3816 2.965348653754e+02
RINT14698 nd3786 nd3817 1.051936504946e+01
RINT14699 nd3787 nd3818 1.059376775131e+01
RINT14700 nd3788 nd3819 1.059376775131e+01
RINT14701 nd3789 nd3820 3.677205321604e+03
RINT14702 nd3790 nd3821 6.128675536007e+02
RINT14703 nd3791 nd3822 1.050630091887e+03
RINT14704 nd3792 nd3823 1.050630091887e+03
RINT14705 nd3793 nd3824 1.050630091887e+03
RINT14706 nd3794 nd3825 1.050630091887e+03
RINT14707 nd3795 nd3826 1.050630091887e+03
RINT14708 nd3796 nd3827 1.050630091887e+03
RINT14709 nd3797 nd3828 1.050630091887e+03
RINT14710 nd3798 nd3829 2.334733537526e+02
RINT14711 nd3799 nd3830 2.334733537526e+02
RINT14712 nd3800 nd3831 5.538970918181e+02
RINT14713 nd3801 nd3832 3.983936132610e+01
RINT14714 nd3802 nd3833 8.836967932549e+02
RINT14715 nd3803 nd3834 3.682069971895e+00
RINT14716 nd3804 nd3835 3.682069971895e+00
RINT14717 nd3805 nd3836 3.682069971895e+00
RINT14718 nd3806 nd3837 3.682069971895e+00
RINT14719 nd3807 nd3838 3.682069971895e+00
RINT14720 nd3808 nd3839 3.682069971895e+00
RINT14721 nd3809 nd3840 3.682069971895e+00
RINT14722 nd3810 nd3841 3.682069971895e+00
RINT14723 nd3811 nd3842 3.682069971895e+00
RINT14724 nd3812 nd3843 3.682069971895e+00
RINT14725 nd3813 nd3844 1.042035668855e+01
RINT14726 nd3814 nd3845 8.998029228461e+00
RINT14727 nd3815 nd3846 8.998029228461e+00
RINT14728 nd3816 nd3847 5.220533381408e+02
RINT14729 nd3817 nd3848 1.851947369575e+01
RINT14730 nd3818 nd3849 1.865046058263e+01
RINT14731 nd3819 nd3850 1.865046058263e+01
RINT14732 nd3820 nd3851 7.408377398100e+02
RINT14733 nd3821 nd3852 1.234729566350e+02
RINT14734 nd3822 nd3853 2.116679256600e+02
RINT14735 nd3823 nd3854 2.116679256600e+02
RINT14736 nd3824 nd3855 2.116679256600e+02
RINT14737 nd3825 nd3856 2.116679256600e+02
RINT14738 nd3826 nd3857 2.116679256600e+02
RINT14739 nd3827 nd3858 2.116679256600e+02
RINT14740 nd3828 nd3859 2.116679256600e+02
RINT14741 nd3829 nd3860 4.703731681333e+01
RINT14742 nd3830 nd3861 4.703731681333e+01
RINT14743 nd3831 nd3862 9.751427556557e+02
RINT14744 nd3832 nd3863 7.013769373582e+01
RINT14745 nd3833 nd3864 1.555759253601e+03
RINT14746 nd3834 nd3865 6.482330223337e+00
RINT14747 nd3835 nd3866 6.482330223337e+00
RINT14748 nd3836 nd3867 6.482330223337e+00
RINT14749 nd3837 nd3868 6.482330223337e+00
RINT14750 nd3838 nd3869 6.482330223337e+00
RINT14751 nd3839 nd3870 6.482330223337e+00
RINT14752 nd3840 nd3871 6.482330223337e+00
RINT14753 nd3841 nd3872 6.482330223337e+00
RINT14754 nd3842 nd3873 6.482330223337e+00
RINT14755 nd3843 nd3874 6.482330223337e+00
RINT14756 nd3844 nd3875 1.042035668855e+01
RINT14757 nd3845 nd3876 8.998029228461e+00
RINT14758 nd3846 nd3877 8.998029228461e+00
RINT14759 nd3847 nd3878 5.220533381408e+02
RINT14760 nd3848 nd3879 1.851947369575e+01
RINT14761 nd3849 nd3880 1.865046058263e+01
RINT14762 nd3850 nd3881 1.865046058263e+01
RINT14763 nd3851 nd3882 7.408377398100e+02
RINT14764 nd3852 nd3883 1.234729566350e+02
RINT14765 nd3853 nd3884 2.116679256600e+02
RINT14766 nd3854 nd3885 2.116679256600e+02
RINT14767 nd3855 nd3886 2.116679256600e+02
RINT14768 nd3856 nd3887 2.116679256600e+02
RINT14769 nd3857 nd3888 2.116679256600e+02
RINT14770 nd3858 nd3889 2.116679256600e+02
RINT14771 nd3859 nd3890 2.116679256600e+02
RINT14772 nd3860 nd3891 4.703731681333e+01
RINT14773 nd3861 nd3892 4.703731681333e+01
RINT14774 nd3862 nd3893 9.751427556557e+02
RINT14775 nd3863 nd3894 7.013769373582e+01
RINT14776 nd3864 nd3895 1.555759253601e+03
RINT14777 nd3865 nd3896 6.482330223337e+00
RINT14778 nd3866 nd3897 6.482330223337e+00
RINT14779 nd3867 nd3898 6.482330223337e+00
RINT14780 nd3868 nd3899 6.482330223337e+00
RINT14781 nd3869 nd3900 6.482330223337e+00
RINT14782 nd3870 nd3901 6.482330223337e+00
RINT14783 nd3871 nd3902 6.482330223337e+00
RINT14784 nd3872 nd3903 6.482330223337e+00
RINT14785 nd3873 nd3904 6.482330223337e+00
RINT14786 nd3874 nd3905 6.482330223337e+00
RINT14787 nd3906 nd3937 9.847510605046e+01
RINT14788 nd3907 nd3938 8.503373819163e+01
RINT14789 nd3908 nd3939 8.503373819163e+01
RINT14790 nd3909 nd3940 4.933541084432e+03
RINT14791 nd3910 nd3941 1.750138877867e+02
RINT14792 nd3911 nd3942 1.762517482517e+02
RINT14793 nd3912 nd3943 1.762517482517e+02
RINT14794 nd3913 nd3944 7.001111111111e+03
RINT14795 nd3914 nd3945 1.166851851852e+03
RINT14796 nd3915 nd3946 2.000317460317e+03
RINT14797 nd3916 nd3947 2.000317460317e+03
RINT14798 nd3917 nd3948 2.000317460317e+03
RINT14799 nd3918 nd3949 2.000317460317e+03
RINT14800 nd3919 nd3950 2.000317460317e+03
RINT14801 nd3920 nd3951 2.000317460317e+03
RINT14802 nd3921 nd3952 2.000317460317e+03
RINT14803 nd3922 nd3953 4.445149911817e+02
RINT14804 nd3923 nd3954 4.445149911817e+02
RINT14805 nd3924 nd3955 9.215355015920e+03
RINT14806 nd3925 nd3956 6.628196169481e+02
RINT14807 nd3926 nd3957 1.470233333333e+04
RINT14808 nd3927 nd3958 6.125972222222e+01
RINT14809 nd3928 nd3959 6.125972222222e+01
RINT14810 nd3929 nd3960 6.125972222222e+01
RINT14811 nd3930 nd3961 6.125972222222e+01
RINT14812 nd3931 nd3962 6.125972222222e+01
RINT14813 nd3932 nd3963 6.125972222222e+01
RINT14814 nd3933 nd3964 6.125972222222e+01
RINT14815 nd3934 nd3965 6.125972222222e+01
RINT14816 nd3935 nd3966 6.125972222222e+01
RINT14817 nd3936 nd3967 6.125972222222e+01
RINT14818 nd3937 nd3968 9.847510605046e+01
RINT14819 nd3938 nd3969 8.503373819163e+01
RINT14820 nd3939 nd3970 8.503373819163e+01
RINT14821 nd3940 nd3971 4.933541084432e+03
RINT14822 nd3941 nd3972 1.750138877867e+02
RINT14823 nd3942 nd3973 1.762517482517e+02
RINT14824 nd3943 nd3974 1.762517482517e+02
RINT14825 nd3944 nd3975 7.001111111111e+03
RINT14826 nd3945 nd3976 1.166851851852e+03
RINT14827 nd3946 nd3977 2.000317460317e+03
RINT14828 nd3947 nd3978 2.000317460317e+03
RINT14829 nd3948 nd3979 2.000317460317e+03
RINT14830 nd3949 nd3980 2.000317460317e+03
RINT14831 nd3950 nd3981 2.000317460317e+03
RINT14832 nd3951 nd3982 2.000317460317e+03
RINT14833 nd3952 nd3983 2.000317460317e+03
RINT14834 nd3953 nd3984 4.445149911817e+02
RINT14835 nd3954 nd3985 4.445149911817e+02
RINT14836 nd3955 nd3986 9.215355015920e+03
RINT14837 nd3956 nd3987 6.628196169481e+02
RINT14838 nd3957 nd3988 1.470233333333e+04
RINT14839 nd3958 nd3989 6.125972222222e+01
RINT14840 nd3959 nd3990 6.125972222222e+01
RINT14841 nd3960 nd3991 6.125972222222e+01
RINT14842 nd3961 nd3992 6.125972222222e+01
RINT14843 nd3962 nd3993 6.125972222222e+01
RINT14844 nd3963 nd3994 6.125972222222e+01
RINT14845 nd3964 nd3995 6.125972222222e+01
RINT14846 nd3965 nd3996 6.125972222222e+01
RINT14847 nd3966 nd3997 6.125972222222e+01
RINT14848 nd3967 nd3998 6.125972222222e+01
RINT14849 nd3968 nd3999 5.593547666890e+01
RINT14850 nd3969 nd4000 4.830055909003e+01
RINT14851 nd3970 nd4001 4.830055909003e+01
RINT14852 nd3971 nd4002 2.802332318199e+03
RINT14853 nd3972 nd4003 9.941076105071e+01
RINT14854 nd3973 nd4004 1.001138861139e+02
RINT14855 nd3974 nd4005 1.001138861139e+02
RINT14856 nd3975 nd4006 3.475055555556e+04
RINT14857 nd3976 nd4007 5.791759259259e+03
RINT14858 nd3977 nd4008 9.928730158730e+03
RINT14859 nd3978 nd4009 9.928730158730e+03
RINT14860 nd3979 nd4010 9.928730158730e+03
RINT14861 nd3980 nd4011 9.928730158730e+03
RINT14862 nd3981 nd4012 9.928730158730e+03
RINT14863 nd3982 nd4013 9.928730158730e+03
RINT14864 nd3983 nd4014 9.928730158730e+03
RINT14865 nd3984 nd4015 2.206384479718e+03
RINT14866 nd3985 nd4016 2.206384479718e+03
RINT14867 nd3986 nd4017 5.234472915668e+03
RINT14868 nd3987 nd4018 3.764924223640e+02
RINT14869 nd3988 nd4019 8.351166666667e+03
RINT14870 nd3989 nd4020 3.479652777778e+01
RINT14871 nd3990 nd4021 3.479652777778e+01
RINT14872 nd3991 nd4022 3.479652777778e+01
RINT14873 nd3992 nd4023 3.479652777778e+01
RINT14874 nd3993 nd4024 3.479652777778e+01
RINT14875 nd3994 nd4025 3.479652777778e+01
RINT14876 nd3995 nd4026 3.479652777778e+01
RINT14877 nd3996 nd4027 3.479652777778e+01
RINT14878 nd3997 nd4028 3.479652777778e+01
RINT14879 nd3998 nd4029 3.479652777778e+01
RINT14880 nd3999 nd4030 7.082876200045e+01
RINT14881 nd4000 nd4031 6.116098419125e+01
RINT14882 nd4001 nd4032 6.116098419125e+01
RINT14883 nd4002 nd4033 3.548476577518e+03
RINT14884 nd4003 nd4034 1.258797020078e+02
RINT14885 nd4004 nd4035 1.267700399600e+02
RINT14886 nd4005 nd4036 1.267700399600e+02
RINT14887 nd4006 nd4037 3.304604427083e+05
RINT14888 nd4007 nd4038 5.507674045139e+04
RINT14889 nd4008 nd4039 9.441726934524e+04
RINT14890 nd4009 nd4040 9.441726934524e+04
RINT14891 nd4010 nd4041 9.441726934524e+04
RINT14892 nd4011 nd4042 9.441726934524e+04
RINT14893 nd4012 nd4043 9.441726934524e+04
RINT14894 nd4013 nd4044 9.441726934524e+04
RINT14895 nd4014 nd4045 9.441726934524e+04
RINT14896 nd4015 nd4046 2.098161541005e+04
RINT14897 nd4016 nd4047 2.098161541005e+04
RINT14898 nd4017 nd4048 6.628194813396e+03
RINT14899 nd4018 nd4049 4.767366574247e+02
RINT14900 nd4019 nd4050 1.057473416667e+04
RINT14901 nd4020 nd4051 4.406139236111e+01
RINT14902 nd4021 nd4052 4.406139236111e+01
RINT14903 nd4022 nd4053 4.406139236111e+01
RINT14904 nd4023 nd4054 4.406139236111e+01
RINT14905 nd4024 nd4055 4.406139236111e+01
RINT14906 nd4025 nd4056 4.406139236111e+01
RINT14907 nd4026 nd4057 4.406139236111e+01
RINT14908 nd4027 nd4058 4.406139236111e+01
RINT14909 nd4028 nd4059 4.406139236111e+01
RINT14910 nd4029 nd4060 4.406139236111e+01
RINT14911 nd4030 nd4061 1.282616767136e+02
RINT14912 nd4031 nd4062 1.107545883941e+02
RINT14913 nd4032 nd4063 1.107545883941e+02
RINT14914 nd4033 nd4064 6.425829603070e+03
RINT14915 nd4034 nd4065 2.279517697008e+02
RINT14916 nd4035 nd4066 2.295640559441e+02
RINT14917 nd4036 nd4067 2.295640559441e+02
RINT14918 nd4037 nd4068 5.984208854167e+05
RINT14919 nd4038 nd4069 9.973681423611e+04
RINT14920 nd4039 nd4070 1.709773958333e+05
RINT14921 nd4040 nd4071 1.709773958333e+05
RINT14922 nd4041 nd4072 1.709773958333e+05
RINT14923 nd4042 nd4073 1.709773958333e+05
RINT14924 nd4043 nd4074 1.709773958333e+05
RINT14925 nd4044 nd4075 1.709773958333e+05
RINT14926 nd4045 nd4076 1.709773958333e+05
RINT14927 nd4046 nd4077 3.799497685185e+04
RINT14928 nd4047 nd4078 3.799497685185e+04
RINT14929 nd4048 nd4079 1.200279881138e+04
RINT14930 nd4049 nd4080 8.633080870696e+02
RINT14931 nd4050 nd4081 1.914946833333e+04
RINT14932 nd4051 nd4082 7.978945138889e+01
RINT14933 nd4052 nd4083 7.978945138889e+01
RINT14934 nd4053 nd4084 7.978945138889e+01
RINT14935 nd4054 nd4085 7.978945138889e+01
RINT14936 nd4055 nd4086 7.978945138889e+01
RINT14937 nd4056 nd4087 7.978945138889e+01
RINT14938 nd4057 nd4088 7.978945138889e+01
RINT14939 nd4058 nd4089 7.978945138889e+01
RINT14940 nd4059 nd4090 7.978945138889e+01
RINT14941 nd4060 nd4091 7.978945138889e+01
RINT14942 nd4061 nd4092 1.282616767136e+02
RINT14943 nd4062 nd4093 1.107545883941e+02
RINT14944 nd4063 nd4094 1.107545883941e+02
RINT14945 nd4064 nd4095 6.425829603070e+03
RINT14946 nd4065 nd4096 2.279517697008e+02
RINT14947 nd4066 nd4097 2.295640559441e+02
RINT14948 nd4067 nd4098 2.295640559441e+02
RINT14949 nd4068 nd4099 5.984208854167e+05
RINT14950 nd4069 nd4100 9.973681423611e+04
RINT14951 nd4070 nd4101 1.709773958333e+05
RINT14952 nd4071 nd4102 1.709773958333e+05
RINT14953 nd4072 nd4103 1.709773958333e+05
RINT14954 nd4073 nd4104 1.709773958333e+05
RINT14955 nd4074 nd4105 1.709773958333e+05
RINT14956 nd4075 nd4106 1.709773958333e+05
RINT14957 nd4076 nd4107 1.709773958333e+05
RINT14958 nd4077 nd4108 3.799497685185e+04
RINT14959 nd4078 nd4109 3.799497685185e+04
RINT14960 nd4079 nd4110 1.200279881138e+04
RINT14961 nd4080 nd4111 8.633080870696e+02
RINT14962 nd4081 nd4112 1.914946833333e+04
RINT14963 nd4082 nd4113 7.978945138889e+01
RINT14964 nd4083 nd4114 7.978945138889e+01
RINT14965 nd4084 nd4115 7.978945138889e+01
RINT14966 nd4085 nd4116 7.978945138889e+01
RINT14967 nd4086 nd4117 7.978945138889e+01
RINT14968 nd4087 nd4118 7.978945138889e+01
RINT14969 nd4088 nd4119 7.978945138889e+01
RINT14970 nd4089 nd4120 7.978945138889e+01
RINT14971 nd4090 nd4121 7.978945138889e+01
RINT14972 nd4091 nd4122 7.978945138889e+01
RINT14973 nd4092 nd4123 1.282616767136e+02
RINT14974 nd4093 nd4124 1.107545883941e+02
RINT14975 nd4094 nd4125 1.107545883941e+02
RINT14976 nd4095 nd4126 6.425829603070e+03
RINT14977 nd4096 nd4127 2.279517697008e+02
RINT14978 nd4097 nd4128 2.295640559441e+02
RINT14979 nd4098 nd4129 2.295640559441e+02
RINT14980 nd4099 nd4130 5.984208854167e+05
RINT14981 nd4100 nd4131 9.973681423611e+04
RINT14982 nd4101 nd4132 1.709773958333e+05
RINT14983 nd4102 nd4133 1.709773958333e+05
RINT14984 nd4103 nd4134 1.709773958333e+05
RINT14985 nd4104 nd4135 1.709773958333e+05
RINT14986 nd4105 nd4136 1.709773958333e+05
RINT14987 nd4106 nd4137 1.709773958333e+05
RINT14988 nd4107 nd4138 1.709773958333e+05
RINT14989 nd4108 nd4139 3.799497685185e+04
RINT14990 nd4109 nd4140 3.799497685185e+04
RINT14991 nd4110 nd4141 1.200279881138e+04
RINT14992 nd4111 nd4142 8.633080870696e+02
RINT14993 nd4112 nd4143 1.914946833333e+04
RINT14994 nd4113 nd4144 7.978945138889e+01
RINT14995 nd4114 nd4145 7.978945138889e+01
RINT14996 nd4115 nd4146 7.978945138889e+01
RINT14997 nd4116 nd4147 7.978945138889e+01
RINT14998 nd4117 nd4148 7.978945138889e+01
RINT14999 nd4118 nd4149 7.978945138889e+01
RINT15000 nd4119 nd4150 7.978945138889e+01
RINT15001 nd4120 nd4151 7.978945138889e+01
RINT15002 nd4121 nd4152 7.978945138889e+01
RINT15003 nd4122 nd4153 7.978945138889e+01
RINT15004 nd4123 nd4154 1.282616767136e+02
RINT15005 nd4124 nd4155 1.107545883941e+02
RINT15006 nd4125 nd4156 1.107545883941e+02
RINT15007 nd4126 nd4157 6.425829603070e+03
RINT15008 nd4127 nd4158 2.279517697008e+02
RINT15009 nd4128 nd4159 2.295640559441e+02
RINT15010 nd4129 nd4160 2.295640559441e+02
RINT15011 nd4130 nd4161 5.984208854167e+05
RINT15012 nd4131 nd4162 9.973681423611e+04
RINT15013 nd4132 nd4163 1.709773958333e+05
RINT15014 nd4133 nd4164 1.709773958333e+05
RINT15015 nd4134 nd4165 1.709773958333e+05
RINT15016 nd4135 nd4166 1.709773958333e+05
RINT15017 nd4136 nd4167 1.709773958333e+05
RINT15018 nd4137 nd4168 1.709773958333e+05
RINT15019 nd4138 nd4169 1.709773958333e+05
RINT15020 nd4139 nd4170 3.799497685185e+04
RINT15021 nd4140 nd4171 3.799497685185e+04
RINT15022 nd4141 nd4172 1.200279881138e+04
RINT15023 nd4142 nd4173 8.633080870696e+02
RINT15024 nd4143 nd4174 1.914946833333e+04
RINT15025 nd4144 nd4175 7.978945138889e+01
RINT15026 nd4145 nd4176 7.978945138889e+01
RINT15027 nd4146 nd4177 7.978945138889e+01
RINT15028 nd4147 nd4178 7.978945138889e+01
RINT15029 nd4148 nd4179 7.978945138889e+01
RINT15030 nd4149 nd4180 7.978945138889e+01
RINT15031 nd4150 nd4181 7.978945138889e+01
RINT15032 nd4151 nd4182 7.978945138889e+01
RINT15033 nd4152 nd4183 7.978945138889e+01
RINT15034 nd4153 nd4184 7.978945138889e+01
RINT15035 nd4154 nd4185 1.282616767136e+02
RINT15036 nd4155 nd4186 1.107545883941e+02
RINT15037 nd4156 nd4187 1.107545883941e+02
RINT15038 nd4157 nd4188 6.425829603070e+03
RINT15039 nd4158 nd4189 2.279517697008e+02
RINT15040 nd4159 nd4190 2.295640559441e+02
RINT15041 nd4160 nd4191 2.295640559441e+02
RINT15042 nd4161 nd4192 5.984208854167e+05
RINT15043 nd4162 nd4193 9.973681423611e+04
RINT15044 nd4163 nd4194 1.709773958333e+05
RINT15045 nd4164 nd4195 1.709773958333e+05
RINT15046 nd4165 nd4196 1.709773958333e+05
RINT15047 nd4166 nd4197 1.709773958333e+05
RINT15048 nd4167 nd4198 1.709773958333e+05
RINT15049 nd4168 nd4199 1.709773958333e+05
RINT15050 nd4169 nd4200 1.709773958333e+05
RINT15051 nd4170 nd4201 3.799497685185e+04
RINT15052 nd4171 nd4202 3.799497685185e+04
RINT15053 nd4172 nd4203 1.200279881138e+04
RINT15054 nd4173 nd4204 8.633080870696e+02
RINT15055 nd4174 nd4205 1.914946833333e+04
RINT15056 nd4175 nd4206 7.978945138889e+01
RINT15057 nd4176 nd4207 7.978945138889e+01
RINT15058 nd4177 nd4208 7.978945138889e+01
RINT15059 nd4178 nd4209 7.978945138889e+01
RINT15060 nd4179 nd4210 7.978945138889e+01
RINT15061 nd4180 nd4211 7.978945138889e+01
RINT15062 nd4181 nd4212 7.978945138889e+01
RINT15063 nd4182 nd4213 7.978945138889e+01
RINT15064 nd4183 nd4214 7.978945138889e+01
RINT15065 nd4184 nd4215 7.978945138889e+01
RINT15066 nd4185 nd4216 7.082876200045e+01
RINT15067 nd4186 nd4217 6.116098419125e+01
RINT15068 nd4187 nd4218 6.116098419125e+01
RINT15069 nd4188 nd4219 3.548476577518e+03
RINT15070 nd4189 nd4220 1.258797020078e+02
RINT15071 nd4190 nd4221 1.267700399600e+02
RINT15072 nd4191 nd4222 1.267700399600e+02
RINT15073 nd4192 nd4223 3.304604427083e+05
RINT15074 nd4193 nd4224 5.507674045139e+04
RINT15075 nd4194 nd4225 9.441726934524e+04
RINT15076 nd4195 nd4226 9.441726934524e+04
RINT15077 nd4196 nd4227 9.441726934524e+04
RINT15078 nd4197 nd4228 9.441726934524e+04
RINT15079 nd4198 nd4229 9.441726934524e+04
RINT15080 nd4199 nd4230 9.441726934524e+04
RINT15081 nd4200 nd4231 9.441726934524e+04
RINT15082 nd4201 nd4232 2.098161541005e+04
RINT15083 nd4202 nd4233 2.098161541005e+04
RINT15084 nd4203 nd4234 6.628194813396e+03
RINT15085 nd4204 nd4235 4.767366574247e+02
RINT15086 nd4205 nd4236 1.057473416667e+04
RINT15087 nd4206 nd4237 4.406139236111e+01
RINT15088 nd4207 nd4238 4.406139236111e+01
RINT15089 nd4208 nd4239 4.406139236111e+01
RINT15090 nd4209 nd4240 4.406139236111e+01
RINT15091 nd4210 nd4241 4.406139236111e+01
RINT15092 nd4211 nd4242 4.406139236111e+01
RINT15093 nd4212 nd4243 4.406139236111e+01
RINT15094 nd4213 nd4244 4.406139236111e+01
RINT15095 nd4214 nd4245 4.406139236111e+01
RINT15096 nd4215 nd4246 4.406139236111e+01
RINT15097 nd4216 nd4247 7.082876200045e+01
RINT15098 nd4217 nd4248 6.116098419125e+01
RINT15099 nd4218 nd4249 6.116098419125e+01
RINT15100 nd4219 nd4250 3.548476577518e+03
RINT15101 nd4220 nd4251 1.258797020078e+02
RINT15102 nd4221 nd4252 1.267700399600e+02
RINT15103 nd4222 nd4253 1.267700399600e+02
RINT15104 nd4223 nd4254 3.304604427083e+05
RINT15105 nd4224 nd4255 5.507674045139e+04
RINT15106 nd4225 nd4256 9.441726934524e+04
RINT15107 nd4226 nd4257 9.441726934524e+04
RINT15108 nd4227 nd4258 9.441726934524e+04
RINT15109 nd4228 nd4259 9.441726934524e+04
RINT15110 nd4229 nd4260 9.441726934524e+04
RINT15111 nd4230 nd4261 9.441726934524e+04
RINT15112 nd4231 nd4262 9.441726934524e+04
RINT15113 nd4232 nd4263 2.098161541005e+04
RINT15114 nd4233 nd4264 2.098161541005e+04
RINT15115 nd4234 nd4265 6.628194813396e+03
RINT15116 nd4235 nd4266 4.767366574247e+02
RINT15117 nd4236 nd4267 1.057473416667e+04
RINT15118 nd4237 nd4268 4.406139236111e+01
RINT15119 nd4238 nd4269 4.406139236111e+01
RINT15120 nd4239 nd4270 4.406139236111e+01
RINT15121 nd4240 nd4271 4.406139236111e+01
RINT15122 nd4241 nd4272 4.406139236111e+01
RINT15123 nd4242 nd4273 4.406139236111e+01
RINT15124 nd4243 nd4274 4.406139236111e+01
RINT15125 nd4244 nd4275 4.406139236111e+01
RINT15126 nd4245 nd4276 4.406139236111e+01
RINT15127 nd4246 nd4277 4.406139236111e+01
RINT15128 nd4247 nd4278 1.282616767136e+02
RINT15129 nd4248 nd4279 1.107545883941e+02
RINT15130 nd4249 nd4280 1.107545883941e+02
RINT15131 nd4250 nd4281 6.425829603070e+03
RINT15132 nd4251 nd4282 2.279517697008e+02
RINT15133 nd4252 nd4283 2.295640559441e+02
RINT15134 nd4253 nd4284 2.295640559441e+02
RINT15135 nd4254 nd4285 5.984208854167e+05
RINT15136 nd4255 nd4286 9.973681423611e+04
RINT15137 nd4256 nd4287 1.709773958333e+05
RINT15138 nd4257 nd4288 1.709773958333e+05
RINT15139 nd4258 nd4289 1.709773958333e+05
RINT15140 nd4259 nd4290 1.709773958333e+05
RINT15141 nd4260 nd4291 1.709773958333e+05
RINT15142 nd4261 nd4292 1.709773958333e+05
RINT15143 nd4262 nd4293 1.709773958333e+05
RINT15144 nd4263 nd4294 3.799497685185e+04
RINT15145 nd4264 nd4295 3.799497685185e+04
RINT15146 nd4265 nd4296 1.200279881138e+04
RINT15147 nd4266 nd4297 8.633080870696e+02
RINT15148 nd4267 nd4298 1.914946833333e+04
RINT15149 nd4268 nd4299 7.978945138889e+01
RINT15150 nd4269 nd4300 7.978945138889e+01
RINT15151 nd4270 nd4301 7.978945138889e+01
RINT15152 nd4271 nd4302 7.978945138889e+01
RINT15153 nd4272 nd4303 7.978945138889e+01
RINT15154 nd4273 nd4304 7.978945138889e+01
RINT15155 nd4274 nd4305 7.978945138889e+01
RINT15156 nd4275 nd4306 7.978945138889e+01
RINT15157 nd4276 nd4307 7.978945138889e+01
RINT15158 nd4277 nd4308 7.978945138889e+01
RINT15159 nd4278 nd4309 1.282616767136e+02
RINT15160 nd4279 nd4310 1.107545883941e+02
RINT15161 nd4280 nd4311 1.107545883941e+02
RINT15162 nd4281 nd4312 6.425829603070e+03
RINT15163 nd4282 nd4313 2.279517697008e+02
RINT15164 nd4283 nd4314 2.295640559441e+02
RINT15165 nd4284 nd4315 2.295640559441e+02
RINT15166 nd4285 nd4316 5.984208854167e+05
RINT15167 nd4286 nd4317 9.973681423611e+04
RINT15168 nd4287 nd4318 1.709773958333e+05
RINT15169 nd4288 nd4319 1.709773958333e+05
RINT15170 nd4289 nd4320 1.709773958333e+05
RINT15171 nd4290 nd4321 1.709773958333e+05
RINT15172 nd4291 nd4322 1.709773958333e+05
RINT15173 nd4292 nd4323 1.709773958333e+05
RINT15174 nd4293 nd4324 1.709773958333e+05
RINT15175 nd4294 nd4325 3.799497685185e+04
RINT15176 nd4295 nd4326 3.799497685185e+04
RINT15177 nd4296 nd4327 1.200279881138e+04
RINT15178 nd4297 nd4328 8.633080870696e+02
RINT15179 nd4298 nd4329 1.914946833333e+04
RINT15180 nd4299 nd4330 7.978945138889e+01
RINT15181 nd4300 nd4331 7.978945138889e+01
RINT15182 nd4301 nd4332 7.978945138889e+01
RINT15183 nd4302 nd4333 7.978945138889e+01
RINT15184 nd4303 nd4334 7.978945138889e+01
RINT15185 nd4304 nd4335 7.978945138889e+01
RINT15186 nd4305 nd4336 7.978945138889e+01
RINT15187 nd4306 nd4337 7.978945138889e+01
RINT15188 nd4307 nd4338 7.978945138889e+01
RINT15189 nd4308 nd4339 7.978945138889e+01
RINT15190 nd4309 nd4340 1.282616767136e+02
RINT15191 nd4310 nd4341 1.107545883941e+02
RINT15192 nd4311 nd4342 1.107545883941e+02
RINT15193 nd4312 nd4343 6.425829603070e+03
RINT15194 nd4313 nd4344 2.279517697008e+02
RINT15195 nd4314 nd4345 2.295640559441e+02
RINT15196 nd4315 nd4346 2.295640559441e+02
RINT15197 nd4316 nd4347 5.984208854167e+05
RINT15198 nd4317 nd4348 9.973681423611e+04
RINT15199 nd4318 nd4349 1.709773958333e+05
RINT15200 nd4319 nd4350 1.709773958333e+05
RINT15201 nd4320 nd4351 1.709773958333e+05
RINT15202 nd4321 nd4352 1.709773958333e+05
RINT15203 nd4322 nd4353 1.709773958333e+05
RINT15204 nd4323 nd4354 1.709773958333e+05
RINT15205 nd4324 nd4355 1.709773958333e+05
RINT15206 nd4325 nd4356 3.799497685185e+04
RINT15207 nd4326 nd4357 3.799497685185e+04
RINT15208 nd4327 nd4358 1.200279881138e+04
RINT15209 nd4328 nd4359 8.633080870696e+02
RINT15210 nd4329 nd4360 1.914946833333e+04
RINT15211 nd4330 nd4361 7.978945138889e+01
RINT15212 nd4331 nd4362 7.978945138889e+01
RINT15213 nd4332 nd4363 7.978945138889e+01
RINT15214 nd4333 nd4364 7.978945138889e+01
RINT15215 nd4334 nd4365 7.978945138889e+01
RINT15216 nd4335 nd4366 7.978945138889e+01
RINT15217 nd4336 nd4367 7.978945138889e+01
RINT15218 nd4337 nd4368 7.978945138889e+01
RINT15219 nd4338 nd4369 7.978945138889e+01
RINT15220 nd4339 nd4370 7.978945138889e+01
RINT15221 nd4340 nd4371 1.282616767136e+02
RINT15222 nd4341 nd4372 1.107545883941e+02
RINT15223 nd4342 nd4373 1.107545883941e+02
RINT15224 nd4343 nd4374 6.425829603070e+03
RINT15225 nd4344 nd4375 2.279517697008e+02
RINT15226 nd4345 nd4376 2.295640559441e+02
RINT15227 nd4346 nd4377 2.295640559441e+02
RINT15228 nd4347 nd4378 5.984208854167e+05
RINT15229 nd4348 nd4379 9.973681423611e+04
RINT15230 nd4349 nd4380 1.709773958333e+05
RINT15231 nd4350 nd4381 1.709773958333e+05
RINT15232 nd4351 nd4382 1.709773958333e+05
RINT15233 nd4352 nd4383 1.709773958333e+05
RINT15234 nd4353 nd4384 1.709773958333e+05
RINT15235 nd4354 nd4385 1.709773958333e+05
RINT15236 nd4355 nd4386 1.709773958333e+05
RINT15237 nd4356 nd4387 3.799497685185e+04
RINT15238 nd4357 nd4388 3.799497685185e+04
RINT15239 nd4358 nd4389 1.200279881138e+04
RINT15240 nd4359 nd4390 8.633080870696e+02
RINT15241 nd4360 nd4391 1.914946833333e+04
RINT15242 nd4361 nd4392 7.978945138889e+01
RINT15243 nd4362 nd4393 7.978945138889e+01
RINT15244 nd4363 nd4394 7.978945138889e+01
RINT15245 nd4364 nd4395 7.978945138889e+01
RINT15246 nd4365 nd4396 7.978945138889e+01
RINT15247 nd4366 nd4397 7.978945138889e+01
RINT15248 nd4367 nd4398 7.978945138889e+01
RINT15249 nd4368 nd4399 7.978945138889e+01
RINT15250 nd4369 nd4400 7.978945138889e+01
RINT15251 nd4370 nd4401 7.978945138889e+01
RINT15252 nd4371 nd4402 1.282616767136e+02
RINT15253 nd4372 nd4403 1.107545883941e+02
RINT15254 nd4373 nd4404 1.107545883941e+02
RINT15255 nd4374 nd4405 6.425829603070e+03
RINT15256 nd4375 nd4406 2.279517697008e+02
RINT15257 nd4376 nd4407 2.295640559441e+02
RINT15258 nd4377 nd4408 2.295640559441e+02
RINT15259 nd4378 nd4409 5.984208854167e+05
RINT15260 nd4379 nd4410 9.973681423611e+04
RINT15261 nd4380 nd4411 1.709773958333e+05
RINT15262 nd4381 nd4412 1.709773958333e+05
RINT15263 nd4382 nd4413 1.709773958333e+05
RINT15264 nd4383 nd4414 1.709773958333e+05
RINT15265 nd4384 nd4415 1.709773958333e+05
RINT15266 nd4385 nd4416 1.709773958333e+05
RINT15267 nd4386 nd4417 1.709773958333e+05
RINT15268 nd4387 nd4418 3.799497685185e+04
RINT15269 nd4388 nd4419 3.799497685185e+04
RINT15270 nd4389 nd4420 1.200279881138e+04
RINT15271 nd4390 nd4421 8.633080870696e+02
RINT15272 nd4391 nd4422 1.914946833333e+04
RINT15273 nd4392 nd4423 7.978945138889e+01
RINT15274 nd4393 nd4424 7.978945138889e+01
RINT15275 nd4394 nd4425 7.978945138889e+01
RINT15276 nd4395 nd4426 7.978945138889e+01
RINT15277 nd4396 nd4427 7.978945138889e+01
RINT15278 nd4397 nd4428 7.978945138889e+01
RINT15279 nd4398 nd4429 7.978945138889e+01
RINT15280 nd4399 nd4430 7.978945138889e+01
RINT15281 nd4400 nd4431 7.978945138889e+01
RINT15282 nd4401 nd4432 7.978945138889e+01
RINT15283 nd4402 nd4433 7.082876200045e+01
RINT15284 nd4403 nd4434 6.116098419125e+01
RINT15285 nd4404 nd4435 6.116098419125e+01
RINT15286 nd4405 nd4436 3.548476577518e+03
RINT15287 nd4406 nd4437 1.258797020078e+02
RINT15288 nd4407 nd4438 1.267700399600e+02
RINT15289 nd4408 nd4439 1.267700399600e+02
RINT15290 nd4409 nd4440 3.304604427083e+05
RINT15291 nd4410 nd4441 5.507674045139e+04
RINT15292 nd4411 nd4442 9.441726934524e+04
RINT15293 nd4412 nd4443 9.441726934524e+04
RINT15294 nd4413 nd4444 9.441726934524e+04
RINT15295 nd4414 nd4445 9.441726934524e+04
RINT15296 nd4415 nd4446 9.441726934524e+04
RINT15297 nd4416 nd4447 9.441726934524e+04
RINT15298 nd4417 nd4448 9.441726934524e+04
RINT15299 nd4418 nd4449 2.098161541005e+04
RINT15300 nd4419 nd4450 2.098161541005e+04
RINT15301 nd4420 nd4451 6.628194813396e+03
RINT15302 nd4421 nd4452 4.767366574247e+02
RINT15303 nd4422 nd4453 1.057473416667e+04
RINT15304 nd4423 nd4454 4.406139236111e+01
RINT15305 nd4424 nd4455 4.406139236111e+01
RINT15306 nd4425 nd4456 4.406139236111e+01
RINT15307 nd4426 nd4457 4.406139236111e+01
RINT15308 nd4427 nd4458 4.406139236111e+01
RINT15309 nd4428 nd4459 4.406139236111e+01
RINT15310 nd4429 nd4460 4.406139236111e+01
RINT15311 nd4430 nd4461 4.406139236111e+01
RINT15312 nd4431 nd4462 4.406139236111e+01
RINT15313 nd4432 nd4463 4.406139236111e+01
RINT15314 nd4433 nd4464 5.593547666890e+01
RINT15315 nd4434 nd4465 4.830055909003e+01
RINT15316 nd4435 nd4466 4.830055909003e+01
RINT15317 nd4436 nd4467 2.802332318199e+03
RINT15318 nd4437 nd4468 9.941076105071e+01
RINT15319 nd4438 nd4469 1.001138861139e+02
RINT15320 nd4439 nd4470 1.001138861139e+02
RINT15321 nd4440 nd4471 3.475055555556e+04
RINT15322 nd4441 nd4472 5.791759259259e+03
RINT15323 nd4442 nd4473 9.928730158730e+03
RINT15324 nd4443 nd4474 9.928730158730e+03
RINT15325 nd4444 nd4475 9.928730158730e+03
RINT15326 nd4445 nd4476 9.928730158730e+03
RINT15327 nd4446 nd4477 9.928730158730e+03
RINT15328 nd4447 nd4478 9.928730158730e+03
RINT15329 nd4448 nd4479 9.928730158730e+03
RINT15330 nd4449 nd4480 2.206384479718e+03
RINT15331 nd4450 nd4481 2.206384479718e+03
RINT15332 nd4451 nd4482 5.234472915668e+03
RINT15333 nd4452 nd4483 3.764924223640e+02
RINT15334 nd4453 nd4484 8.351166666667e+03
RINT15335 nd4454 nd4485 3.479652777778e+01
RINT15336 nd4455 nd4486 3.479652777778e+01
RINT15337 nd4456 nd4487 3.479652777778e+01
RINT15338 nd4457 nd4488 3.479652777778e+01
RINT15339 nd4458 nd4489 3.479652777778e+01
RINT15340 nd4459 nd4490 3.479652777778e+01
RINT15341 nd4460 nd4491 3.479652777778e+01
RINT15342 nd4461 nd4492 3.479652777778e+01
RINT15343 nd4462 nd4493 3.479652777778e+01
RINT15344 nd4463 nd4494 3.479652777778e+01
RINT15345 nd4464 nd4495 9.847510605046e+01
RINT15346 nd4465 nd4496 8.503373819163e+01
RINT15347 nd4466 nd4497 8.503373819163e+01
RINT15348 nd4467 nd4498 4.933541084432e+03
RINT15349 nd4468 nd4499 1.750138877867e+02
RINT15350 nd4469 nd4500 1.762517482517e+02
RINT15351 nd4470 nd4501 1.762517482517e+02
RINT15352 nd4471 nd4502 7.001111111111e+03
RINT15353 nd4472 nd4503 1.166851851852e+03
RINT15354 nd4473 nd4504 2.000317460317e+03
RINT15355 nd4474 nd4505 2.000317460317e+03
RINT15356 nd4475 nd4506 2.000317460317e+03
RINT15357 nd4476 nd4507 2.000317460317e+03
RINT15358 nd4477 nd4508 2.000317460317e+03
RINT15359 nd4478 nd4509 2.000317460317e+03
RINT15360 nd4479 nd4510 2.000317460317e+03
RINT15361 nd4480 nd4511 4.445149911817e+02
RINT15362 nd4481 nd4512 4.445149911817e+02
RINT15363 nd4482 nd4513 9.215355015920e+03
RINT15364 nd4483 nd4514 6.628196169481e+02
RINT15365 nd4484 nd4515 1.470233333333e+04
RINT15366 nd4485 nd4516 6.125972222222e+01
RINT15367 nd4486 nd4517 6.125972222222e+01
RINT15368 nd4487 nd4518 6.125972222222e+01
RINT15369 nd4488 nd4519 6.125972222222e+01
RINT15370 nd4489 nd4520 6.125972222222e+01
RINT15371 nd4490 nd4521 6.125972222222e+01
RINT15372 nd4491 nd4522 6.125972222222e+01
RINT15373 nd4492 nd4523 6.125972222222e+01
RINT15374 nd4493 nd4524 6.125972222222e+01
RINT15375 nd4494 nd4525 6.125972222222e+01
RINT15376 nd4495 nd4526 9.847510605046e+01
RINT15377 nd4496 nd4527 8.503373819163e+01
RINT15378 nd4497 nd4528 8.503373819163e+01
RINT15379 nd4498 nd4529 4.933541084432e+03
RINT15380 nd4499 nd4530 1.750138877867e+02
RINT15381 nd4500 nd4531 1.762517482517e+02
RINT15382 nd4501 nd4532 1.762517482517e+02
RINT15383 nd4502 nd4533 7.001111111111e+03
RINT15384 nd4503 nd4534 1.166851851852e+03
RINT15385 nd4504 nd4535 2.000317460317e+03
RINT15386 nd4505 nd4536 2.000317460317e+03
RINT15387 nd4506 nd4537 2.000317460317e+03
RINT15388 nd4507 nd4538 2.000317460317e+03
RINT15389 nd4508 nd4539 2.000317460317e+03
RINT15390 nd4509 nd4540 2.000317460317e+03
RINT15391 nd4510 nd4541 2.000317460317e+03
RINT15392 nd4511 nd4542 4.445149911817e+02
RINT15393 nd4512 nd4543 4.445149911817e+02
RINT15394 nd4513 nd4544 9.215355015920e+03
RINT15395 nd4514 nd4545 6.628196169481e+02
RINT15396 nd4515 nd4546 1.470233333333e+04
RINT15397 nd4516 nd4547 6.125972222222e+01
RINT15398 nd4517 nd4548 6.125972222222e+01
RINT15399 nd4518 nd4549 6.125972222222e+01
RINT15400 nd4519 nd4550 6.125972222222e+01
RINT15401 nd4520 nd4551 6.125972222222e+01
RINT15402 nd4521 nd4552 6.125972222222e+01
RINT15403 nd4522 nd4553 6.125972222222e+01
RINT15404 nd4523 nd4554 6.125972222222e+01
RINT15405 nd4524 nd4555 6.125972222222e+01
RINT15406 nd4525 nd4556 6.125972222222e+01
RINT15407 nd4557 nd4588 1.042035668855e+01
RINT15408 nd4558 nd4589 8.998029228461e+00
RINT15409 nd4559 nd4590 8.998029228461e+00
RINT15410 nd4560 nd4591 5.220533381408e+02
RINT15411 nd4561 nd4592 1.851947369575e+01
RINT15412 nd4562 nd4593 1.865046058263e+01
RINT15413 nd4563 nd4594 1.865046058263e+01
RINT15414 nd4564 nd4595 7.408377398100e+02
RINT15415 nd4565 nd4596 1.234729566350e+02
RINT15416 nd4566 nd4597 2.116679256600e+02
RINT15417 nd4567 nd4598 2.116679256600e+02
RINT15418 nd4568 nd4599 2.116679256600e+02
RINT15419 nd4569 nd4600 2.116679256600e+02
RINT15420 nd4570 nd4601 2.116679256600e+02
RINT15421 nd4571 nd4602 2.116679256600e+02
RINT15422 nd4572 nd4603 2.116679256600e+02
RINT15423 nd4573 nd4604 4.703731681333e+01
RINT15424 nd4574 nd4605 4.703731681333e+01
RINT15425 nd4575 nd4606 9.751427556557e+02
RINT15426 nd4576 nd4607 7.013769373582e+01
RINT15427 nd4577 nd4608 1.555759253601e+03
RINT15428 nd4578 nd4609 6.482330223337e+00
RINT15429 nd4579 nd4610 6.482330223337e+00
RINT15430 nd4580 nd4611 6.482330223337e+00
RINT15431 nd4581 nd4612 6.482330223337e+00
RINT15432 nd4582 nd4613 6.482330223337e+00
RINT15433 nd4583 nd4614 6.482330223337e+00
RINT15434 nd4584 nd4615 6.482330223337e+00
RINT15435 nd4585 nd4616 6.482330223337e+00
RINT15436 nd4586 nd4617 6.482330223337e+00
RINT15437 nd4587 nd4618 6.482330223337e+00
RINT15438 nd4588 nd4619 1.042035668855e+01
RINT15439 nd4589 nd4620 8.998029228461e+00
RINT15440 nd4590 nd4621 8.998029228461e+00
RINT15441 nd4591 nd4622 5.220533381408e+02
RINT15442 nd4592 nd4623 1.851947369575e+01
RINT15443 nd4593 nd4624 1.865046058263e+01
RINT15444 nd4594 nd4625 1.865046058263e+01
RINT15445 nd4595 nd4626 7.408377398100e+02
RINT15446 nd4596 nd4627 1.234729566350e+02
RINT15447 nd4597 nd4628 2.116679256600e+02
RINT15448 nd4598 nd4629 2.116679256600e+02
RINT15449 nd4599 nd4630 2.116679256600e+02
RINT15450 nd4600 nd4631 2.116679256600e+02
RINT15451 nd4601 nd4632 2.116679256600e+02
RINT15452 nd4602 nd4633 2.116679256600e+02
RINT15453 nd4603 nd4634 2.116679256600e+02
RINT15454 nd4604 nd4635 4.703731681333e+01
RINT15455 nd4605 nd4636 4.703731681333e+01
RINT15456 nd4606 nd4637 9.751427556557e+02
RINT15457 nd4607 nd4638 7.013769373582e+01
RINT15458 nd4608 nd4639 1.555759253601e+03
RINT15459 nd4609 nd4640 6.482330223337e+00
RINT15460 nd4610 nd4641 6.482330223337e+00
RINT15461 nd4611 nd4642 6.482330223337e+00
RINT15462 nd4612 nd4643 6.482330223337e+00
RINT15463 nd4613 nd4644 6.482330223337e+00
RINT15464 nd4614 nd4645 6.482330223337e+00
RINT15465 nd4615 nd4646 6.482330223337e+00
RINT15466 nd4616 nd4647 6.482330223337e+00
RINT15467 nd4617 nd4648 6.482330223337e+00
RINT15468 nd4618 nd4649 6.482330223337e+00
RINT15469 nd4619 nd4650 5.918933645378e+00
RINT15470 nd4620 nd4651 5.111028301069e+00
RINT15471 nd4621 nd4652 5.111028301069e+00
RINT15472 nd4622 nd4653 2.965348653754e+02
RINT15473 nd4623 nd4654 1.051936504946e+01
RINT15474 nd4624 nd4655 1.059376775131e+01
RINT15475 nd4625 nd4656 1.059376775131e+01
RINT15476 nd4626 nd4657 3.677205321604e+03
RINT15477 nd4627 nd4658 6.128675536007e+02
RINT15478 nd4628 nd4659 1.050630091887e+03
RINT15479 nd4629 nd4660 1.050630091887e+03
RINT15480 nd4630 nd4661 1.050630091887e+03
RINT15481 nd4631 nd4662 1.050630091887e+03
RINT15482 nd4632 nd4663 1.050630091887e+03
RINT15483 nd4633 nd4664 1.050630091887e+03
RINT15484 nd4634 nd4665 1.050630091887e+03
RINT15485 nd4635 nd4666 2.334733537526e+02
RINT15486 nd4636 nd4667 2.334733537526e+02
RINT15487 nd4637 nd4668 5.538970918181e+02
RINT15488 nd4638 nd4669 3.983936132610e+01
RINT15489 nd4639 nd4670 8.836967932549e+02
RINT15490 nd4640 nd4671 3.682069971895e+00
RINT15491 nd4641 nd4672 3.682069971895e+00
RINT15492 nd4642 nd4673 3.682069971895e+00
RINT15493 nd4643 nd4674 3.682069971895e+00
RINT15494 nd4644 nd4675 3.682069971895e+00
RINT15495 nd4645 nd4676 3.682069971895e+00
RINT15496 nd4646 nd4677 3.682069971895e+00
RINT15497 nd4647 nd4678 3.682069971895e+00
RINT15498 nd4648 nd4679 3.682069971895e+00
RINT15499 nd4649 nd4680 3.682069971895e+00
RINT15500 nd4650 nd4681 7.494898898358e+00
RINT15501 nd4651 nd4682 6.471882044678e+00
RINT15502 nd4652 nd4683 6.471882044678e+00
RINT15503 nd4653 nd4684 3.754897366627e+02
RINT15504 nd4654 nd4685 1.332023338058e+01
RINT15505 nd4655 nd4686 1.341444641988e+01
RINT15506 nd4656 nd4687 1.341444641988e+01
RINT15507 nd4657 nd4688 3.942767563891e+03
RINT15508 nd4658 nd4689 6.216370766103e+02
RINT15509 nd4659 nd4690 1.083955004199e+03
RINT15510 nd4660 nd4691 1.083955004199e+03
RINT15511 nd4661 nd4692 1.083955004199e+03
RINT15512 nd4662 nd4693 1.083955004199e+03
RINT15513 nd4663 nd4694 1.083955004199e+03
RINT15514 nd4664 nd4695 1.083955004199e+03
RINT15515 nd4665 nd4696 1.083955004199e+03
RINT15516 nd4666 nd4697 2.368141244230e+02
RINT15517 nd4667 nd4698 2.376222816265e+02
RINT15518 nd4668 nd4699 7.013767938611e+02
RINT15519 nd4669 nd4700 5.044692223361e+01
RINT15520 nd4670 nd4701 1.118988405525e+03
RINT15521 nd4671 nd4702 4.662451689687e+00
RINT15522 nd4672 nd4703 4.662451689687e+00
RINT15523 nd4673 nd4704 4.662451689687e+00
RINT15524 nd4674 nd4705 4.662451689687e+00
RINT15525 nd4675 nd4706 4.662451689687e+00
RINT15526 nd4676 nd4707 4.662451689687e+00
RINT15527 nd4677 nd4708 4.662451689687e+00
RINT15528 nd4678 nd4709 4.662451689687e+00
RINT15529 nd4679 nd4710 4.662451689687e+00
RINT15530 nd4680 nd4711 4.662451689687e+00
RINT15531 nd4681 nd4712 1.357228719451e+01
RINT15532 nd4682 nd4713 1.171973671568e+01
RINT15533 nd4683 nd4714 1.171973671568e+01
RINT15534 nd4684 nd4715 6.799630807155e+02
RINT15535 nd4685 nd4716 2.412121035800e+01
RINT15536 nd4686 nd4717 2.429181791977e+01
RINT15537 nd4687 nd4718 2.429181791977e+01
RINT15538 nd4688 nd4719 1.271962224384e+03
RINT15539 nd4689 nd4720 1.410120026542e+02
RINT15540 nd4690 nd4721 2.783177502845e+02
RINT15541 nd4691 nd4722 2.783177502845e+02
RINT15542 nd4692 nd4723 2.783177502845e+02
RINT15543 nd4693 nd4724 2.783177502845e+02
RINT15544 nd4694 nd4725 2.783177502845e+02
RINT15545 nd4695 nd4726 2.783177502845e+02
RINT15546 nd4696 nd4727 2.783177502845e+02
RINT15547 nd4697 nd4728 5.371885815399e+01
RINT15548 nd4698 nd4729 5.533517256115e+01
RINT15549 nd4699 nd4730 1.270102159742e+03
RINT15550 nd4700 nd4731 9.135281555084e+01
RINT15551 nd4701 nd4732 2.026342478141e+03
RINT15552 nd4702 nd4733 8.443093658921e+00
RINT15553 nd4703 nd4734 8.443093658921e+00
RINT15554 nd4704 nd4735 8.443093658921e+00
RINT15555 nd4705 nd4736 8.443093658921e+00
RINT15556 nd4706 nd4737 8.443093658921e+00
RINT15557 nd4707 nd4738 8.443093658921e+00
RINT15558 nd4708 nd4739 8.443093658921e+00
RINT15559 nd4709 nd4740 8.443093658921e+00
RINT15560 nd4710 nd4741 8.443093658921e+00
RINT15561 nd4711 nd4742 8.443093658921e+00
RINT15562 nd4712 nd4743 1.357228719451e+01
RINT15563 nd4713 nd4744 1.171973671568e+01
RINT15564 nd4714 nd4745 1.171973671568e+01
RINT15565 nd4715 nd4746 6.799630807155e+02
RINT15566 nd4716 nd4747 2.412121035800e+01
RINT15567 nd4717 nd4748 2.429181791977e+01
RINT15568 nd4718 nd4749 2.429181791977e+01
RINT15569 nd4719 nd4750 1.271962224384e+03
RINT15570 nd4720 nd4751 1.410120026542e+02
RINT15571 nd4721 nd4752 2.783177502845e+02
RINT15572 nd4722 nd4753 2.783177502845e+02
RINT15573 nd4723 nd4754 2.783177502845e+02
RINT15574 nd4724 nd4755 2.783177502845e+02
RINT15575 nd4725 nd4756 2.783177502845e+02
RINT15576 nd4726 nd4757 2.783177502845e+02
RINT15577 nd4727 nd4758 2.783177502845e+02
RINT15578 nd4728 nd4759 5.371885815399e+01
RINT15579 nd4729 nd4760 5.533517256115e+01
RINT15580 nd4730 nd4761 1.270102159742e+03
RINT15581 nd4731 nd4762 9.135281555084e+01
RINT15582 nd4732 nd4763 2.026342478141e+03
RINT15583 nd4733 nd4764 8.443093658921e+00
RINT15584 nd4734 nd4765 8.443093658921e+00
RINT15585 nd4735 nd4766 8.443093658921e+00
RINT15586 nd4736 nd4767 8.443093658921e+00
RINT15587 nd4737 nd4768 8.443093658921e+00
RINT15588 nd4738 nd4769 8.443093658921e+00
RINT15589 nd4739 nd4770 8.443093658921e+00
RINT15590 nd4740 nd4771 8.443093658921e+00
RINT15591 nd4741 nd4772 8.443093658921e+00
RINT15592 nd4742 nd4773 8.443093658921e+00
RINT15593 nd4743 nd4774 1.357228719451e+01
RINT15594 nd4744 nd4775 1.171973671568e+01
RINT15595 nd4745 nd4776 1.171973671568e+01
RINT15596 nd4746 nd4777 6.799630807155e+02
RINT15597 nd4747 nd4778 2.412121035800e+01
RINT15598 nd4748 nd4779 2.429181791977e+01
RINT15599 nd4749 nd4780 2.429181791977e+01
RINT15600 nd4750 nd4781 1.271962224384e+03
RINT15601 nd4751 nd4782 1.410120026542e+02
RINT15602 nd4752 nd4783 2.783177502845e+02
RINT15603 nd4753 nd4784 2.783177502845e+02
RINT15604 nd4754 nd4785 2.783177502845e+02
RINT15605 nd4755 nd4786 2.783177502845e+02
RINT15606 nd4756 nd4787 2.783177502845e+02
RINT15607 nd4757 nd4788 2.783177502845e+02
RINT15608 nd4758 nd4789 2.783177502845e+02
RINT15609 nd4759 nd4790 5.371885815399e+01
RINT15610 nd4760 nd4791 5.533517256115e+01
RINT15611 nd4761 nd4792 1.270102159742e+03
RINT15612 nd4762 nd4793 9.135281555084e+01
RINT15613 nd4763 nd4794 2.026342478141e+03
RINT15614 nd4764 nd4795 8.443093658921e+00
RINT15615 nd4765 nd4796 8.443093658921e+00
RINT15616 nd4766 nd4797 8.443093658921e+00
RINT15617 nd4767 nd4798 8.443093658921e+00
RINT15618 nd4768 nd4799 8.443093658921e+00
RINT15619 nd4769 nd4800 8.443093658921e+00
RINT15620 nd4770 nd4801 8.443093658921e+00
RINT15621 nd4771 nd4802 8.443093658921e+00
RINT15622 nd4772 nd4803 8.443093658921e+00
RINT15623 nd4773 nd4804 8.443093658921e+00
RINT15624 nd4774 nd4805 1.357228719451e+01
RINT15625 nd4775 nd4806 1.171973671568e+01
RINT15626 nd4776 nd4807 1.171973671568e+01
RINT15627 nd4777 nd4808 6.799630807155e+02
RINT15628 nd4778 nd4809 2.412121035800e+01
RINT15629 nd4779 nd4810 2.429181791977e+01
RINT15630 nd4780 nd4811 2.429181791977e+01
RINT15631 nd4781 nd4812 1.271962224384e+03
RINT15632 nd4782 nd4813 1.410120026542e+02
RINT15633 nd4783 nd4814 2.783177502845e+02
RINT15634 nd4784 nd4815 2.783177502845e+02
RINT15635 nd4785 nd4816 2.783177502845e+02
RINT15636 nd4786 nd4817 2.783177502845e+02
RINT15637 nd4787 nd4818 2.783177502845e+02
RINT15638 nd4788 nd4819 2.783177502845e+02
RINT15639 nd4789 nd4820 2.783177502845e+02
RINT15640 nd4790 nd4821 5.371885815399e+01
RINT15641 nd4791 nd4822 5.533517256115e+01
RINT15642 nd4792 nd4823 1.270102159742e+03
RINT15643 nd4793 nd4824 9.135281555084e+01
RINT15644 nd4794 nd4825 2.026342478141e+03
RINT15645 nd4795 nd4826 8.443093658921e+00
RINT15646 nd4796 nd4827 8.443093658921e+00
RINT15647 nd4797 nd4828 8.443093658921e+00
RINT15648 nd4798 nd4829 8.443093658921e+00
RINT15649 nd4799 nd4830 8.443093658921e+00
RINT15650 nd4800 nd4831 8.443093658921e+00
RINT15651 nd4801 nd4832 8.443093658921e+00
RINT15652 nd4802 nd4833 8.443093658921e+00
RINT15653 nd4803 nd4834 8.443093658921e+00
RINT15654 nd4804 nd4835 8.443093658921e+00
RINT15655 nd4805 nd4836 1.357228719451e+01
RINT15656 nd4806 nd4837 1.171973671568e+01
RINT15657 nd4807 nd4838 1.171973671568e+01
RINT15658 nd4808 nd4839 6.799630807155e+02
RINT15659 nd4809 nd4840 2.412121035800e+01
RINT15660 nd4810 nd4841 2.429181791977e+01
RINT15661 nd4811 nd4842 2.429181791977e+01
RINT15662 nd4812 nd4843 1.271962224384e+03
RINT15663 nd4813 nd4844 1.410120026542e+02
RINT15664 nd4814 nd4845 2.783177502845e+02
RINT15665 nd4815 nd4846 2.783177502845e+02
RINT15666 nd4816 nd4847 2.783177502845e+02
RINT15667 nd4817 nd4848 2.783177502845e+02
RINT15668 nd4818 nd4849 2.783177502845e+02
RINT15669 nd4819 nd4850 2.783177502845e+02
RINT15670 nd4820 nd4851 2.783177502845e+02
RINT15671 nd4821 nd4852 5.371885815399e+01
RINT15672 nd4822 nd4853 5.533517256115e+01
RINT15673 nd4823 nd4854 1.270102159742e+03
RINT15674 nd4824 nd4855 9.135281555084e+01
RINT15675 nd4825 nd4856 2.026342478141e+03
RINT15676 nd4826 nd4857 8.443093658921e+00
RINT15677 nd4827 nd4858 8.443093658921e+00
RINT15678 nd4828 nd4859 8.443093658921e+00
RINT15679 nd4829 nd4860 8.443093658921e+00
RINT15680 nd4830 nd4861 8.443093658921e+00
RINT15681 nd4831 nd4862 8.443093658921e+00
RINT15682 nd4832 nd4863 8.443093658921e+00
RINT15683 nd4833 nd4864 8.443093658921e+00
RINT15684 nd4834 nd4865 8.443093658921e+00
RINT15685 nd4835 nd4866 8.443093658921e+00
RINT15686 nd4836 nd4867 7.494898898358e+00
RINT15687 nd4837 nd4868 6.471882044678e+00
RINT15688 nd4838 nd4869 6.471882044678e+00
RINT15689 nd4839 nd4870 3.754897366627e+02
RINT15690 nd4840 nd4871 1.332023338058e+01
RINT15691 nd4841 nd4872 1.341444641988e+01
RINT15692 nd4842 nd4873 1.341444641988e+01
RINT15693 nd4843 nd4874 3.942767563891e+03
RINT15694 nd4844 nd4875 6.216370766103e+02
RINT15695 nd4845 nd4876 1.083955004199e+03
RINT15696 nd4846 nd4877 1.083955004199e+03
RINT15697 nd4847 nd4878 1.083955004199e+03
RINT15698 nd4848 nd4879 1.083955004199e+03
RINT15699 nd4849 nd4880 1.083955004199e+03
RINT15700 nd4850 nd4881 1.083955004199e+03
RINT15701 nd4851 nd4882 1.083955004199e+03
RINT15702 nd4852 nd4883 2.368141244230e+02
RINT15703 nd4853 nd4884 2.376222816266e+02
RINT15704 nd4854 nd4885 7.013767938611e+02
RINT15705 nd4855 nd4886 5.044692223361e+01
RINT15706 nd4856 nd4887 1.118988405525e+03
RINT15707 nd4857 nd4888 4.662451689687e+00
RINT15708 nd4858 nd4889 4.662451689687e+00
RINT15709 nd4859 nd4890 4.662451689687e+00
RINT15710 nd4860 nd4891 4.662451689687e+00
RINT15711 nd4861 nd4892 4.662451689687e+00
RINT15712 nd4862 nd4893 4.662451689687e+00
RINT15713 nd4863 nd4894 4.662451689687e+00
RINT15714 nd4864 nd4895 4.662451689687e+00
RINT15715 nd4865 nd4896 4.662451689687e+00
RINT15716 nd4866 nd4897 4.662451689687e+00
RINT15717 nd4867 nd4898 7.494898898358e+00
RINT15718 nd4868 nd4899 6.471882044678e+00
RINT15719 nd4869 nd4900 6.471882044678e+00
RINT15720 nd4870 nd4901 3.754897366627e+02
RINT15721 nd4871 nd4902 1.332023338058e+01
RINT15722 nd4872 nd4903 1.341444641988e+01
RINT15723 nd4873 nd4904 1.341444641988e+01
RINT15724 nd4874 nd4905 3.942767563891e+03
RINT15725 nd4875 nd4906 6.216370766103e+02
RINT15726 nd4876 nd4907 1.083955004199e+03
RINT15727 nd4877 nd4908 1.083955004199e+03
RINT15728 nd4878 nd4909 1.083955004199e+03
RINT15729 nd4879 nd4910 1.083955004199e+03
RINT15730 nd4880 nd4911 1.083955004199e+03
RINT15731 nd4881 nd4912 1.083955004199e+03
RINT15732 nd4882 nd4913 1.083955004199e+03
RINT15733 nd4883 nd4914 2.368141244230e+02
RINT15734 nd4884 nd4915 2.376222816266e+02
RINT15735 nd4885 nd4916 7.013767938611e+02
RINT15736 nd4886 nd4917 5.044692223361e+01
RINT15737 nd4887 nd4918 1.118988405525e+03
RINT15738 nd4888 nd4919 4.662451689687e+00
RINT15739 nd4889 nd4920 4.662451689687e+00
RINT15740 nd4890 nd4921 4.662451689687e+00
RINT15741 nd4891 nd4922 4.662451689687e+00
RINT15742 nd4892 nd4923 4.662451689687e+00
RINT15743 nd4893 nd4924 4.662451689687e+00
RINT15744 nd4894 nd4925 4.662451689687e+00
RINT15745 nd4895 nd4926 4.662451689687e+00
RINT15746 nd4896 nd4927 4.662451689687e+00
RINT15747 nd4897 nd4928 4.662451689687e+00
RINT15748 nd4898 nd4929 1.357228719451e+01
RINT15749 nd4899 nd4930 1.171973671568e+01
RINT15750 nd4900 nd4931 1.171973671568e+01
RINT15751 nd4901 nd4932 6.799630807155e+02
RINT15752 nd4902 nd4933 2.412121035800e+01
RINT15753 nd4903 nd4934 2.429181791977e+01
RINT15754 nd4904 nd4935 2.429181791977e+01
RINT15755 nd4905 nd4936 1.271962224384e+03
RINT15756 nd4906 nd4937 1.410120026542e+02
RINT15757 nd4907 nd4938 2.783177502845e+02
RINT15758 nd4908 nd4939 2.783177502845e+02
RINT15759 nd4909 nd4940 2.783177502845e+02
RINT15760 nd4910 nd4941 2.783177502845e+02
RINT15761 nd4911 nd4942 2.783177502845e+02
RINT15762 nd4912 nd4943 2.783177502845e+02
RINT15763 nd4913 nd4944 2.783177502845e+02
RINT15764 nd4914 nd4945 5.371885815399e+01
RINT15765 nd4915 nd4946 5.533517256115e+01
RINT15766 nd4916 nd4947 1.270102159742e+03
RINT15767 nd4917 nd4948 9.135281555084e+01
RINT15768 nd4918 nd4949 2.026342478141e+03
RINT15769 nd4919 nd4950 8.443093658921e+00
RINT15770 nd4920 nd4951 8.443093658921e+00
RINT15771 nd4921 nd4952 8.443093658921e+00
RINT15772 nd4922 nd4953 8.443093658921e+00
RINT15773 nd4923 nd4954 8.443093658921e+00
RINT15774 nd4924 nd4955 8.443093658921e+00
RINT15775 nd4925 nd4956 8.443093658921e+00
RINT15776 nd4926 nd4957 8.443093658921e+00
RINT15777 nd4927 nd4958 8.443093658921e+00
RINT15778 nd4928 nd4959 8.443093658921e+00
RINT15779 nd4929 nd4960 1.357228719451e+01
RINT15780 nd4930 nd4961 1.171973671568e+01
RINT15781 nd4931 nd4962 1.171973671568e+01
RINT15782 nd4932 nd4963 6.799630807155e+02
RINT15783 nd4933 nd4964 2.412121035800e+01
RINT15784 nd4934 nd4965 2.429181791977e+01
RINT15785 nd4935 nd4966 2.429181791977e+01
RINT15786 nd4936 nd4967 1.271962224384e+03
RINT15787 nd4937 nd4968 1.410120026542e+02
RINT15788 nd4938 nd4969 2.783177502845e+02
RINT15789 nd4939 nd4970 2.783177502845e+02
RINT15790 nd4940 nd4971 2.783177502845e+02
RINT15791 nd4941 nd4972 2.783177502845e+02
RINT15792 nd4942 nd4973 2.783177502845e+02
RINT15793 nd4943 nd4974 2.783177502845e+02
RINT15794 nd4944 nd4975 2.783177502845e+02
RINT15795 nd4945 nd4976 5.371885815399e+01
RINT15796 nd4946 nd4977 5.533517256115e+01
RINT15797 nd4947 nd4978 1.270102159742e+03
RINT15798 nd4948 nd4979 9.135281555084e+01
RINT15799 nd4949 nd4980 2.026342478141e+03
RINT15800 nd4950 nd4981 8.443093658921e+00
RINT15801 nd4951 nd4982 8.443093658921e+00
RINT15802 nd4952 nd4983 8.443093658921e+00
RINT15803 nd4953 nd4984 8.443093658921e+00
RINT15804 nd4954 nd4985 8.443093658921e+00
RINT15805 nd4955 nd4986 8.443093658921e+00
RINT15806 nd4956 nd4987 8.443093658921e+00
RINT15807 nd4957 nd4988 8.443093658921e+00
RINT15808 nd4958 nd4989 8.443093658921e+00
RINT15809 nd4959 nd4990 8.443093658921e+00
RINT15810 nd4960 nd4991 1.357228719451e+01
RINT15811 nd4961 nd4992 1.171973671568e+01
RINT15812 nd4962 nd4993 1.171973671568e+01
RINT15813 nd4963 nd4994 6.799630807155e+02
RINT15814 nd4964 nd4995 2.412121035800e+01
RINT15815 nd4965 nd4996 2.429181791977e+01
RINT15816 nd4966 nd4997 2.429181791977e+01
RINT15817 nd4967 nd4998 1.271962224384e+03
RINT15818 nd4968 nd4999 1.410120026542e+02
RINT15819 nd4969 nd5000 2.783177502845e+02
RINT15820 nd4970 nd5001 2.783177502845e+02
RINT15821 nd4971 nd5002 2.783177502845e+02
RINT15822 nd4972 nd5003 2.783177502845e+02
RINT15823 nd4973 nd5004 2.783177502845e+02
RINT15824 nd4974 nd5005 2.783177502845e+02
RINT15825 nd4975 nd5006 2.783177502845e+02
RINT15826 nd4976 nd5007 5.371885815399e+01
RINT15827 nd4977 nd5008 5.533517256115e+01
RINT15828 nd4978 nd5009 1.270102159742e+03
RINT15829 nd4979 nd5010 9.135281555084e+01
RINT15830 nd4980 nd5011 2.026342478141e+03
RINT15831 nd4981 nd5012 8.443093658921e+00
RINT15832 nd4982 nd5013 8.443093658921e+00
RINT15833 nd4983 nd5014 8.443093658921e+00
RINT15834 nd4984 nd5015 8.443093658921e+00
RINT15835 nd4985 nd5016 8.443093658921e+00
RINT15836 nd4986 nd5017 8.443093658921e+00
RINT15837 nd4987 nd5018 8.443093658921e+00
RINT15838 nd4988 nd5019 8.443093658921e+00
RINT15839 nd4989 nd5020 8.443093658921e+00
RINT15840 nd4990 nd5021 8.443093658921e+00
RINT15841 nd4991 nd5022 1.357228719451e+01
RINT15842 nd4992 nd5023 1.171973671568e+01
RINT15843 nd4993 nd5024 1.171973671568e+01
RINT15844 nd4994 nd5025 6.799630807155e+02
RINT15845 nd4995 nd5026 2.412121035800e+01
RINT15846 nd4996 nd5027 2.429181791977e+01
RINT15847 nd4997 nd5028 2.429181791977e+01
RINT15848 nd4998 nd5029 1.271962224384e+03
RINT15849 nd4999 nd5030 1.410120026542e+02
RINT15850 nd5000 nd5031 2.783177502845e+02
RINT15851 nd5001 nd5032 2.783177502845e+02
RINT15852 nd5002 nd5033 2.783177502845e+02
RINT15853 nd5003 nd5034 2.783177502845e+02
RINT15854 nd5004 nd5035 2.783177502845e+02
RINT15855 nd5005 nd5036 2.783177502845e+02
RINT15856 nd5006 nd5037 2.783177502845e+02
RINT15857 nd5007 nd5038 5.371885815399e+01
RINT15858 nd5008 nd5039 5.533517256115e+01
RINT15859 nd5009 nd5040 1.270102159742e+03
RINT15860 nd5010 nd5041 9.135281555084e+01
RINT15861 nd5011 nd5042 2.026342478141e+03
RINT15862 nd5012 nd5043 8.443093658921e+00
RINT15863 nd5013 nd5044 8.443093658921e+00
RINT15864 nd5014 nd5045 8.443093658921e+00
RINT15865 nd5015 nd5046 8.443093658921e+00
RINT15866 nd5016 nd5047 8.443093658921e+00
RINT15867 nd5017 nd5048 8.443093658921e+00
RINT15868 nd5018 nd5049 8.443093658921e+00
RINT15869 nd5019 nd5050 8.443093658921e+00
RINT15870 nd5020 nd5051 8.443093658921e+00
RINT15871 nd5021 nd5052 8.443093658921e+00
RINT15872 nd5022 nd5053 1.357228719451e+01
RINT15873 nd5023 nd5054 1.171973671568e+01
RINT15874 nd5024 nd5055 1.171973671568e+01
RINT15875 nd5025 nd5056 6.799630807155e+02
RINT15876 nd5026 nd5057 2.412121035800e+01
RINT15877 nd5027 nd5058 2.429181791977e+01
RINT15878 nd5028 nd5059 2.429181791977e+01
RINT15879 nd5029 nd5060 1.271962224384e+03
RINT15880 nd5030 nd5061 1.410120026542e+02
RINT15881 nd5031 nd5062 2.783177502845e+02
RINT15882 nd5032 nd5063 2.783177502845e+02
RINT15883 nd5033 nd5064 2.783177502845e+02
RINT15884 nd5034 nd5065 2.783177502845e+02
RINT15885 nd5035 nd5066 2.783177502845e+02
RINT15886 nd5036 nd5067 2.783177502845e+02
RINT15887 nd5037 nd5068 2.783177502845e+02
RINT15888 nd5038 nd5069 5.371885815399e+01
RINT15889 nd5039 nd5070 5.533517256115e+01
RINT15890 nd5040 nd5071 1.270102159742e+03
RINT15891 nd5041 nd5072 9.135281555084e+01
RINT15892 nd5042 nd5073 2.026342478141e+03
RINT15893 nd5043 nd5074 8.443093658921e+00
RINT15894 nd5044 nd5075 8.443093658921e+00
RINT15895 nd5045 nd5076 8.443093658921e+00
RINT15896 nd5046 nd5077 8.443093658921e+00
RINT15897 nd5047 nd5078 8.443093658921e+00
RINT15898 nd5048 nd5079 8.443093658921e+00
RINT15899 nd5049 nd5080 8.443093658921e+00
RINT15900 nd5050 nd5081 8.443093658921e+00
RINT15901 nd5051 nd5082 8.443093658921e+00
RINT15902 nd5052 nd5083 8.443093658921e+00
RINT15903 nd5053 nd5084 7.494898898358e+00
RINT15904 nd5054 nd5085 6.471882044678e+00
RINT15905 nd5055 nd5086 6.471882044678e+00
RINT15906 nd5056 nd5087 3.754897366627e+02
RINT15907 nd5057 nd5088 1.332023338058e+01
RINT15908 nd5058 nd5089 1.341444641988e+01
RINT15909 nd5059 nd5090 1.341444641988e+01
RINT15910 nd5060 nd5091 3.942767563891e+03
RINT15911 nd5061 nd5092 6.216370766103e+02
RINT15912 nd5062 nd5093 1.083955004199e+03
RINT15913 nd5063 nd5094 1.083955004199e+03
RINT15914 nd5064 nd5095 1.083955004199e+03
RINT15915 nd5065 nd5096 1.083955004199e+03
RINT15916 nd5066 nd5097 1.083955004199e+03
RINT15917 nd5067 nd5098 1.083955004199e+03
RINT15918 nd5068 nd5099 1.083955004199e+03
RINT15919 nd5069 nd5100 2.368141244230e+02
RINT15920 nd5070 nd5101 2.376222816266e+02
RINT15921 nd5071 nd5102 7.013767938611e+02
RINT15922 nd5072 nd5103 5.044692223361e+01
RINT15923 nd5073 nd5104 1.118988405525e+03
RINT15924 nd5074 nd5105 4.662451689687e+00
RINT15925 nd5075 nd5106 4.662451689687e+00
RINT15926 nd5076 nd5107 4.662451689687e+00
RINT15927 nd5077 nd5108 4.662451689687e+00
RINT15928 nd5078 nd5109 4.662451689687e+00
RINT15929 nd5079 nd5110 4.662451689687e+00
RINT15930 nd5080 nd5111 4.662451689687e+00
RINT15931 nd5081 nd5112 4.662451689687e+00
RINT15932 nd5082 nd5113 4.662451689687e+00
RINT15933 nd5083 nd5114 4.662451689687e+00
RINT15934 nd5084 nd5115 5.918933645378e+00
RINT15935 nd5085 nd5116 5.111028301069e+00
RINT15936 nd5086 nd5117 5.111028301069e+00
RINT15937 nd5087 nd5118 2.965348653754e+02
RINT15938 nd5088 nd5119 1.051936504946e+01
RINT15939 nd5089 nd5120 1.059376775131e+01
RINT15940 nd5090 nd5121 1.059376775131e+01
RINT15941 nd5091 nd5122 3.677205321604e+03
RINT15942 nd5092 nd5123 6.128675536007e+02
RINT15943 nd5093 nd5124 1.050630091887e+03
RINT15944 nd5094 nd5125 1.050630091887e+03
RINT15945 nd5095 nd5126 1.050630091887e+03
RINT15946 nd5096 nd5127 1.050630091887e+03
RINT15947 nd5097 nd5128 1.050630091887e+03
RINT15948 nd5098 nd5129 1.050630091887e+03
RINT15949 nd5099 nd5130 1.050630091887e+03
RINT15950 nd5100 nd5131 2.334733537526e+02
RINT15951 nd5101 nd5132 2.334733537526e+02
RINT15952 nd5102 nd5133 5.538970918181e+02
RINT15953 nd5103 nd5134 3.983936132610e+01
RINT15954 nd5104 nd5135 8.836967932549e+02
RINT15955 nd5105 nd5136 3.682069971895e+00
RINT15956 nd5106 nd5137 3.682069971895e+00
RINT15957 nd5107 nd5138 3.682069971895e+00
RINT15958 nd5108 nd5139 3.682069971895e+00
RINT15959 nd5109 nd5140 3.682069971895e+00
RINT15960 nd5110 nd5141 3.682069971895e+00
RINT15961 nd5111 nd5142 3.682069971895e+00
RINT15962 nd5112 nd5143 3.682069971895e+00
RINT15963 nd5113 nd5144 3.682069971895e+00
RINT15964 nd5114 nd5145 3.682069971895e+00
RINT15965 nd5115 nd5146 1.042035668855e+01
RINT15966 nd5116 nd5147 8.998029228461e+00
RINT15967 nd5117 nd5148 8.998029228461e+00
RINT15968 nd5118 nd5149 5.220533381408e+02
RINT15969 nd5119 nd5150 1.851947369575e+01
RINT15970 nd5120 nd5151 1.865046058263e+01
RINT15971 nd5121 nd5152 1.865046058263e+01
RINT15972 nd5122 nd5153 7.408377398100e+02
RINT15973 nd5123 nd5154 1.234729566350e+02
RINT15974 nd5124 nd5155 2.116679256600e+02
RINT15975 nd5125 nd5156 2.116679256600e+02
RINT15976 nd5126 nd5157 2.116679256600e+02
RINT15977 nd5127 nd5158 2.116679256600e+02
RINT15978 nd5128 nd5159 2.116679256600e+02
RINT15979 nd5129 nd5160 2.116679256600e+02
RINT15980 nd5130 nd5161 2.116679256600e+02
RINT15981 nd5131 nd5162 4.703731681333e+01
RINT15982 nd5132 nd5163 4.703731681333e+01
RINT15983 nd5133 nd5164 9.751427556557e+02
RINT15984 nd5134 nd5165 7.013769373582e+01
RINT15985 nd5135 nd5166 1.555759253601e+03
RINT15986 nd5136 nd5167 6.482330223337e+00
RINT15987 nd5137 nd5168 6.482330223337e+00
RINT15988 nd5138 nd5169 6.482330223337e+00
RINT15989 nd5139 nd5170 6.482330223337e+00
RINT15990 nd5140 nd5171 6.482330223337e+00
RINT15991 nd5141 nd5172 6.482330223337e+00
RINT15992 nd5142 nd5173 6.482330223337e+00
RINT15993 nd5143 nd5174 6.482330223337e+00
RINT15994 nd5144 nd5175 6.482330223337e+00
RINT15995 nd5145 nd5176 6.482330223337e+00
RINT15996 nd5146 nd5177 1.042035668855e+01
RINT15997 nd5147 nd5178 8.998029228461e+00
RINT15998 nd5148 nd5179 8.998029228461e+00
RINT15999 nd5149 nd5180 5.220533381408e+02
RINT16000 nd5150 nd5181 1.851947369575e+01
RINT16001 nd5151 nd5182 1.865046058263e+01
RINT16002 nd5152 nd5183 1.865046058263e+01
RINT16003 nd5153 nd5184 7.408377398100e+02
RINT16004 nd5154 nd5185 1.234729566350e+02
RINT16005 nd5155 nd5186 2.116679256600e+02
RINT16006 nd5156 nd5187 2.116679256600e+02
RINT16007 nd5157 nd5188 2.116679256600e+02
RINT16008 nd5158 nd5189 2.116679256600e+02
RINT16009 nd5159 nd5190 2.116679256600e+02
RINT16010 nd5160 nd5191 2.116679256600e+02
RINT16011 nd5161 nd5192 2.116679256600e+02
RINT16012 nd5162 nd5193 4.703731681333e+01
RINT16013 nd5163 nd5194 4.703731681333e+01
RINT16014 nd5164 nd5195 9.751427556557e+02
RINT16015 nd5165 nd5196 7.013769373582e+01
RINT16016 nd5166 nd5197 1.555759253601e+03
RINT16017 nd5167 nd5198 6.482330223337e+00
RINT16018 nd5168 nd5199 6.482330223337e+00
RINT16019 nd5169 nd5200 6.482330223337e+00
RINT16020 nd5170 nd5201 6.482330223337e+00
RINT16021 nd5171 nd5202 6.482330223337e+00
RINT16022 nd5172 nd5203 6.482330223337e+00
RINT16023 nd5173 nd5204 6.482330223337e+00
RINT16024 nd5174 nd5205 6.482330223337e+00
RINT16025 nd5175 nd5206 6.482330223337e+00
RINT16026 nd5176 nd5207 6.482330223337e+00
RINT16027 nd5208 nd5239 1.042035668855e+01
RINT16028 nd5209 nd5240 8.998029228461e+00
RINT16029 nd5210 nd5241 8.998029228461e+00
RINT16030 nd5211 nd5242 5.220533381408e+02
RINT16031 nd5212 nd5243 1.851947369575e+01
RINT16032 nd5213 nd5244 1.865046058263e+01
RINT16033 nd5214 nd5245 1.865046058263e+01
RINT16034 nd5215 nd5246 7.408377398100e+02
RINT16035 nd5216 nd5247 1.234729566350e+02
RINT16036 nd5217 nd5248 2.116679256600e+02
RINT16037 nd5218 nd5249 2.116679256600e+02
RINT16038 nd5219 nd5250 2.116679256600e+02
RINT16039 nd5220 nd5251 2.116679256600e+02
RINT16040 nd5221 nd5252 2.116679256600e+02
RINT16041 nd5222 nd5253 2.116679256600e+02
RINT16042 nd5223 nd5254 2.116679256600e+02
RINT16043 nd5224 nd5255 4.703731681333e+01
RINT16044 nd5225 nd5256 4.703731681333e+01
RINT16045 nd5226 nd5257 9.751427556557e+02
RINT16046 nd5227 nd5258 7.013769373582e+01
RINT16047 nd5228 nd5259 1.555759253601e+03
RINT16048 nd5229 nd5260 6.482330223337e+00
RINT16049 nd5230 nd5261 6.482330223337e+00
RINT16050 nd5231 nd5262 6.482330223337e+00
RINT16051 nd5232 nd5263 6.482330223337e+00
RINT16052 nd5233 nd5264 6.482330223337e+00
RINT16053 nd5234 nd5265 6.482330223337e+00
RINT16054 nd5235 nd5266 6.482330223337e+00
RINT16055 nd5236 nd5267 6.482330223337e+00
RINT16056 nd5237 nd5268 6.482330223337e+00
RINT16057 nd5238 nd5269 6.482330223337e+00
RINT16058 nd5239 nd5270 1.042035668855e+01
RINT16059 nd5240 nd5271 8.998029228461e+00
RINT16060 nd5241 nd5272 8.998029228461e+00
RINT16061 nd5242 nd5273 5.220533381408e+02
RINT16062 nd5243 nd5274 1.851947369575e+01
RINT16063 nd5244 nd5275 1.865046058263e+01
RINT16064 nd5245 nd5276 1.865046058263e+01
RINT16065 nd5246 nd5277 7.408377398100e+02
RINT16066 nd5247 nd5278 1.234729566350e+02
RINT16067 nd5248 nd5279 2.116679256600e+02
RINT16068 nd5249 nd5280 2.116679256600e+02
RINT16069 nd5250 nd5281 2.116679256600e+02
RINT16070 nd5251 nd5282 2.116679256600e+02
RINT16071 nd5252 nd5283 2.116679256600e+02
RINT16072 nd5253 nd5284 2.116679256600e+02
RINT16073 nd5254 nd5285 2.116679256600e+02
RINT16074 nd5255 nd5286 4.703731681333e+01
RINT16075 nd5256 nd5287 4.703731681333e+01
RINT16076 nd5257 nd5288 9.751427556557e+02
RINT16077 nd5258 nd5289 7.013769373582e+01
RINT16078 nd5259 nd5290 1.555759253601e+03
RINT16079 nd5260 nd5291 6.482330223337e+00
RINT16080 nd5261 nd5292 6.482330223337e+00
RINT16081 nd5262 nd5293 6.482330223337e+00
RINT16082 nd5263 nd5294 6.482330223337e+00
RINT16083 nd5264 nd5295 6.482330223337e+00
RINT16084 nd5265 nd5296 6.482330223337e+00
RINT16085 nd5266 nd5297 6.482330223337e+00
RINT16086 nd5267 nd5298 6.482330223337e+00
RINT16087 nd5268 nd5299 6.482330223337e+00
RINT16088 nd5269 nd5300 6.482330223337e+00
RINT16089 nd5270 nd5301 5.918933645377e+00
RINT16090 nd5271 nd5302 5.111028301069e+00
RINT16091 nd5272 nd5303 5.111028301069e+00
RINT16092 nd5273 nd5304 2.965348653754e+02
RINT16093 nd5274 nd5305 1.051936504946e+01
RINT16094 nd5275 nd5306 1.059376775131e+01
RINT16095 nd5276 nd5307 1.059376775131e+01
RINT16096 nd5277 nd5308 3.677205321604e+03
RINT16097 nd5278 nd5309 6.128675536007e+02
RINT16098 nd5279 nd5310 1.050630091887e+03
RINT16099 nd5280 nd5311 1.050630091887e+03
RINT16100 nd5281 nd5312 1.050630091887e+03
RINT16101 nd5282 nd5313 1.050630091887e+03
RINT16102 nd5283 nd5314 1.050630091887e+03
RINT16103 nd5284 nd5315 1.050630091887e+03
RINT16104 nd5285 nd5316 1.050630091887e+03
RINT16105 nd5286 nd5317 2.334733537526e+02
RINT16106 nd5287 nd5318 2.334733537526e+02
RINT16107 nd5288 nd5319 5.538970918181e+02
RINT16108 nd5289 nd5320 3.983936132610e+01
RINT16109 nd5290 nd5321 8.836967932549e+02
RINT16110 nd5291 nd5322 3.682069971895e+00
RINT16111 nd5292 nd5323 3.682069971895e+00
RINT16112 nd5293 nd5324 3.682069971895e+00
RINT16113 nd5294 nd5325 3.682069971895e+00
RINT16114 nd5295 nd5326 3.682069971895e+00
RINT16115 nd5296 nd5327 3.682069971895e+00
RINT16116 nd5297 nd5328 3.682069971895e+00
RINT16117 nd5298 nd5329 3.682069971895e+00
RINT16118 nd5299 nd5330 3.682069971895e+00
RINT16119 nd5300 nd5331 3.682069971895e+00
RINT16120 nd5301 nd5332 7.494898898358e+00
RINT16121 nd5302 nd5333 6.471882044678e+00
RINT16122 nd5303 nd5334 6.471882044678e+00
RINT16123 nd5304 nd5335 3.754897366627e+02
RINT16124 nd5305 nd5336 1.332023338058e+01
RINT16125 nd5306 nd5337 1.341444641988e+01
RINT16126 nd5307 nd5338 1.341444641988e+01
RINT16127 nd5308 nd5339 3.942767563891e+03
RINT16128 nd5309 nd5340 6.216370766103e+02
RINT16129 nd5310 nd5341 1.083955004199e+03
RINT16130 nd5311 nd5342 1.083955004199e+03
RINT16131 nd5312 nd5343 1.083955004199e+03
RINT16132 nd5313 nd5344 1.083955004199e+03
RINT16133 nd5314 nd5345 1.083955004199e+03
RINT16134 nd5315 nd5346 1.083955004199e+03
RINT16135 nd5316 nd5347 1.083955004199e+03
RINT16136 nd5317 nd5348 2.368141244230e+02
RINT16137 nd5318 nd5349 2.376222816265e+02
RINT16138 nd5319 nd5350 7.013767938611e+02
RINT16139 nd5320 nd5351 5.044692223361e+01
RINT16140 nd5321 nd5352 1.118988405525e+03
RINT16141 nd5322 nd5353 4.662451689687e+00
RINT16142 nd5323 nd5354 4.662451689687e+00
RINT16143 nd5324 nd5355 4.662451689687e+00
RINT16144 nd5325 nd5356 4.662451689687e+00
RINT16145 nd5326 nd5357 4.662451689687e+00
RINT16146 nd5327 nd5358 4.662451689687e+00
RINT16147 nd5328 nd5359 4.662451689687e+00
RINT16148 nd5329 nd5360 4.662451689687e+00
RINT16149 nd5330 nd5361 4.662451689687e+00
RINT16150 nd5331 nd5362 4.662451689687e+00
RINT16151 nd5332 nd5363 1.357228719451e+01
RINT16152 nd5333 nd5364 1.171973671568e+01
RINT16153 nd5334 nd5365 1.171973671568e+01
RINT16154 nd5335 nd5366 6.799630807155e+02
RINT16155 nd5336 nd5367 2.412121035800e+01
RINT16156 nd5337 nd5368 2.429181791977e+01
RINT16157 nd5338 nd5369 2.429181791977e+01
RINT16158 nd5339 nd5370 1.271962224384e+03
RINT16159 nd5340 nd5371 1.410120026542e+02
RINT16160 nd5341 nd5372 2.783177502845e+02
RINT16161 nd5342 nd5373 2.783177502845e+02
RINT16162 nd5343 nd5374 2.783177502845e+02
RINT16163 nd5344 nd5375 2.783177502845e+02
RINT16164 nd5345 nd5376 2.783177502845e+02
RINT16165 nd5346 nd5377 2.783177502845e+02
RINT16166 nd5347 nd5378 2.783177502845e+02
RINT16167 nd5348 nd5379 5.371885815399e+01
RINT16168 nd5349 nd5380 5.533517256115e+01
RINT16169 nd5350 nd5381 1.270102159742e+03
RINT16170 nd5351 nd5382 9.135281555084e+01
RINT16171 nd5352 nd5383 2.026342478141e+03
RINT16172 nd5353 nd5384 8.443093658921e+00
RINT16173 nd5354 nd5385 8.443093658921e+00
RINT16174 nd5355 nd5386 8.443093658921e+00
RINT16175 nd5356 nd5387 8.443093658921e+00
RINT16176 nd5357 nd5388 8.443093658921e+00
RINT16177 nd5358 nd5389 8.443093658921e+00
RINT16178 nd5359 nd5390 8.443093658921e+00
RINT16179 nd5360 nd5391 8.443093658921e+00
RINT16180 nd5361 nd5392 8.443093658921e+00
RINT16181 nd5362 nd5393 8.443093658921e+00
RINT16182 nd5363 nd5394 1.357228719451e+01
RINT16183 nd5364 nd5395 1.171973671568e+01
RINT16184 nd5365 nd5396 1.171973671568e+01
RINT16185 nd5366 nd5397 6.799630807155e+02
RINT16186 nd5367 nd5398 2.412121035800e+01
RINT16187 nd5368 nd5399 2.429181791977e+01
RINT16188 nd5369 nd5400 2.429181791977e+01
RINT16189 nd5370 nd5401 1.271962224384e+03
RINT16190 nd5371 nd5402 1.410120026542e+02
RINT16191 nd5372 nd5403 2.783177502845e+02
RINT16192 nd5373 nd5404 2.783177502845e+02
RINT16193 nd5374 nd5405 2.783177502845e+02
RINT16194 nd5375 nd5406 2.783177502845e+02
RINT16195 nd5376 nd5407 2.783177502845e+02
RINT16196 nd5377 nd5408 2.783177502845e+02
RINT16197 nd5378 nd5409 2.783177502845e+02
RINT16198 nd5379 nd5410 5.371885815399e+01
RINT16199 nd5380 nd5411 5.533517256115e+01
RINT16200 nd5381 nd5412 1.270102159742e+03
RINT16201 nd5382 nd5413 9.135281555084e+01
RINT16202 nd5383 nd5414 2.026342478141e+03
RINT16203 nd5384 nd5415 8.443093658921e+00
RINT16204 nd5385 nd5416 8.443093658921e+00
RINT16205 nd5386 nd5417 8.443093658921e+00
RINT16206 nd5387 nd5418 8.443093658921e+00
RINT16207 nd5388 nd5419 8.443093658921e+00
RINT16208 nd5389 nd5420 8.443093658921e+00
RINT16209 nd5390 nd5421 8.443093658921e+00
RINT16210 nd5391 nd5422 8.443093658921e+00
RINT16211 nd5392 nd5423 8.443093658921e+00
RINT16212 nd5393 nd5424 8.443093658921e+00
RINT16213 nd5394 nd5425 1.357228719451e+01
RINT16214 nd5395 nd5426 1.171973671568e+01
RINT16215 nd5396 nd5427 1.171973671568e+01
RINT16216 nd5397 nd5428 6.799630807155e+02
RINT16217 nd5398 nd5429 2.412121035800e+01
RINT16218 nd5399 nd5430 2.429181791977e+01
RINT16219 nd5400 nd5431 2.429181791977e+01
RINT16220 nd5401 nd5432 1.271962224384e+03
RINT16221 nd5402 nd5433 1.410120026542e+02
RINT16222 nd5403 nd5434 2.783177502845e+02
RINT16223 nd5404 nd5435 2.783177502845e+02
RINT16224 nd5405 nd5436 2.783177502845e+02
RINT16225 nd5406 nd5437 2.783177502845e+02
RINT16226 nd5407 nd5438 2.783177502845e+02
RINT16227 nd5408 nd5439 2.783177502845e+02
RINT16228 nd5409 nd5440 2.783177502845e+02
RINT16229 nd5410 nd5441 5.371885815399e+01
RINT16230 nd5411 nd5442 5.533517256115e+01
RINT16231 nd5412 nd5443 1.270102159742e+03
RINT16232 nd5413 nd5444 9.135281555084e+01
RINT16233 nd5414 nd5445 2.026342478141e+03
RINT16234 nd5415 nd5446 8.443093658921e+00
RINT16235 nd5416 nd5447 8.443093658921e+00
RINT16236 nd5417 nd5448 8.443093658921e+00
RINT16237 nd5418 nd5449 8.443093658921e+00
RINT16238 nd5419 nd5450 8.443093658921e+00
RINT16239 nd5420 nd5451 8.443093658921e+00
RINT16240 nd5421 nd5452 8.443093658921e+00
RINT16241 nd5422 nd5453 8.443093658921e+00
RINT16242 nd5423 nd5454 8.443093658921e+00
RINT16243 nd5424 nd5455 8.443093658921e+00
RINT16244 nd5425 nd5456 1.357228719451e+01
RINT16245 nd5426 nd5457 1.171973671568e+01
RINT16246 nd5427 nd5458 1.171973671568e+01
RINT16247 nd5428 nd5459 6.799630807155e+02
RINT16248 nd5429 nd5460 2.412121035800e+01
RINT16249 nd5430 nd5461 2.429181791977e+01
RINT16250 nd5431 nd5462 2.429181791977e+01
RINT16251 nd5432 nd5463 1.271962224384e+03
RINT16252 nd5433 nd5464 1.410120026542e+02
RINT16253 nd5434 nd5465 2.783177502845e+02
RINT16254 nd5435 nd5466 2.783177502845e+02
RINT16255 nd5436 nd5467 2.783177502845e+02
RINT16256 nd5437 nd5468 2.783177502845e+02
RINT16257 nd5438 nd5469 2.783177502845e+02
RINT16258 nd5439 nd5470 2.783177502845e+02
RINT16259 nd5440 nd5471 2.783177502845e+02
RINT16260 nd5441 nd5472 5.371885815399e+01
RINT16261 nd5442 nd5473 5.533517256115e+01
RINT16262 nd5443 nd5474 1.270102159742e+03
RINT16263 nd5444 nd5475 9.135281555084e+01
RINT16264 nd5445 nd5476 2.026342478141e+03
RINT16265 nd5446 nd5477 8.443093658921e+00
RINT16266 nd5447 nd5478 8.443093658921e+00
RINT16267 nd5448 nd5479 8.443093658921e+00
RINT16268 nd5449 nd5480 8.443093658921e+00
RINT16269 nd5450 nd5481 8.443093658921e+00
RINT16270 nd5451 nd5482 8.443093658921e+00
RINT16271 nd5452 nd5483 8.443093658921e+00
RINT16272 nd5453 nd5484 8.443093658921e+00
RINT16273 nd5454 nd5485 8.443093658921e+00
RINT16274 nd5455 nd5486 8.443093658921e+00
RINT16275 nd5456 nd5487 1.357228719451e+01
RINT16276 nd5457 nd5488 1.171973671568e+01
RINT16277 nd5458 nd5489 1.171973671568e+01
RINT16278 nd5459 nd5490 6.799630807155e+02
RINT16279 nd5460 nd5491 2.412121035800e+01
RINT16280 nd5461 nd5492 2.429181791977e+01
RINT16281 nd5462 nd5493 2.429181791977e+01
RINT16282 nd5463 nd5494 1.271962224384e+03
RINT16283 nd5464 nd5495 1.410120026542e+02
RINT16284 nd5465 nd5496 2.783177502845e+02
RINT16285 nd5466 nd5497 2.783177502845e+02
RINT16286 nd5467 nd5498 2.783177502845e+02
RINT16287 nd5468 nd5499 2.783177502845e+02
RINT16288 nd5469 nd5500 2.783177502845e+02
RINT16289 nd5470 nd5501 2.783177502845e+02
RINT16290 nd5471 nd5502 2.783177502845e+02
RINT16291 nd5472 nd5503 5.371885815399e+01
RINT16292 nd5473 nd5504 5.533517256115e+01
RINT16293 nd5474 nd5505 1.270102159742e+03
RINT16294 nd5475 nd5506 9.135281555084e+01
RINT16295 nd5476 nd5507 2.026342478141e+03
RINT16296 nd5477 nd5508 8.443093658921e+00
RINT16297 nd5478 nd5509 8.443093658921e+00
RINT16298 nd5479 nd5510 8.443093658921e+00
RINT16299 nd5480 nd5511 8.443093658921e+00
RINT16300 nd5481 nd5512 8.443093658921e+00
RINT16301 nd5482 nd5513 8.443093658921e+00
RINT16302 nd5483 nd5514 8.443093658921e+00
RINT16303 nd5484 nd5515 8.443093658921e+00
RINT16304 nd5485 nd5516 8.443093658921e+00
RINT16305 nd5486 nd5517 8.443093658921e+00
RINT16306 nd5487 nd5518 7.494898898358e+00
RINT16307 nd5488 nd5519 6.471882044678e+00
RINT16308 nd5489 nd5520 6.471882044678e+00
RINT16309 nd5490 nd5521 3.754897366627e+02
RINT16310 nd5491 nd5522 1.332023338058e+01
RINT16311 nd5492 nd5523 1.341444641988e+01
RINT16312 nd5493 nd5524 1.341444641988e+01
RINT16313 nd5494 nd5525 3.942767563891e+03
RINT16314 nd5495 nd5526 6.216370766103e+02
RINT16315 nd5496 nd5527 1.083955004199e+03
RINT16316 nd5497 nd5528 1.083955004199e+03
RINT16317 nd5498 nd5529 1.083955004199e+03
RINT16318 nd5499 nd5530 1.083955004199e+03
RINT16319 nd5500 nd5531 1.083955004199e+03
RINT16320 nd5501 nd5532 1.083955004199e+03
RINT16321 nd5502 nd5533 1.083955004199e+03
RINT16322 nd5503 nd5534 2.368141244230e+02
RINT16323 nd5504 nd5535 2.376222816266e+02
RINT16324 nd5505 nd5536 7.013767938611e+02
RINT16325 nd5506 nd5537 5.044692223361e+01
RINT16326 nd5507 nd5538 1.118988405525e+03
RINT16327 nd5508 nd5539 4.662451689687e+00
RINT16328 nd5509 nd5540 4.662451689687e+00
RINT16329 nd5510 nd5541 4.662451689687e+00
RINT16330 nd5511 nd5542 4.662451689687e+00
RINT16331 nd5512 nd5543 4.662451689687e+00
RINT16332 nd5513 nd5544 4.662451689687e+00
RINT16333 nd5514 nd5545 4.662451689687e+00
RINT16334 nd5515 nd5546 4.662451689687e+00
RINT16335 nd5516 nd5547 4.662451689687e+00
RINT16336 nd5517 nd5548 4.662451689687e+00
RINT16337 nd5518 nd5549 7.494898898358e+00
RINT16338 nd5519 nd5550 6.471882044678e+00
RINT16339 nd5520 nd5551 6.471882044678e+00
RINT16340 nd5521 nd5552 3.754897366627e+02
RINT16341 nd5522 nd5553 1.332023338058e+01
RINT16342 nd5523 nd5554 1.341444641988e+01
RINT16343 nd5524 nd5555 1.341444641988e+01
RINT16344 nd5525 nd5556 3.942767563891e+03
RINT16345 nd5526 nd5557 6.216370766103e+02
RINT16346 nd5527 nd5558 1.083955004199e+03
RINT16347 nd5528 nd5559 1.083955004199e+03
RINT16348 nd5529 nd5560 1.083955004199e+03
RINT16349 nd5530 nd5561 1.083955004199e+03
RINT16350 nd5531 nd5562 1.083955004199e+03
RINT16351 nd5532 nd5563 1.083955004199e+03
RINT16352 nd5533 nd5564 1.083955004199e+03
RINT16353 nd5534 nd5565 2.368141244230e+02
RINT16354 nd5535 nd5566 2.376222816266e+02
RINT16355 nd5536 nd5567 7.013767938611e+02
RINT16356 nd5537 nd5568 5.044692223361e+01
RINT16357 nd5538 nd5569 1.118988405525e+03
RINT16358 nd5539 nd5570 4.662451689687e+00
RINT16359 nd5540 nd5571 4.662451689687e+00
RINT16360 nd5541 nd5572 4.662451689687e+00
RINT16361 nd5542 nd5573 4.662451689687e+00
RINT16362 nd5543 nd5574 4.662451689687e+00
RINT16363 nd5544 nd5575 4.662451689687e+00
RINT16364 nd5545 nd5576 4.662451689687e+00
RINT16365 nd5546 nd5577 4.662451689687e+00
RINT16366 nd5547 nd5578 4.662451689687e+00
RINT16367 nd5548 nd5579 4.662451689687e+00
RINT16368 nd5549 nd5580 1.357228719451e+01
RINT16369 nd5550 nd5581 1.171973671568e+01
RINT16370 nd5551 nd5582 1.171973671568e+01
RINT16371 nd5552 nd5583 6.799630807155e+02
RINT16372 nd5553 nd5584 2.412121035800e+01
RINT16373 nd5554 nd5585 2.429181791977e+01
RINT16374 nd5555 nd5586 2.429181791977e+01
RINT16375 nd5556 nd5587 1.271962224384e+03
RINT16376 nd5557 nd5588 1.410120026542e+02
RINT16377 nd5558 nd5589 2.783177502845e+02
RINT16378 nd5559 nd5590 2.783177502845e+02
RINT16379 nd5560 nd5591 2.783177502845e+02
RINT16380 nd5561 nd5592 2.783177502845e+02
RINT16381 nd5562 nd5593 2.783177502845e+02
RINT16382 nd5563 nd5594 2.783177502845e+02
RINT16383 nd5564 nd5595 2.783177502845e+02
RINT16384 nd5565 nd5596 5.371885815399e+01
RINT16385 nd5566 nd5597 5.533517256115e+01
RINT16386 nd5567 nd5598 1.270102159742e+03
RINT16387 nd5568 nd5599 9.135281555084e+01
RINT16388 nd5569 nd5600 2.026342478141e+03
RINT16389 nd5570 nd5601 8.443093658921e+00
RINT16390 nd5571 nd5602 8.443093658921e+00
RINT16391 nd5572 nd5603 8.443093658921e+00
RINT16392 nd5573 nd5604 8.443093658921e+00
RINT16393 nd5574 nd5605 8.443093658921e+00
RINT16394 nd5575 nd5606 8.443093658921e+00
RINT16395 nd5576 nd5607 8.443093658921e+00
RINT16396 nd5577 nd5608 8.443093658921e+00
RINT16397 nd5578 nd5609 8.443093658921e+00
RINT16398 nd5579 nd5610 8.443093658921e+00
RINT16399 nd5580 nd5611 1.357228719451e+01
RINT16400 nd5581 nd5612 1.171973671568e+01
RINT16401 nd5582 nd5613 1.171973671568e+01
RINT16402 nd5583 nd5614 6.799630807155e+02
RINT16403 nd5584 nd5615 2.412121035800e+01
RINT16404 nd5585 nd5616 2.429181791977e+01
RINT16405 nd5586 nd5617 2.429181791977e+01
RINT16406 nd5587 nd5618 1.271962224384e+03
RINT16407 nd5588 nd5619 1.410120026542e+02
RINT16408 nd5589 nd5620 2.783177502845e+02
RINT16409 nd5590 nd5621 2.783177502845e+02
RINT16410 nd5591 nd5622 2.783177502845e+02
RINT16411 nd5592 nd5623 2.783177502845e+02
RINT16412 nd5593 nd5624 2.783177502845e+02
RINT16413 nd5594 nd5625 2.783177502845e+02
RINT16414 nd5595 nd5626 2.783177502845e+02
RINT16415 nd5596 nd5627 5.371885815399e+01
RINT16416 nd5597 nd5628 5.533517256115e+01
RINT16417 nd5598 nd5629 1.270102159742e+03
RINT16418 nd5599 nd5630 9.135281555084e+01
RINT16419 nd5600 nd5631 2.026342478141e+03
RINT16420 nd5601 nd5632 8.443093658921e+00
RINT16421 nd5602 nd5633 8.443093658921e+00
RINT16422 nd5603 nd5634 8.443093658921e+00
RINT16423 nd5604 nd5635 8.443093658921e+00
RINT16424 nd5605 nd5636 8.443093658921e+00
RINT16425 nd5606 nd5637 8.443093658921e+00
RINT16426 nd5607 nd5638 8.443093658921e+00
RINT16427 nd5608 nd5639 8.443093658921e+00
RINT16428 nd5609 nd5640 8.443093658921e+00
RINT16429 nd5610 nd5641 8.443093658921e+00
RINT16430 nd5611 nd5642 1.357228719451e+01
RINT16431 nd5612 nd5643 1.171973671568e+01
RINT16432 nd5613 nd5644 1.171973671568e+01
RINT16433 nd5614 nd5645 6.799630807155e+02
RINT16434 nd5615 nd5646 2.412121035800e+01
RINT16435 nd5616 nd5647 2.429181791977e+01
RINT16436 nd5617 nd5648 2.429181791977e+01
RINT16437 nd5618 nd5649 1.271962224384e+03
RINT16438 nd5619 nd5650 1.410120026542e+02
RINT16439 nd5620 nd5651 2.783177502845e+02
RINT16440 nd5621 nd5652 2.783177502845e+02
RINT16441 nd5622 nd5653 2.783177502845e+02
RINT16442 nd5623 nd5654 2.783177502845e+02
RINT16443 nd5624 nd5655 2.783177502845e+02
RINT16444 nd5625 nd5656 2.783177502845e+02
RINT16445 nd5626 nd5657 2.783177502845e+02
RINT16446 nd5627 nd5658 5.371885815399e+01
RINT16447 nd5628 nd5659 5.533517256115e+01
RINT16448 nd5629 nd5660 1.270102159742e+03
RINT16449 nd5630 nd5661 9.135281555084e+01
RINT16450 nd5631 nd5662 2.026342478141e+03
RINT16451 nd5632 nd5663 8.443093658921e+00
RINT16452 nd5633 nd5664 8.443093658921e+00
RINT16453 nd5634 nd5665 8.443093658921e+00
RINT16454 nd5635 nd5666 8.443093658921e+00
RINT16455 nd5636 nd5667 8.443093658921e+00
RINT16456 nd5637 nd5668 8.443093658921e+00
RINT16457 nd5638 nd5669 8.443093658921e+00
RINT16458 nd5639 nd5670 8.443093658921e+00
RINT16459 nd5640 nd5671 8.443093658921e+00
RINT16460 nd5641 nd5672 8.443093658921e+00
RINT16461 nd5642 nd5673 1.357228719451e+01
RINT16462 nd5643 nd5674 1.171973671568e+01
RINT16463 nd5644 nd5675 1.171973671568e+01
RINT16464 nd5645 nd5676 6.799630807155e+02
RINT16465 nd5646 nd5677 2.412121035800e+01
RINT16466 nd5647 nd5678 2.429181791977e+01
RINT16467 nd5648 nd5679 2.429181791977e+01
RINT16468 nd5649 nd5680 1.271962224384e+03
RINT16469 nd5650 nd5681 1.410120026542e+02
RINT16470 nd5651 nd5682 2.783177502845e+02
RINT16471 nd5652 nd5683 2.783177502845e+02
RINT16472 nd5653 nd5684 2.783177502845e+02
RINT16473 nd5654 nd5685 2.783177502845e+02
RINT16474 nd5655 nd5686 2.783177502845e+02
RINT16475 nd5656 nd5687 2.783177502845e+02
RINT16476 nd5657 nd5688 2.783177502845e+02
RINT16477 nd5658 nd5689 5.371885815399e+01
RINT16478 nd5659 nd5690 5.533517256115e+01
RINT16479 nd5660 nd5691 1.270102159742e+03
RINT16480 nd5661 nd5692 9.135281555084e+01
RINT16481 nd5662 nd5693 2.026342478141e+03
RINT16482 nd5663 nd5694 8.443093658921e+00
RINT16483 nd5664 nd5695 8.443093658921e+00
RINT16484 nd5665 nd5696 8.443093658921e+00
RINT16485 nd5666 nd5697 8.443093658921e+00
RINT16486 nd5667 nd5698 8.443093658921e+00
RINT16487 nd5668 nd5699 8.443093658921e+00
RINT16488 nd5669 nd5700 8.443093658921e+00
RINT16489 nd5670 nd5701 8.443093658921e+00
RINT16490 nd5671 nd5702 8.443093658921e+00
RINT16491 nd5672 nd5703 8.443093658921e+00
RINT16492 nd5673 nd5704 1.357228719451e+01
RINT16493 nd5674 nd5705 1.171973671568e+01
RINT16494 nd5675 nd5706 1.171973671568e+01
RINT16495 nd5676 nd5707 6.799630807155e+02
RINT16496 nd5677 nd5708 2.412121035800e+01
RINT16497 nd5678 nd5709 2.429181791977e+01
RINT16498 nd5679 nd5710 2.429181791977e+01
RINT16499 nd5680 nd5711 1.271962224384e+03
RINT16500 nd5681 nd5712 1.410120026542e+02
RINT16501 nd5682 nd5713 2.783177502845e+02
RINT16502 nd5683 nd5714 2.783177502845e+02
RINT16503 nd5684 nd5715 2.783177502845e+02
RINT16504 nd5685 nd5716 2.783177502845e+02
RINT16505 nd5686 nd5717 2.783177502845e+02
RINT16506 nd5687 nd5718 2.783177502845e+02
RINT16507 nd5688 nd5719 2.783177502845e+02
RINT16508 nd5689 nd5720 5.371885815399e+01
RINT16509 nd5690 nd5721 5.533517256115e+01
RINT16510 nd5691 nd5722 1.270102159742e+03
RINT16511 nd5692 nd5723 9.135281555084e+01
RINT16512 nd5693 nd5724 2.026342478141e+03
RINT16513 nd5694 nd5725 8.443093658921e+00
RINT16514 nd5695 nd5726 8.443093658921e+00
RINT16515 nd5696 nd5727 8.443093658921e+00
RINT16516 nd5697 nd5728 8.443093658921e+00
RINT16517 nd5698 nd5729 8.443093658921e+00
RINT16518 nd5699 nd5730 8.443093658921e+00
RINT16519 nd5700 nd5731 8.443093658921e+00
RINT16520 nd5701 nd5732 8.443093658921e+00
RINT16521 nd5702 nd5733 8.443093658921e+00
RINT16522 nd5703 nd5734 8.443093658921e+00
RINT16523 nd5704 nd5735 7.494898898358e+00
RINT16524 nd5705 nd5736 6.471882044678e+00
RINT16525 nd5706 nd5737 6.471882044678e+00
RINT16526 nd5707 nd5738 3.754897366627e+02
RINT16527 nd5708 nd5739 1.332023338058e+01
RINT16528 nd5709 nd5740 1.341444641988e+01
RINT16529 nd5710 nd5741 1.341444641988e+01
RINT16530 nd5711 nd5742 3.942767563891e+03
RINT16531 nd5712 nd5743 6.216370766103e+02
RINT16532 nd5713 nd5744 1.083955004199e+03
RINT16533 nd5714 nd5745 1.083955004199e+03
RINT16534 nd5715 nd5746 1.083955004199e+03
RINT16535 nd5716 nd5747 1.083955004199e+03
RINT16536 nd5717 nd5748 1.083955004199e+03
RINT16537 nd5718 nd5749 1.083955004199e+03
RINT16538 nd5719 nd5750 1.083955004199e+03
RINT16539 nd5720 nd5751 2.368141244230e+02
RINT16540 nd5721 nd5752 2.376222816266e+02
RINT16541 nd5722 nd5753 7.013767938611e+02
RINT16542 nd5723 nd5754 5.044692223361e+01
RINT16543 nd5724 nd5755 1.118988405525e+03
RINT16544 nd5725 nd5756 4.662451689687e+00
RINT16545 nd5726 nd5757 4.662451689687e+00
RINT16546 nd5727 nd5758 4.662451689687e+00
RINT16547 nd5728 nd5759 4.662451689687e+00
RINT16548 nd5729 nd5760 4.662451689687e+00
RINT16549 nd5730 nd5761 4.662451689687e+00
RINT16550 nd5731 nd5762 4.662451689687e+00
RINT16551 nd5732 nd5763 4.662451689687e+00
RINT16552 nd5733 nd5764 4.662451689687e+00
RINT16553 nd5734 nd5765 4.662451689687e+00
RINT16554 nd5735 nd5766 5.918933645378e+00
RINT16555 nd5736 nd5767 5.111028301069e+00
RINT16556 nd5737 nd5768 5.111028301069e+00
RINT16557 nd5738 nd5769 2.965348653754e+02
RINT16558 nd5739 nd5770 1.051936504946e+01
RINT16559 nd5740 nd5771 1.059376775131e+01
RINT16560 nd5741 nd5772 1.059376775131e+01
RINT16561 nd5742 nd5773 3.677205321604e+03
RINT16562 nd5743 nd5774 6.128675536007e+02
RINT16563 nd5744 nd5775 1.050630091887e+03
RINT16564 nd5745 nd5776 1.050630091887e+03
RINT16565 nd5746 nd5777 1.050630091887e+03
RINT16566 nd5747 nd5778 1.050630091887e+03
RINT16567 nd5748 nd5779 1.050630091887e+03
RINT16568 nd5749 nd5780 1.050630091887e+03
RINT16569 nd5750 nd5781 1.050630091887e+03
RINT16570 nd5751 nd5782 2.334733537526e+02
RINT16571 nd5752 nd5783 2.334733537526e+02
RINT16572 nd5753 nd5784 5.538970918181e+02
RINT16573 nd5754 nd5785 3.983936132610e+01
RINT16574 nd5755 nd5786 8.836967932549e+02
RINT16575 nd5756 nd5787 3.682069971895e+00
RINT16576 nd5757 nd5788 3.682069971895e+00
RINT16577 nd5758 nd5789 3.682069971895e+00
RINT16578 nd5759 nd5790 3.682069971895e+00
RINT16579 nd5760 nd5791 3.682069971895e+00
RINT16580 nd5761 nd5792 3.682069971895e+00
RINT16581 nd5762 nd5793 3.682069971895e+00
RINT16582 nd5763 nd5794 3.682069971895e+00
RINT16583 nd5764 nd5795 3.682069971895e+00
RINT16584 nd5765 nd5796 3.682069971895e+00
RINT16585 nd5766 nd5797 1.042035668855e+01
RINT16586 nd5767 nd5798 8.998029228461e+00
RINT16587 nd5768 nd5799 8.998029228461e+00
RINT16588 nd5769 nd5800 5.220533381408e+02
RINT16589 nd5770 nd5801 1.851947369575e+01
RINT16590 nd5771 nd5802 1.865046058263e+01
RINT16591 nd5772 nd5803 1.865046058263e+01
RINT16592 nd5773 nd5804 7.408377398100e+02
RINT16593 nd5774 nd5805 1.234729566350e+02
RINT16594 nd5775 nd5806 2.116679256600e+02
RINT16595 nd5776 nd5807 2.116679256600e+02
RINT16596 nd5777 nd5808 2.116679256600e+02
RINT16597 nd5778 nd5809 2.116679256600e+02
RINT16598 nd5779 nd5810 2.116679256600e+02
RINT16599 nd5780 nd5811 2.116679256600e+02
RINT16600 nd5781 nd5812 2.116679256600e+02
RINT16601 nd5782 nd5813 4.703731681333e+01
RINT16602 nd5783 nd5814 4.703731681333e+01
RINT16603 nd5784 nd5815 9.751427556557e+02
RINT16604 nd5785 nd5816 7.013769373581e+01
RINT16605 nd5786 nd5817 1.555759253601e+03
RINT16606 nd5787 nd5818 6.482330223337e+00
RINT16607 nd5788 nd5819 6.482330223337e+00
RINT16608 nd5789 nd5820 6.482330223337e+00
RINT16609 nd5790 nd5821 6.482330223337e+00
RINT16610 nd5791 nd5822 6.482330223337e+00
RINT16611 nd5792 nd5823 6.482330223337e+00
RINT16612 nd5793 nd5824 6.482330223337e+00
RINT16613 nd5794 nd5825 6.482330223337e+00
RINT16614 nd5795 nd5826 6.482330223337e+00
RINT16615 nd5796 nd5827 6.482330223337e+00
RINT16616 nd5797 nd5828 1.042035668855e+01
RINT16617 nd5798 nd5829 8.998029228461e+00
RINT16618 nd5799 nd5830 8.998029228461e+00
RINT16619 nd5800 nd5831 5.220533381408e+02
RINT16620 nd5801 nd5832 1.851947369575e+01
RINT16621 nd5802 nd5833 1.865046058263e+01
RINT16622 nd5803 nd5834 1.865046058263e+01
RINT16623 nd5804 nd5835 7.408377398100e+02
RINT16624 nd5805 nd5836 1.234729566350e+02
RINT16625 nd5806 nd5837 2.116679256600e+02
RINT16626 nd5807 nd5838 2.116679256600e+02
RINT16627 nd5808 nd5839 2.116679256600e+02
RINT16628 nd5809 nd5840 2.116679256600e+02
RINT16629 nd5810 nd5841 2.116679256600e+02
RINT16630 nd5811 nd5842 2.116679256600e+02
RINT16631 nd5812 nd5843 2.116679256600e+02
RINT16632 nd5813 nd5844 4.703731681333e+01
RINT16633 nd5814 nd5845 4.703731681333e+01
RINT16634 nd5815 nd5846 9.751427556557e+02
RINT16635 nd5816 nd5847 7.013769373581e+01
RINT16636 nd5817 nd5848 1.555759253601e+03
RINT16637 nd5818 nd5849 6.482330223337e+00
RINT16638 nd5819 nd5850 6.482330223337e+00
RINT16639 nd5820 nd5851 6.482330223337e+00
RINT16640 nd5821 nd5852 6.482330223337e+00
RINT16641 nd5822 nd5853 6.482330223337e+00
RINT16642 nd5823 nd5854 6.482330223337e+00
RINT16643 nd5824 nd5855 6.482330223337e+00
RINT16644 nd5825 nd5856 6.482330223337e+00
RINT16645 nd5826 nd5857 6.482330223337e+00
RINT16646 nd5827 nd5858 6.482330223337e+00
RINT16647 nd5859 nd5890 1.042035668855e+01
RINT16648 nd5860 nd5891 8.998029228461e+00
RINT16649 nd5861 nd5892 8.998029228461e+00
RINT16650 nd5862 nd5893 5.220533381408e+02
RINT16651 nd5863 nd5894 1.851947369575e+01
RINT16652 nd5864 nd5895 1.865046058263e+01
RINT16653 nd5865 nd5896 1.865046058263e+01
RINT16654 nd5866 nd5897 7.408377398100e+02
RINT16655 nd5867 nd5898 1.234729566350e+02
RINT16656 nd5868 nd5899 2.116679256600e+02
RINT16657 nd5869 nd5900 2.116679256600e+02
RINT16658 nd5870 nd5901 2.116679256600e+02
RINT16659 nd5871 nd5902 2.116679256600e+02
RINT16660 nd5872 nd5903 2.116679256600e+02
RINT16661 nd5873 nd5904 2.116679256600e+02
RINT16662 nd5874 nd5905 2.116679256600e+02
RINT16663 nd5875 nd5906 4.703731681333e+01
RINT16664 nd5876 nd5907 4.703731681333e+01
RINT16665 nd5877 nd5908 9.751427556557e+02
RINT16666 nd5878 nd5909 7.013769373582e+01
RINT16667 nd5879 nd5910 1.555759253601e+03
RINT16668 nd5880 nd5911 6.482330223337e+00
RINT16669 nd5881 nd5912 6.482330223337e+00
RINT16670 nd5882 nd5913 6.482330223337e+00
RINT16671 nd5883 nd5914 6.482330223337e+00
RINT16672 nd5884 nd5915 6.482330223337e+00
RINT16673 nd5885 nd5916 6.482330223337e+00
RINT16674 nd5886 nd5917 6.482330223337e+00
RINT16675 nd5887 nd5918 6.482330223337e+00
RINT16676 nd5888 nd5919 6.482330223337e+00
RINT16677 nd5889 nd5920 6.482330223337e+00
RINT16678 nd5890 nd5921 1.042035668855e+01
RINT16679 nd5891 nd5922 8.998029228461e+00
RINT16680 nd5892 nd5923 8.998029228461e+00
RINT16681 nd5893 nd5924 5.220533381408e+02
RINT16682 nd5894 nd5925 1.851947369575e+01
RINT16683 nd5895 nd5926 1.865046058263e+01
RINT16684 nd5896 nd5927 1.865046058263e+01
RINT16685 nd5897 nd5928 7.408377398100e+02
RINT16686 nd5898 nd5929 1.234729566350e+02
RINT16687 nd5899 nd5930 2.116679256600e+02
RINT16688 nd5900 nd5931 2.116679256600e+02
RINT16689 nd5901 nd5932 2.116679256600e+02
RINT16690 nd5902 nd5933 2.116679256600e+02
RINT16691 nd5903 nd5934 2.116679256600e+02
RINT16692 nd5904 nd5935 2.116679256600e+02
RINT16693 nd5905 nd5936 2.116679256600e+02
RINT16694 nd5906 nd5937 4.703731681333e+01
RINT16695 nd5907 nd5938 4.703731681333e+01
RINT16696 nd5908 nd5939 9.751427556557e+02
RINT16697 nd5909 nd5940 7.013769373582e+01
RINT16698 nd5910 nd5941 1.555759253601e+03
RINT16699 nd5911 nd5942 6.482330223337e+00
RINT16700 nd5912 nd5943 6.482330223337e+00
RINT16701 nd5913 nd5944 6.482330223337e+00
RINT16702 nd5914 nd5945 6.482330223337e+00
RINT16703 nd5915 nd5946 6.482330223337e+00
RINT16704 nd5916 nd5947 6.482330223337e+00
RINT16705 nd5917 nd5948 6.482330223337e+00
RINT16706 nd5918 nd5949 6.482330223337e+00
RINT16707 nd5919 nd5950 6.482330223337e+00
RINT16708 nd5920 nd5951 6.482330223337e+00
RINT16709 nd5921 nd5952 5.918933645378e+00
RINT16710 nd5922 nd5953 5.111028301069e+00
RINT16711 nd5923 nd5954 5.111028301069e+00
RINT16712 nd5924 nd5955 2.965348653754e+02
RINT16713 nd5925 nd5956 1.051936504946e+01
RINT16714 nd5926 nd5957 1.059376775131e+01
RINT16715 nd5927 nd5958 1.059376775131e+01
RINT16716 nd5928 nd5959 3.677205321604e+03
RINT16717 nd5929 nd5960 6.128675536007e+02
RINT16718 nd5930 nd5961 1.050630091887e+03
RINT16719 nd5931 nd5962 1.050630091887e+03
RINT16720 nd5932 nd5963 1.050630091887e+03
RINT16721 nd5933 nd5964 1.050630091887e+03
RINT16722 nd5934 nd5965 1.050630091887e+03
RINT16723 nd5935 nd5966 1.050630091887e+03
RINT16724 nd5936 nd5967 1.050630091887e+03
RINT16725 nd5937 nd5968 2.334733537526e+02
RINT16726 nd5938 nd5969 2.334733537526e+02
RINT16727 nd5939 nd5970 5.538970918181e+02
RINT16728 nd5940 nd5971 3.983936132610e+01
RINT16729 nd5941 nd5972 8.836967932549e+02
RINT16730 nd5942 nd5973 3.682069971895e+00
RINT16731 nd5943 nd5974 3.682069971895e+00
RINT16732 nd5944 nd5975 3.682069971895e+00
RINT16733 nd5945 nd5976 3.682069971895e+00
RINT16734 nd5946 nd5977 3.682069971895e+00
RINT16735 nd5947 nd5978 3.682069971895e+00
RINT16736 nd5948 nd5979 3.682069971895e+00
RINT16737 nd5949 nd5980 3.682069971895e+00
RINT16738 nd5950 nd5981 3.682069971895e+00
RINT16739 nd5951 nd5982 3.682069971895e+00
RINT16740 nd5952 nd5983 7.494898898358e+00
RINT16741 nd5953 nd5984 6.471882044678e+00
RINT16742 nd5954 nd5985 6.471882044678e+00
RINT16743 nd5955 nd5986 3.754897366627e+02
RINT16744 nd5956 nd5987 1.332023338058e+01
RINT16745 nd5957 nd5988 1.341444641988e+01
RINT16746 nd5958 nd5989 1.341444641988e+01
RINT16747 nd5959 nd5990 3.942767563891e+03
RINT16748 nd5960 nd5991 6.216370766103e+02
RINT16749 nd5961 nd5992 1.083955004199e+03
RINT16750 nd5962 nd5993 1.083955004199e+03
RINT16751 nd5963 nd5994 1.083955004199e+03
RINT16752 nd5964 nd5995 1.083955004199e+03
RINT16753 nd5965 nd5996 1.083955004199e+03
RINT16754 nd5966 nd5997 1.083955004199e+03
RINT16755 nd5967 nd5998 1.083955004199e+03
RINT16756 nd5968 nd5999 2.368141244230e+02
RINT16757 nd5969 nd6000 2.376222816265e+02
RINT16758 nd5970 nd6001 7.013767938611e+02
RINT16759 nd5971 nd6002 5.044692223361e+01
RINT16760 nd5972 nd6003 1.118988405525e+03
RINT16761 nd5973 nd6004 4.662451689687e+00
RINT16762 nd5974 nd6005 4.662451689687e+00
RINT16763 nd5975 nd6006 4.662451689687e+00
RINT16764 nd5976 nd6007 4.662451689687e+00
RINT16765 nd5977 nd6008 4.662451689687e+00
RINT16766 nd5978 nd6009 4.662451689687e+00
RINT16767 nd5979 nd6010 4.662451689687e+00
RINT16768 nd5980 nd6011 4.662451689687e+00
RINT16769 nd5981 nd6012 4.662451689687e+00
RINT16770 nd5982 nd6013 4.662451689687e+00
RINT16771 nd5983 nd6014 1.357228719451e+01
RINT16772 nd5984 nd6015 1.171973671568e+01
RINT16773 nd5985 nd6016 1.171973671568e+01
RINT16774 nd5986 nd6017 6.799630807155e+02
RINT16775 nd5987 nd6018 2.412121035800e+01
RINT16776 nd5988 nd6019 2.429181791977e+01
RINT16777 nd5989 nd6020 2.429181791977e+01
RINT16778 nd5990 nd6021 1.271962224384e+03
RINT16779 nd5991 nd6022 1.410120026542e+02
RINT16780 nd5992 nd6023 2.783177502845e+02
RINT16781 nd5993 nd6024 2.783177502845e+02
RINT16782 nd5994 nd6025 2.783177502845e+02
RINT16783 nd5995 nd6026 2.783177502845e+02
RINT16784 nd5996 nd6027 2.783177502845e+02
RINT16785 nd5997 nd6028 2.783177502845e+02
RINT16786 nd5998 nd6029 2.783177502845e+02
RINT16787 nd5999 nd6030 5.371885815399e+01
RINT16788 nd6000 nd6031 5.533517256115e+01
RINT16789 nd6001 nd6032 1.270102159742e+03
RINT16790 nd6002 nd6033 9.135281555084e+01
RINT16791 nd6003 nd6034 2.026342478141e+03
RINT16792 nd6004 nd6035 8.443093658921e+00
RINT16793 nd6005 nd6036 8.443093658921e+00
RINT16794 nd6006 nd6037 8.443093658921e+00
RINT16795 nd6007 nd6038 8.443093658921e+00
RINT16796 nd6008 nd6039 8.443093658921e+00
RINT16797 nd6009 nd6040 8.443093658921e+00
RINT16798 nd6010 nd6041 8.443093658921e+00
RINT16799 nd6011 nd6042 8.443093658921e+00
RINT16800 nd6012 nd6043 8.443093658921e+00
RINT16801 nd6013 nd6044 8.443093658921e+00
RINT16802 nd6014 nd6045 1.357228719451e+01
RINT16803 nd6015 nd6046 1.171973671568e+01
RINT16804 nd6016 nd6047 1.171973671568e+01
RINT16805 nd6017 nd6048 6.799630807155e+02
RINT16806 nd6018 nd6049 2.412121035800e+01
RINT16807 nd6019 nd6050 2.429181791977e+01
RINT16808 nd6020 nd6051 2.429181791977e+01
RINT16809 nd6021 nd6052 1.271962224384e+03
RINT16810 nd6022 nd6053 1.410120026542e+02
RINT16811 nd6023 nd6054 2.783177502845e+02
RINT16812 nd6024 nd6055 2.783177502845e+02
RINT16813 nd6025 nd6056 2.783177502845e+02
RINT16814 nd6026 nd6057 2.783177502845e+02
RINT16815 nd6027 nd6058 2.783177502845e+02
RINT16816 nd6028 nd6059 2.783177502845e+02
RINT16817 nd6029 nd6060 2.783177502845e+02
RINT16818 nd6030 nd6061 5.371885815399e+01
RINT16819 nd6031 nd6062 5.533517256115e+01
RINT16820 nd6032 nd6063 1.270102159742e+03
RINT16821 nd6033 nd6064 9.135281555084e+01
RINT16822 nd6034 nd6065 2.026342478141e+03
RINT16823 nd6035 nd6066 8.443093658921e+00
RINT16824 nd6036 nd6067 8.443093658921e+00
RINT16825 nd6037 nd6068 8.443093658921e+00
RINT16826 nd6038 nd6069 8.443093658921e+00
RINT16827 nd6039 nd6070 8.443093658921e+00
RINT16828 nd6040 nd6071 8.443093658921e+00
RINT16829 nd6041 nd6072 8.443093658921e+00
RINT16830 nd6042 nd6073 8.443093658921e+00
RINT16831 nd6043 nd6074 8.443093658921e+00
RINT16832 nd6044 nd6075 8.443093658921e+00
RINT16833 nd6045 nd6076 1.357228719451e+01
RINT16834 nd6046 nd6077 1.171973671568e+01
RINT16835 nd6047 nd6078 1.171973671568e+01
RINT16836 nd6048 nd6079 6.799630807155e+02
RINT16837 nd6049 nd6080 2.412121035800e+01
RINT16838 nd6050 nd6081 2.429181791977e+01
RINT16839 nd6051 nd6082 2.429181791977e+01
RINT16840 nd6052 nd6083 1.271962224384e+03
RINT16841 nd6053 nd6084 1.410120026542e+02
RINT16842 nd6054 nd6085 2.783177502845e+02
RINT16843 nd6055 nd6086 2.783177502845e+02
RINT16844 nd6056 nd6087 2.783177502845e+02
RINT16845 nd6057 nd6088 2.783177502845e+02
RINT16846 nd6058 nd6089 2.783177502845e+02
RINT16847 nd6059 nd6090 2.783177502845e+02
RINT16848 nd6060 nd6091 2.783177502845e+02
RINT16849 nd6061 nd6092 5.371885815399e+01
RINT16850 nd6062 nd6093 5.533517256115e+01
RINT16851 nd6063 nd6094 1.270102159742e+03
RINT16852 nd6064 nd6095 9.135281555084e+01
RINT16853 nd6065 nd6096 2.026342478141e+03
RINT16854 nd6066 nd6097 8.443093658921e+00
RINT16855 nd6067 nd6098 8.443093658921e+00
RINT16856 nd6068 nd6099 8.443093658921e+00
RINT16857 nd6069 nd6100 8.443093658921e+00
RINT16858 nd6070 nd6101 8.443093658921e+00
RINT16859 nd6071 nd6102 8.443093658921e+00
RINT16860 nd6072 nd6103 8.443093658921e+00
RINT16861 nd6073 nd6104 8.443093658921e+00
RINT16862 nd6074 nd6105 8.443093658921e+00
RINT16863 nd6075 nd6106 8.443093658921e+00
RINT16864 nd6076 nd6107 1.357228719451e+01
RINT16865 nd6077 nd6108 1.171973671568e+01
RINT16866 nd6078 nd6109 1.171973671568e+01
RINT16867 nd6079 nd6110 6.799630807155e+02
RINT16868 nd6080 nd6111 2.412121035800e+01
RINT16869 nd6081 nd6112 2.429181791977e+01
RINT16870 nd6082 nd6113 2.429181791977e+01
RINT16871 nd6083 nd6114 1.271962224384e+03
RINT16872 nd6084 nd6115 1.410120026542e+02
RINT16873 nd6085 nd6116 2.783177502845e+02
RINT16874 nd6086 nd6117 2.783177502845e+02
RINT16875 nd6087 nd6118 2.783177502845e+02
RINT16876 nd6088 nd6119 2.783177502845e+02
RINT16877 nd6089 nd6120 2.783177502845e+02
RINT16878 nd6090 nd6121 2.783177502845e+02
RINT16879 nd6091 nd6122 2.783177502845e+02
RINT16880 nd6092 nd6123 5.371885815399e+01
RINT16881 nd6093 nd6124 5.533517256115e+01
RINT16882 nd6094 nd6125 1.270102159742e+03
RINT16883 nd6095 nd6126 9.135281555084e+01
RINT16884 nd6096 nd6127 2.026342478141e+03
RINT16885 nd6097 nd6128 8.443093658921e+00
RINT16886 nd6098 nd6129 8.443093658921e+00
RINT16887 nd6099 nd6130 8.443093658921e+00
RINT16888 nd6100 nd6131 8.443093658921e+00
RINT16889 nd6101 nd6132 8.443093658921e+00
RINT16890 nd6102 nd6133 8.443093658921e+00
RINT16891 nd6103 nd6134 8.443093658921e+00
RINT16892 nd6104 nd6135 8.443093658921e+00
RINT16893 nd6105 nd6136 8.443093658921e+00
RINT16894 nd6106 nd6137 8.443093658921e+00
RINT16895 nd6107 nd6138 1.357228719451e+01
RINT16896 nd6108 nd6139 1.171973671568e+01
RINT16897 nd6109 nd6140 1.171973671568e+01
RINT16898 nd6110 nd6141 6.799630807155e+02
RINT16899 nd6111 nd6142 2.412121035800e+01
RINT16900 nd6112 nd6143 2.429181791977e+01
RINT16901 nd6113 nd6144 2.429181791977e+01
RINT16902 nd6114 nd6145 1.271962224384e+03
RINT16903 nd6115 nd6146 1.410120026542e+02
RINT16904 nd6116 nd6147 2.783177502845e+02
RINT16905 nd6117 nd6148 2.783177502845e+02
RINT16906 nd6118 nd6149 2.783177502845e+02
RINT16907 nd6119 nd6150 2.783177502845e+02
RINT16908 nd6120 nd6151 2.783177502845e+02
RINT16909 nd6121 nd6152 2.783177502845e+02
RINT16910 nd6122 nd6153 2.783177502845e+02
RINT16911 nd6123 nd6154 5.371885815399e+01
RINT16912 nd6124 nd6155 5.533517256115e+01
RINT16913 nd6125 nd6156 1.270102159742e+03
RINT16914 nd6126 nd6157 9.135281555084e+01
RINT16915 nd6127 nd6158 2.026342478141e+03
RINT16916 nd6128 nd6159 8.443093658921e+00
RINT16917 nd6129 nd6160 8.443093658921e+00
RINT16918 nd6130 nd6161 8.443093658921e+00
RINT16919 nd6131 nd6162 8.443093658921e+00
RINT16920 nd6132 nd6163 8.443093658921e+00
RINT16921 nd6133 nd6164 8.443093658921e+00
RINT16922 nd6134 nd6165 8.443093658921e+00
RINT16923 nd6135 nd6166 8.443093658921e+00
RINT16924 nd6136 nd6167 8.443093658921e+00
RINT16925 nd6137 nd6168 8.443093658921e+00
RINT16926 nd6138 nd6169 7.494898898358e+00
RINT16927 nd6139 nd6170 6.471882044678e+00
RINT16928 nd6140 nd6171 6.471882044678e+00
RINT16929 nd6141 nd6172 3.754897366627e+02
RINT16930 nd6142 nd6173 1.332023338058e+01
RINT16931 nd6143 nd6174 1.341444641988e+01
RINT16932 nd6144 nd6175 1.341444641988e+01
RINT16933 nd6145 nd6176 3.942767563891e+03
RINT16934 nd6146 nd6177 6.216370766103e+02
RINT16935 nd6147 nd6178 1.083955004199e+03
RINT16936 nd6148 nd6179 1.083955004199e+03
RINT16937 nd6149 nd6180 1.083955004199e+03
RINT16938 nd6150 nd6181 1.083955004199e+03
RINT16939 nd6151 nd6182 1.083955004199e+03
RINT16940 nd6152 nd6183 1.083955004199e+03
RINT16941 nd6153 nd6184 1.083955004199e+03
RINT16942 nd6154 nd6185 2.368141244230e+02
RINT16943 nd6155 nd6186 2.376222816266e+02
RINT16944 nd6156 nd6187 7.013767938611e+02
RINT16945 nd6157 nd6188 5.044692223361e+01
RINT16946 nd6158 nd6189 1.118988405525e+03
RINT16947 nd6159 nd6190 4.662451689687e+00
RINT16948 nd6160 nd6191 4.662451689687e+00
RINT16949 nd6161 nd6192 4.662451689687e+00
RINT16950 nd6162 nd6193 4.662451689687e+00
RINT16951 nd6163 nd6194 4.662451689687e+00
RINT16952 nd6164 nd6195 4.662451689687e+00
RINT16953 nd6165 nd6196 4.662451689687e+00
RINT16954 nd6166 nd6197 4.662451689687e+00
RINT16955 nd6167 nd6198 4.662451689687e+00
RINT16956 nd6168 nd6199 4.662451689687e+00
RINT16957 nd6169 nd6200 7.494898898358e+00
RINT16958 nd6170 nd6201 6.471882044678e+00
RINT16959 nd6171 nd6202 6.471882044678e+00
RINT16960 nd6172 nd6203 3.754897366627e+02
RINT16961 nd6173 nd6204 1.332023338058e+01
RINT16962 nd6174 nd6205 1.341444641988e+01
RINT16963 nd6175 nd6206 1.341444641988e+01
RINT16964 nd6176 nd6207 3.942767563891e+03
RINT16965 nd6177 nd6208 6.216370766103e+02
RINT16966 nd6178 nd6209 1.083955004199e+03
RINT16967 nd6179 nd6210 1.083955004199e+03
RINT16968 nd6180 nd6211 1.083955004199e+03
RINT16969 nd6181 nd6212 1.083955004199e+03
RINT16970 nd6182 nd6213 1.083955004199e+03
RINT16971 nd6183 nd6214 1.083955004199e+03
RINT16972 nd6184 nd6215 1.083955004199e+03
RINT16973 nd6185 nd6216 2.368141244230e+02
RINT16974 nd6186 nd6217 2.376222816266e+02
RINT16975 nd6187 nd6218 7.013767938611e+02
RINT16976 nd6188 nd6219 5.044692223361e+01
RINT16977 nd6189 nd6220 1.118988405525e+03
RINT16978 nd6190 nd6221 4.662451689687e+00
RINT16979 nd6191 nd6222 4.662451689687e+00
RINT16980 nd6192 nd6223 4.662451689687e+00
RINT16981 nd6193 nd6224 4.662451689687e+00
RINT16982 nd6194 nd6225 4.662451689687e+00
RINT16983 nd6195 nd6226 4.662451689687e+00
RINT16984 nd6196 nd6227 4.662451689687e+00
RINT16985 nd6197 nd6228 4.662451689687e+00
RINT16986 nd6198 nd6229 4.662451689687e+00
RINT16987 nd6199 nd6230 4.662451689687e+00
RINT16988 nd6200 nd6231 1.357228719451e+01
RINT16989 nd6201 nd6232 1.171973671568e+01
RINT16990 nd6202 nd6233 1.171973671568e+01
RINT16991 nd6203 nd6234 6.799630807155e+02
RINT16992 nd6204 nd6235 2.412121035800e+01
RINT16993 nd6205 nd6236 2.429181791977e+01
RINT16994 nd6206 nd6237 2.429181791977e+01
RINT16995 nd6207 nd6238 1.271962224384e+03
RINT16996 nd6208 nd6239 1.410120026542e+02
RINT16997 nd6209 nd6240 2.783177502845e+02
RINT16998 nd6210 nd6241 2.783177502845e+02
RINT16999 nd6211 nd6242 2.783177502845e+02
RINT17000 nd6212 nd6243 2.783177502845e+02
RINT17001 nd6213 nd6244 2.783177502845e+02
RINT17002 nd6214 nd6245 2.783177502845e+02
RINT17003 nd6215 nd6246 2.783177502845e+02
RINT17004 nd6216 nd6247 5.371885815399e+01
RINT17005 nd6217 nd6248 5.533517256115e+01
RINT17006 nd6218 nd6249 1.270102159742e+03
RINT17007 nd6219 nd6250 9.135281555084e+01
RINT17008 nd6220 nd6251 2.026342478141e+03
RINT17009 nd6221 nd6252 8.443093658921e+00
RINT17010 nd6222 nd6253 8.443093658921e+00
RINT17011 nd6223 nd6254 8.443093658921e+00
RINT17012 nd6224 nd6255 8.443093658921e+00
RINT17013 nd6225 nd6256 8.443093658921e+00
RINT17014 nd6226 nd6257 8.443093658921e+00
RINT17015 nd6227 nd6258 8.443093658921e+00
RINT17016 nd6228 nd6259 8.443093658921e+00
RINT17017 nd6229 nd6260 8.443093658921e+00
RINT17018 nd6230 nd6261 8.443093658921e+00
RINT17019 nd6231 nd6262 1.357228719451e+01
RINT17020 nd6232 nd6263 1.171973671568e+01
RINT17021 nd6233 nd6264 1.171973671568e+01
RINT17022 nd6234 nd6265 6.799630807155e+02
RINT17023 nd6235 nd6266 2.412121035800e+01
RINT17024 nd6236 nd6267 2.429181791977e+01
RINT17025 nd6237 nd6268 2.429181791977e+01
RINT17026 nd6238 nd6269 1.271962224384e+03
RINT17027 nd6239 nd6270 1.410120026542e+02
RINT17028 nd6240 nd6271 2.783177502845e+02
RINT17029 nd6241 nd6272 2.783177502845e+02
RINT17030 nd6242 nd6273 2.783177502845e+02
RINT17031 nd6243 nd6274 2.783177502845e+02
RINT17032 nd6244 nd6275 2.783177502845e+02
RINT17033 nd6245 nd6276 2.783177502845e+02
RINT17034 nd6246 nd6277 2.783177502845e+02
RINT17035 nd6247 nd6278 5.371885815399e+01
RINT17036 nd6248 nd6279 5.533517256115e+01
RINT17037 nd6249 nd6280 1.270102159742e+03
RINT17038 nd6250 nd6281 9.135281555084e+01
RINT17039 nd6251 nd6282 2.026342478141e+03
RINT17040 nd6252 nd6283 8.443093658921e+00
RINT17041 nd6253 nd6284 8.443093658921e+00
RINT17042 nd6254 nd6285 8.443093658921e+00
RINT17043 nd6255 nd6286 8.443093658921e+00
RINT17044 nd6256 nd6287 8.443093658921e+00
RINT17045 nd6257 nd6288 8.443093658921e+00
RINT17046 nd6258 nd6289 8.443093658921e+00
RINT17047 nd6259 nd6290 8.443093658921e+00
RINT17048 nd6260 nd6291 8.443093658921e+00
RINT17049 nd6261 nd6292 8.443093658921e+00
RINT17050 nd6262 nd6293 1.357228719451e+01
RINT17051 nd6263 nd6294 1.171973671568e+01
RINT17052 nd6264 nd6295 1.171973671568e+01
RINT17053 nd6265 nd6296 6.799630807155e+02
RINT17054 nd6266 nd6297 2.412121035800e+01
RINT17055 nd6267 nd6298 2.429181791977e+01
RINT17056 nd6268 nd6299 2.429181791977e+01
RINT17057 nd6269 nd6300 1.271962224384e+03
RINT17058 nd6270 nd6301 1.410120026542e+02
RINT17059 nd6271 nd6302 2.783177502845e+02
RINT17060 nd6272 nd6303 2.783177502845e+02
RINT17061 nd6273 nd6304 2.783177502845e+02
RINT17062 nd6274 nd6305 2.783177502845e+02
RINT17063 nd6275 nd6306 2.783177502845e+02
RINT17064 nd6276 nd6307 2.783177502845e+02
RINT17065 nd6277 nd6308 2.783177502845e+02
RINT17066 nd6278 nd6309 5.371885815399e+01
RINT17067 nd6279 nd6310 5.533517256115e+01
RINT17068 nd6280 nd6311 1.270102159742e+03
RINT17069 nd6281 nd6312 9.135281555084e+01
RINT17070 nd6282 nd6313 2.026342478141e+03
RINT17071 nd6283 nd6314 8.443093658921e+00
RINT17072 nd6284 nd6315 8.443093658921e+00
RINT17073 nd6285 nd6316 8.443093658921e+00
RINT17074 nd6286 nd6317 8.443093658921e+00
RINT17075 nd6287 nd6318 8.443093658921e+00
RINT17076 nd6288 nd6319 8.443093658921e+00
RINT17077 nd6289 nd6320 8.443093658921e+00
RINT17078 nd6290 nd6321 8.443093658921e+00
RINT17079 nd6291 nd6322 8.443093658921e+00
RINT17080 nd6292 nd6323 8.443093658921e+00
RINT17081 nd6293 nd6324 1.357228719451e+01
RINT17082 nd6294 nd6325 1.171973671568e+01
RINT17083 nd6295 nd6326 1.171973671568e+01
RINT17084 nd6296 nd6327 6.799630807155e+02
RINT17085 nd6297 nd6328 2.412121035800e+01
RINT17086 nd6298 nd6329 2.429181791977e+01
RINT17087 nd6299 nd6330 2.429181791977e+01
RINT17088 nd6300 nd6331 1.271962224384e+03
RINT17089 nd6301 nd6332 1.410120026542e+02
RINT17090 nd6302 nd6333 2.783177502845e+02
RINT17091 nd6303 nd6334 2.783177502845e+02
RINT17092 nd6304 nd6335 2.783177502845e+02
RINT17093 nd6305 nd6336 2.783177502845e+02
RINT17094 nd6306 nd6337 2.783177502845e+02
RINT17095 nd6307 nd6338 2.783177502845e+02
RINT17096 nd6308 nd6339 2.783177502845e+02
RINT17097 nd6309 nd6340 5.371885815399e+01
RINT17098 nd6310 nd6341 5.533517256115e+01
RINT17099 nd6311 nd6342 1.270102159742e+03
RINT17100 nd6312 nd6343 9.135281555084e+01
RINT17101 nd6313 nd6344 2.026342478141e+03
RINT17102 nd6314 nd6345 8.443093658921e+00
RINT17103 nd6315 nd6346 8.443093658921e+00
RINT17104 nd6316 nd6347 8.443093658921e+00
RINT17105 nd6317 nd6348 8.443093658921e+00
RINT17106 nd6318 nd6349 8.443093658921e+00
RINT17107 nd6319 nd6350 8.443093658921e+00
RINT17108 nd6320 nd6351 8.443093658921e+00
RINT17109 nd6321 nd6352 8.443093658921e+00
RINT17110 nd6322 nd6353 8.443093658921e+00
RINT17111 nd6323 nd6354 8.443093658921e+00
RINT17112 nd6324 nd6355 1.357228719451e+01
RINT17113 nd6325 nd6356 1.171973671568e+01
RINT17114 nd6326 nd6357 1.171973671568e+01
RINT17115 nd6327 nd6358 6.799630807155e+02
RINT17116 nd6328 nd6359 2.412121035800e+01
RINT17117 nd6329 nd6360 2.429181791977e+01
RINT17118 nd6330 nd6361 2.429181791977e+01
RINT17119 nd6331 nd6362 1.271962224384e+03
RINT17120 nd6332 nd6363 1.410120026542e+02
RINT17121 nd6333 nd6364 2.783177502845e+02
RINT17122 nd6334 nd6365 2.783177502845e+02
RINT17123 nd6335 nd6366 2.783177502845e+02
RINT17124 nd6336 nd6367 2.783177502845e+02
RINT17125 nd6337 nd6368 2.783177502845e+02
RINT17126 nd6338 nd6369 2.783177502845e+02
RINT17127 nd6339 nd6370 2.783177502845e+02
RINT17128 nd6340 nd6371 5.371885815399e+01
RINT17129 nd6341 nd6372 5.533517256115e+01
RINT17130 nd6342 nd6373 1.270102159742e+03
RINT17131 nd6343 nd6374 9.135281555084e+01
RINT17132 nd6344 nd6375 2.026342478141e+03
RINT17133 nd6345 nd6376 8.443093658921e+00
RINT17134 nd6346 nd6377 8.443093658921e+00
RINT17135 nd6347 nd6378 8.443093658921e+00
RINT17136 nd6348 nd6379 8.443093658921e+00
RINT17137 nd6349 nd6380 8.443093658921e+00
RINT17138 nd6350 nd6381 8.443093658921e+00
RINT17139 nd6351 nd6382 8.443093658921e+00
RINT17140 nd6352 nd6383 8.443093658921e+00
RINT17141 nd6353 nd6384 8.443093658921e+00
RINT17142 nd6354 nd6385 8.443093658921e+00
RINT17143 nd6355 nd6386 7.494898898358e+00
RINT17144 nd6356 nd6387 6.471882044678e+00
RINT17145 nd6357 nd6388 6.471882044678e+00
RINT17146 nd6358 nd6389 3.754897366627e+02
RINT17147 nd6359 nd6390 1.332023338058e+01
RINT17148 nd6360 nd6391 1.341444641988e+01
RINT17149 nd6361 nd6392 1.341444641988e+01
RINT17150 nd6362 nd6393 3.942767563891e+03
RINT17151 nd6363 nd6394 6.216370766103e+02
RINT17152 nd6364 nd6395 1.083955004199e+03
RINT17153 nd6365 nd6396 1.083955004199e+03
RINT17154 nd6366 nd6397 1.083955004199e+03
RINT17155 nd6367 nd6398 1.083955004199e+03
RINT17156 nd6368 nd6399 1.083955004199e+03
RINT17157 nd6369 nd6400 1.083955004199e+03
RINT17158 nd6370 nd6401 1.083955004199e+03
RINT17159 nd6371 nd6402 2.368141244230e+02
RINT17160 nd6372 nd6403 2.376222816266e+02
RINT17161 nd6373 nd6404 7.013767938611e+02
RINT17162 nd6374 nd6405 5.044692223361e+01
RINT17163 nd6375 nd6406 1.118988405525e+03
RINT17164 nd6376 nd6407 4.662451689687e+00
RINT17165 nd6377 nd6408 4.662451689687e+00
RINT17166 nd6378 nd6409 4.662451689687e+00
RINT17167 nd6379 nd6410 4.662451689687e+00
RINT17168 nd6380 nd6411 4.662451689687e+00
RINT17169 nd6381 nd6412 4.662451689687e+00
RINT17170 nd6382 nd6413 4.662451689687e+00
RINT17171 nd6383 nd6414 4.662451689687e+00
RINT17172 nd6384 nd6415 4.662451689687e+00
RINT17173 nd6385 nd6416 4.662451689687e+00
RINT17174 nd6386 nd6417 5.918933645378e+00
RINT17175 nd6387 nd6418 5.111028301069e+00
RINT17176 nd6388 nd6419 5.111028301069e+00
RINT17177 nd6389 nd6420 2.965348653754e+02
RINT17178 nd6390 nd6421 1.051936504946e+01
RINT17179 nd6391 nd6422 1.059376775131e+01
RINT17180 nd6392 nd6423 1.059376775131e+01
RINT17181 nd6393 nd6424 3.677205321604e+03
RINT17182 nd6394 nd6425 6.128675536007e+02
RINT17183 nd6395 nd6426 1.050630091887e+03
RINT17184 nd6396 nd6427 1.050630091887e+03
RINT17185 nd6397 nd6428 1.050630091887e+03
RINT17186 nd6398 nd6429 1.050630091887e+03
RINT17187 nd6399 nd6430 1.050630091887e+03
RINT17188 nd6400 nd6431 1.050630091887e+03
RINT17189 nd6401 nd6432 1.050630091887e+03
RINT17190 nd6402 nd6433 2.334733537526e+02
RINT17191 nd6403 nd6434 2.334733537526e+02
RINT17192 nd6404 nd6435 5.538970918181e+02
RINT17193 nd6405 nd6436 3.983936132610e+01
RINT17194 nd6406 nd6437 8.836967932549e+02
RINT17195 nd6407 nd6438 3.682069971895e+00
RINT17196 nd6408 nd6439 3.682069971895e+00
RINT17197 nd6409 nd6440 3.682069971895e+00
RINT17198 nd6410 nd6441 3.682069971895e+00
RINT17199 nd6411 nd6442 3.682069971895e+00
RINT17200 nd6412 nd6443 3.682069971895e+00
RINT17201 nd6413 nd6444 3.682069971895e+00
RINT17202 nd6414 nd6445 3.682069971895e+00
RINT17203 nd6415 nd6446 3.682069971895e+00
RINT17204 nd6416 nd6447 3.682069971895e+00
RINT17205 nd6417 nd6448 1.042035668855e+01
RINT17206 nd6418 nd6449 8.998029228461e+00
RINT17207 nd6419 nd6450 8.998029228461e+00
RINT17208 nd6420 nd6451 5.220533381408e+02
RINT17209 nd6421 nd6452 1.851947369575e+01
RINT17210 nd6422 nd6453 1.865046058263e+01
RINT17211 nd6423 nd6454 1.865046058263e+01
RINT17212 nd6424 nd6455 7.408377398100e+02
RINT17213 nd6425 nd6456 1.234729566350e+02
RINT17214 nd6426 nd6457 2.116679256600e+02
RINT17215 nd6427 nd6458 2.116679256600e+02
RINT17216 nd6428 nd6459 2.116679256600e+02
RINT17217 nd6429 nd6460 2.116679256600e+02
RINT17218 nd6430 nd6461 2.116679256600e+02
RINT17219 nd6431 nd6462 2.116679256600e+02
RINT17220 nd6432 nd6463 2.116679256600e+02
RINT17221 nd6433 nd6464 4.703731681333e+01
RINT17222 nd6434 nd6465 4.703731681333e+01
RINT17223 nd6435 nd6466 9.751427556557e+02
RINT17224 nd6436 nd6467 7.013769373582e+01
RINT17225 nd6437 nd6468 1.555759253601e+03
RINT17226 nd6438 nd6469 6.482330223337e+00
RINT17227 nd6439 nd6470 6.482330223337e+00
RINT17228 nd6440 nd6471 6.482330223337e+00
RINT17229 nd6441 nd6472 6.482330223337e+00
RINT17230 nd6442 nd6473 6.482330223337e+00
RINT17231 nd6443 nd6474 6.482330223337e+00
RINT17232 nd6444 nd6475 6.482330223337e+00
RINT17233 nd6445 nd6476 6.482330223337e+00
RINT17234 nd6446 nd6477 6.482330223337e+00
RINT17235 nd6447 nd6478 6.482330223337e+00
RINT17236 nd6448 nd6479 1.042035668855e+01
RINT17237 nd6449 nd6480 8.998029228461e+00
RINT17238 nd6450 nd6481 8.998029228461e+00
RINT17239 nd6451 nd6482 5.220533381408e+02
RINT17240 nd6452 nd6483 1.851947369575e+01
RINT17241 nd6453 nd6484 1.865046058263e+01
RINT17242 nd6454 nd6485 1.865046058263e+01
RINT17243 nd6455 nd6486 7.408377398100e+02
RINT17244 nd6456 nd6487 1.234729566350e+02
RINT17245 nd6457 nd6488 2.116679256600e+02
RINT17246 nd6458 nd6489 2.116679256600e+02
RINT17247 nd6459 nd6490 2.116679256600e+02
RINT17248 nd6460 nd6491 2.116679256600e+02
RINT17249 nd6461 nd6492 2.116679256600e+02
RINT17250 nd6462 nd6493 2.116679256600e+02
RINT17251 nd6463 nd6494 2.116679256600e+02
RINT17252 nd6464 nd6495 4.703731681333e+01
RINT17253 nd6465 nd6496 4.703731681333e+01
RINT17254 nd6466 nd6497 9.751427556557e+02
RINT17255 nd6467 nd6498 7.013769373582e+01
RINT17256 nd6468 nd6499 1.555759253601e+03
RINT17257 nd6469 nd6500 6.482330223337e+00
RINT17258 nd6470 nd6501 6.482330223337e+00
RINT17259 nd6471 nd6502 6.482330223337e+00
RINT17260 nd6472 nd6503 6.482330223337e+00
RINT17261 nd6473 nd6504 6.482330223337e+00
RINT17262 nd6474 nd6505 6.482330223337e+00
RINT17263 nd6475 nd6506 6.482330223337e+00
RINT17264 nd6476 nd6507 6.482330223337e+00
RINT17265 nd6477 nd6508 6.482330223337e+00
RINT17266 nd6478 nd6509 6.482330223337e+00
RINT17267 nd6510 nd6541 1.042035668855e+01
RINT17268 nd6511 nd6542 8.998029228461e+00
RINT17269 nd6512 nd6543 8.998029228461e+00
RINT17270 nd6513 nd6544 5.220533381408e+02
RINT17271 nd6514 nd6545 1.851947369575e+01
RINT17272 nd6515 nd6546 1.865046058263e+01
RINT17273 nd6516 nd6547 1.865046058263e+01
RINT17274 nd6517 nd6548 7.408377398100e+02
RINT17275 nd6518 nd6549 1.234729566350e+02
RINT17276 nd6519 nd6550 2.116679256600e+02
RINT17277 nd6520 nd6551 2.116679256600e+02
RINT17278 nd6521 nd6552 2.116679256600e+02
RINT17279 nd6522 nd6553 2.116679256600e+02
RINT17280 nd6523 nd6554 2.116679256600e+02
RINT17281 nd6524 nd6555 2.116679256600e+02
RINT17282 nd6525 nd6556 2.116679256600e+02
RINT17283 nd6526 nd6557 4.703731681333e+01
RINT17284 nd6527 nd6558 4.703731681333e+01
RINT17285 nd6528 nd6559 9.751427556557e+02
RINT17286 nd6529 nd6560 7.013769373582e+01
RINT17287 nd6530 nd6561 1.555759253601e+03
RINT17288 nd6531 nd6562 6.482330223337e+00
RINT17289 nd6532 nd6563 6.482330223337e+00
RINT17290 nd6533 nd6564 6.482330223337e+00
RINT17291 nd6534 nd6565 6.482330223337e+00
RINT17292 nd6535 nd6566 6.482330223337e+00
RINT17293 nd6536 nd6567 6.482330223337e+00
RINT17294 nd6537 nd6568 6.482330223337e+00
RINT17295 nd6538 nd6569 6.482330223337e+00
RINT17296 nd6539 nd6570 6.482330223337e+00
RINT17297 nd6540 nd6571 6.482330223337e+00
RINT17298 nd6541 nd6572 1.042035668855e+01
RINT17299 nd6542 nd6573 8.998029228461e+00
RINT17300 nd6543 nd6574 8.998029228461e+00
RINT17301 nd6544 nd6575 5.220533381408e+02
RINT17302 nd6545 nd6576 1.851947369575e+01
RINT17303 nd6546 nd6577 1.865046058263e+01
RINT17304 nd6547 nd6578 1.865046058263e+01
RINT17305 nd6548 nd6579 7.408377398100e+02
RINT17306 nd6549 nd6580 1.234729566350e+02
RINT17307 nd6550 nd6581 2.116679256600e+02
RINT17308 nd6551 nd6582 2.116679256600e+02
RINT17309 nd6552 nd6583 2.116679256600e+02
RINT17310 nd6553 nd6584 2.116679256600e+02
RINT17311 nd6554 nd6585 2.116679256600e+02
RINT17312 nd6555 nd6586 2.116679256600e+02
RINT17313 nd6556 nd6587 2.116679256600e+02
RINT17314 nd6557 nd6588 4.703731681333e+01
RINT17315 nd6558 nd6589 4.703731681333e+01
RINT17316 nd6559 nd6590 9.751427556557e+02
RINT17317 nd6560 nd6591 7.013769373582e+01
RINT17318 nd6561 nd6592 1.555759253601e+03
RINT17319 nd6562 nd6593 6.482330223337e+00
RINT17320 nd6563 nd6594 6.482330223337e+00
RINT17321 nd6564 nd6595 6.482330223337e+00
RINT17322 nd6565 nd6596 6.482330223337e+00
RINT17323 nd6566 nd6597 6.482330223337e+00
RINT17324 nd6567 nd6598 6.482330223337e+00
RINT17325 nd6568 nd6599 6.482330223337e+00
RINT17326 nd6569 nd6600 6.482330223337e+00
RINT17327 nd6570 nd6601 6.482330223337e+00
RINT17328 nd6571 nd6602 6.482330223337e+00
RINT17329 nd6572 nd6603 5.918933645378e+00
RINT17330 nd6573 nd6604 5.111028301069e+00
RINT17331 nd6574 nd6605 5.111028301069e+00
RINT17332 nd6575 nd6606 2.965348653754e+02
RINT17333 nd6576 nd6607 1.051936504946e+01
RINT17334 nd6577 nd6608 1.059376775131e+01
RINT17335 nd6578 nd6609 1.059376775131e+01
RINT17336 nd6579 nd6610 3.677205321604e+03
RINT17337 nd6580 nd6611 6.128675536007e+02
RINT17338 nd6581 nd6612 1.050630091887e+03
RINT17339 nd6582 nd6613 1.050630091887e+03
RINT17340 nd6583 nd6614 1.050630091887e+03
RINT17341 nd6584 nd6615 1.050630091887e+03
RINT17342 nd6585 nd6616 1.050630091887e+03
RINT17343 nd6586 nd6617 1.050630091887e+03
RINT17344 nd6587 nd6618 1.050630091887e+03
RINT17345 nd6588 nd6619 2.334733537526e+02
RINT17346 nd6589 nd6620 2.334733537526e+02
RINT17347 nd6590 nd6621 5.538970918181e+02
RINT17348 nd6591 nd6622 3.983936132610e+01
RINT17349 nd6592 nd6623 8.836967932549e+02
RINT17350 nd6593 nd6624 3.682069971895e+00
RINT17351 nd6594 nd6625 3.682069971895e+00
RINT17352 nd6595 nd6626 3.682069971895e+00
RINT17353 nd6596 nd6627 3.682069971895e+00
RINT17354 nd6597 nd6628 3.682069971895e+00
RINT17355 nd6598 nd6629 3.682069971895e+00
RINT17356 nd6599 nd6630 3.682069971895e+00
RINT17357 nd6600 nd6631 3.682069971895e+00
RINT17358 nd6601 nd6632 3.682069971895e+00
RINT17359 nd6602 nd6633 3.682069971895e+00
RINT17360 nd6603 nd6634 7.494898898358e+00
RINT17361 nd6604 nd6635 6.471882044678e+00
RINT17362 nd6605 nd6636 6.471882044678e+00
RINT17363 nd6606 nd6637 3.754897366627e+02
RINT17364 nd6607 nd6638 1.332023338058e+01
RINT17365 nd6608 nd6639 1.341444641988e+01
RINT17366 nd6609 nd6640 1.341444641988e+01
RINT17367 nd6610 nd6641 3.942767563891e+03
RINT17368 nd6611 nd6642 6.216370766103e+02
RINT17369 nd6612 nd6643 1.083955004199e+03
RINT17370 nd6613 nd6644 1.083955004199e+03
RINT17371 nd6614 nd6645 1.083955004199e+03
RINT17372 nd6615 nd6646 1.083955004199e+03
RINT17373 nd6616 nd6647 1.083955004199e+03
RINT17374 nd6617 nd6648 1.083955004199e+03
RINT17375 nd6618 nd6649 1.083955004199e+03
RINT17376 nd6619 nd6650 2.368141244230e+02
RINT17377 nd6620 nd6651 2.376222816265e+02
RINT17378 nd6621 nd6652 7.013767938611e+02
RINT17379 nd6622 nd6653 5.044692223361e+01
RINT17380 nd6623 nd6654 1.118988405525e+03
RINT17381 nd6624 nd6655 4.662451689687e+00
RINT17382 nd6625 nd6656 4.662451689687e+00
RINT17383 nd6626 nd6657 4.662451689687e+00
RINT17384 nd6627 nd6658 4.662451689687e+00
RINT17385 nd6628 nd6659 4.662451689687e+00
RINT17386 nd6629 nd6660 4.662451689687e+00
RINT17387 nd6630 nd6661 4.662451689687e+00
RINT17388 nd6631 nd6662 4.662451689687e+00
RINT17389 nd6632 nd6663 4.662451689687e+00
RINT17390 nd6633 nd6664 4.662451689687e+00
RINT17391 nd6634 nd6665 1.357228719451e+01
RINT17392 nd6635 nd6666 1.171973671568e+01
RINT17393 nd6636 nd6667 1.171973671568e+01
RINT17394 nd6637 nd6668 6.799630807155e+02
RINT17395 nd6638 nd6669 2.412121035800e+01
RINT17396 nd6639 nd6670 2.429181791977e+01
RINT17397 nd6640 nd6671 2.429181791977e+01
RINT17398 nd6641 nd6672 1.271962224384e+03
RINT17399 nd6642 nd6673 1.410120026542e+02
RINT17400 nd6643 nd6674 2.783177502845e+02
RINT17401 nd6644 nd6675 2.783177502845e+02
RINT17402 nd6645 nd6676 2.783177502845e+02
RINT17403 nd6646 nd6677 2.783177502845e+02
RINT17404 nd6647 nd6678 2.783177502845e+02
RINT17405 nd6648 nd6679 2.783177502845e+02
RINT17406 nd6649 nd6680 2.783177502845e+02
RINT17407 nd6650 nd6681 5.371885815399e+01
RINT17408 nd6651 nd6682 5.533517256115e+01
RINT17409 nd6652 nd6683 1.270102159742e+03
RINT17410 nd6653 nd6684 9.135281555084e+01
RINT17411 nd6654 nd6685 2.026342478141e+03
RINT17412 nd6655 nd6686 8.443093658921e+00
RINT17413 nd6656 nd6687 8.443093658921e+00
RINT17414 nd6657 nd6688 8.443093658921e+00
RINT17415 nd6658 nd6689 8.443093658921e+00
RINT17416 nd6659 nd6690 8.443093658921e+00
RINT17417 nd6660 nd6691 8.443093658921e+00
RINT17418 nd6661 nd6692 8.443093658921e+00
RINT17419 nd6662 nd6693 8.443093658921e+00
RINT17420 nd6663 nd6694 8.443093658921e+00
RINT17421 nd6664 nd6695 8.443093658921e+00
RINT17422 nd6665 nd6696 1.357228719451e+01
RINT17423 nd6666 nd6697 1.171973671568e+01
RINT17424 nd6667 nd6698 1.171973671568e+01
RINT17425 nd6668 nd6699 6.799630807155e+02
RINT17426 nd6669 nd6700 2.412121035800e+01
RINT17427 nd6670 nd6701 2.429181791977e+01
RINT17428 nd6671 nd6702 2.429181791977e+01
RINT17429 nd6672 nd6703 1.271962224384e+03
RINT17430 nd6673 nd6704 1.410120026542e+02
RINT17431 nd6674 nd6705 2.783177502845e+02
RINT17432 nd6675 nd6706 2.783177502845e+02
RINT17433 nd6676 nd6707 2.783177502845e+02
RINT17434 nd6677 nd6708 2.783177502845e+02
RINT17435 nd6678 nd6709 2.783177502845e+02
RINT17436 nd6679 nd6710 2.783177502845e+02
RINT17437 nd6680 nd6711 2.783177502845e+02
RINT17438 nd6681 nd6712 5.371885815399e+01
RINT17439 nd6682 nd6713 5.533517256115e+01
RINT17440 nd6683 nd6714 1.270102159742e+03
RINT17441 nd6684 nd6715 9.135281555084e+01
RINT17442 nd6685 nd6716 2.026342478141e+03
RINT17443 nd6686 nd6717 8.443093658921e+00
RINT17444 nd6687 nd6718 8.443093658921e+00
RINT17445 nd6688 nd6719 8.443093658921e+00
RINT17446 nd6689 nd6720 8.443093658921e+00
RINT17447 nd6690 nd6721 8.443093658921e+00
RINT17448 nd6691 nd6722 8.443093658921e+00
RINT17449 nd6692 nd6723 8.443093658921e+00
RINT17450 nd6693 nd6724 8.443093658921e+00
RINT17451 nd6694 nd6725 8.443093658921e+00
RINT17452 nd6695 nd6726 8.443093658921e+00
RINT17453 nd6696 nd6727 1.357228719451e+01
RINT17454 nd6697 nd6728 1.171973671568e+01
RINT17455 nd6698 nd6729 1.171973671568e+01
RINT17456 nd6699 nd6730 6.799630807155e+02
RINT17457 nd6700 nd6731 2.412121035800e+01
RINT17458 nd6701 nd6732 2.429181791977e+01
RINT17459 nd6702 nd6733 2.429181791977e+01
RINT17460 nd6703 nd6734 1.271962224384e+03
RINT17461 nd6704 nd6735 1.410120026542e+02
RINT17462 nd6705 nd6736 2.783177502845e+02
RINT17463 nd6706 nd6737 2.783177502845e+02
RINT17464 nd6707 nd6738 2.783177502845e+02
RINT17465 nd6708 nd6739 2.783177502845e+02
RINT17466 nd6709 nd6740 2.783177502845e+02
RINT17467 nd6710 nd6741 2.783177502845e+02
RINT17468 nd6711 nd6742 2.783177502845e+02
RINT17469 nd6712 nd6743 5.371885815399e+01
RINT17470 nd6713 nd6744 5.533517256115e+01
RINT17471 nd6714 nd6745 1.270102159742e+03
RINT17472 nd6715 nd6746 9.135281555084e+01
RINT17473 nd6716 nd6747 2.026342478141e+03
RINT17474 nd6717 nd6748 8.443093658921e+00
RINT17475 nd6718 nd6749 8.443093658921e+00
RINT17476 nd6719 nd6750 8.443093658921e+00
RINT17477 nd6720 nd6751 8.443093658921e+00
RINT17478 nd6721 nd6752 8.443093658921e+00
RINT17479 nd6722 nd6753 8.443093658921e+00
RINT17480 nd6723 nd6754 8.443093658921e+00
RINT17481 nd6724 nd6755 8.443093658921e+00
RINT17482 nd6725 nd6756 8.443093658921e+00
RINT17483 nd6726 nd6757 8.443093658921e+00
RINT17484 nd6727 nd6758 1.357228719451e+01
RINT17485 nd6728 nd6759 1.171973671568e+01
RINT17486 nd6729 nd6760 1.171973671568e+01
RINT17487 nd6730 nd6761 6.799630807155e+02
RINT17488 nd6731 nd6762 2.412121035800e+01
RINT17489 nd6732 nd6763 2.429181791977e+01
RINT17490 nd6733 nd6764 2.429181791977e+01
RINT17491 nd6734 nd6765 1.271962224384e+03
RINT17492 nd6735 nd6766 1.410120026542e+02
RINT17493 nd6736 nd6767 2.783177502845e+02
RINT17494 nd6737 nd6768 2.783177502845e+02
RINT17495 nd6738 nd6769 2.783177502845e+02
RINT17496 nd6739 nd6770 2.783177502845e+02
RINT17497 nd6740 nd6771 2.783177502845e+02
RINT17498 nd6741 nd6772 2.783177502845e+02
RINT17499 nd6742 nd6773 2.783177502845e+02
RINT17500 nd6743 nd6774 5.371885815399e+01
RINT17501 nd6744 nd6775 5.533517256115e+01
RINT17502 nd6745 nd6776 1.270102159742e+03
RINT17503 nd6746 nd6777 9.135281555084e+01
RINT17504 nd6747 nd6778 2.026342478141e+03
RINT17505 nd6748 nd6779 8.443093658921e+00
RINT17506 nd6749 nd6780 8.443093658921e+00
RINT17507 nd6750 nd6781 8.443093658921e+00
RINT17508 nd6751 nd6782 8.443093658921e+00
RINT17509 nd6752 nd6783 8.443093658921e+00
RINT17510 nd6753 nd6784 8.443093658921e+00
RINT17511 nd6754 nd6785 8.443093658921e+00
RINT17512 nd6755 nd6786 8.443093658921e+00
RINT17513 nd6756 nd6787 8.443093658921e+00
RINT17514 nd6757 nd6788 8.443093658921e+00
RINT17515 nd6758 nd6789 1.357228719451e+01
RINT17516 nd6759 nd6790 1.171973671568e+01
RINT17517 nd6760 nd6791 1.171973671568e+01
RINT17518 nd6761 nd6792 6.799630807155e+02
RINT17519 nd6762 nd6793 2.412121035800e+01
RINT17520 nd6763 nd6794 2.429181791977e+01
RINT17521 nd6764 nd6795 2.429181791977e+01
RINT17522 nd6765 nd6796 1.271962224384e+03
RINT17523 nd6766 nd6797 1.410120026542e+02
RINT17524 nd6767 nd6798 2.783177502845e+02
RINT17525 nd6768 nd6799 2.783177502845e+02
RINT17526 nd6769 nd6800 2.783177502845e+02
RINT17527 nd6770 nd6801 2.783177502845e+02
RINT17528 nd6771 nd6802 2.783177502845e+02
RINT17529 nd6772 nd6803 2.783177502845e+02
RINT17530 nd6773 nd6804 2.783177502845e+02
RINT17531 nd6774 nd6805 5.371885815399e+01
RINT17532 nd6775 nd6806 5.533517256115e+01
RINT17533 nd6776 nd6807 1.270102159742e+03
RINT17534 nd6777 nd6808 9.135281555084e+01
RINT17535 nd6778 nd6809 2.026342478141e+03
RINT17536 nd6779 nd6810 8.443093658921e+00
RINT17537 nd6780 nd6811 8.443093658921e+00
RINT17538 nd6781 nd6812 8.443093658921e+00
RINT17539 nd6782 nd6813 8.443093658921e+00
RINT17540 nd6783 nd6814 8.443093658921e+00
RINT17541 nd6784 nd6815 8.443093658921e+00
RINT17542 nd6785 nd6816 8.443093658921e+00
RINT17543 nd6786 nd6817 8.443093658921e+00
RINT17544 nd6787 nd6818 8.443093658921e+00
RINT17545 nd6788 nd6819 8.443093658921e+00
RINT17546 nd6789 nd6820 7.494898898358e+00
RINT17547 nd6790 nd6821 6.471882044678e+00
RINT17548 nd6791 nd6822 6.471882044678e+00
RINT17549 nd6792 nd6823 3.754897366627e+02
RINT17550 nd6793 nd6824 1.332023338058e+01
RINT17551 nd6794 nd6825 1.341444641988e+01
RINT17552 nd6795 nd6826 1.341444641988e+01
RINT17553 nd6796 nd6827 3.942767563891e+03
RINT17554 nd6797 nd6828 6.216370766103e+02
RINT17555 nd6798 nd6829 1.083955004199e+03
RINT17556 nd6799 nd6830 1.083955004199e+03
RINT17557 nd6800 nd6831 1.083955004199e+03
RINT17558 nd6801 nd6832 1.083955004199e+03
RINT17559 nd6802 nd6833 1.083955004199e+03
RINT17560 nd6803 nd6834 1.083955004199e+03
RINT17561 nd6804 nd6835 1.083955004199e+03
RINT17562 nd6805 nd6836 2.368141244230e+02
RINT17563 nd6806 nd6837 2.376222816266e+02
RINT17564 nd6807 nd6838 7.013767938611e+02
RINT17565 nd6808 nd6839 5.044692223361e+01
RINT17566 nd6809 nd6840 1.118988405525e+03
RINT17567 nd6810 nd6841 4.662451689687e+00
RINT17568 nd6811 nd6842 4.662451689687e+00
RINT17569 nd6812 nd6843 4.662451689687e+00
RINT17570 nd6813 nd6844 4.662451689687e+00
RINT17571 nd6814 nd6845 4.662451689687e+00
RINT17572 nd6815 nd6846 4.662451689687e+00
RINT17573 nd6816 nd6847 4.662451689687e+00
RINT17574 nd6817 nd6848 4.662451689687e+00
RINT17575 nd6818 nd6849 4.662451689687e+00
RINT17576 nd6819 nd6850 4.662451689687e+00
RINT17577 nd6820 nd6851 7.494898898358e+00
RINT17578 nd6821 nd6852 6.471882044678e+00
RINT17579 nd6822 nd6853 6.471882044678e+00
RINT17580 nd6823 nd6854 3.754897366627e+02
RINT17581 nd6824 nd6855 1.332023338058e+01
RINT17582 nd6825 nd6856 1.341444641988e+01
RINT17583 nd6826 nd6857 1.341444641988e+01
RINT17584 nd6827 nd6858 3.942767563891e+03
RINT17585 nd6828 nd6859 6.216370766103e+02
RINT17586 nd6829 nd6860 1.083955004199e+03
RINT17587 nd6830 nd6861 1.083955004199e+03
RINT17588 nd6831 nd6862 1.083955004199e+03
RINT17589 nd6832 nd6863 1.083955004199e+03
RINT17590 nd6833 nd6864 1.083955004199e+03
RINT17591 nd6834 nd6865 1.083955004199e+03
RINT17592 nd6835 nd6866 1.083955004199e+03
RINT17593 nd6836 nd6867 2.368141244230e+02
RINT17594 nd6837 nd6868 2.376222816266e+02
RINT17595 nd6838 nd6869 7.013767938611e+02
RINT17596 nd6839 nd6870 5.044692223361e+01
RINT17597 nd6840 nd6871 1.118988405525e+03
RINT17598 nd6841 nd6872 4.662451689687e+00
RINT17599 nd6842 nd6873 4.662451689687e+00
RINT17600 nd6843 nd6874 4.662451689687e+00
RINT17601 nd6844 nd6875 4.662451689687e+00
RINT17602 nd6845 nd6876 4.662451689687e+00
RINT17603 nd6846 nd6877 4.662451689687e+00
RINT17604 nd6847 nd6878 4.662451689687e+00
RINT17605 nd6848 nd6879 4.662451689687e+00
RINT17606 nd6849 nd6880 4.662451689687e+00
RINT17607 nd6850 nd6881 4.662451689687e+00
RINT17608 nd6851 nd6882 1.357228719451e+01
RINT17609 nd6852 nd6883 1.171973671568e+01
RINT17610 nd6853 nd6884 1.171973671568e+01
RINT17611 nd6854 nd6885 6.799630807155e+02
RINT17612 nd6855 nd6886 2.412121035800e+01
RINT17613 nd6856 nd6887 2.429181791977e+01
RINT17614 nd6857 nd6888 2.429181791977e+01
RINT17615 nd6858 nd6889 1.271962224384e+03
RINT17616 nd6859 nd6890 1.410120026542e+02
RINT17617 nd6860 nd6891 2.783177502845e+02
RINT17618 nd6861 nd6892 2.783177502845e+02
RINT17619 nd6862 nd6893 2.783177502845e+02
RINT17620 nd6863 nd6894 2.783177502845e+02
RINT17621 nd6864 nd6895 2.783177502845e+02
RINT17622 nd6865 nd6896 2.783177502845e+02
RINT17623 nd6866 nd6897 2.783177502845e+02
RINT17624 nd6867 nd6898 5.371885815399e+01
RINT17625 nd6868 nd6899 5.533517256115e+01
RINT17626 nd6869 nd6900 1.270102159742e+03
RINT17627 nd6870 nd6901 9.135281555084e+01
RINT17628 nd6871 nd6902 2.026342478141e+03
RINT17629 nd6872 nd6903 8.443093658921e+00
RINT17630 nd6873 nd6904 8.443093658921e+00
RINT17631 nd6874 nd6905 8.443093658921e+00
RINT17632 nd6875 nd6906 8.443093658921e+00
RINT17633 nd6876 nd6907 8.443093658921e+00
RINT17634 nd6877 nd6908 8.443093658921e+00
RINT17635 nd6878 nd6909 8.443093658921e+00
RINT17636 nd6879 nd6910 8.443093658921e+00
RINT17637 nd6880 nd6911 8.443093658921e+00
RINT17638 nd6881 nd6912 8.443093658921e+00
RINT17639 nd6882 nd6913 1.357228719451e+01
RINT17640 nd6883 nd6914 1.171973671568e+01
RINT17641 nd6884 nd6915 1.171973671568e+01
RINT17642 nd6885 nd6916 6.799630807155e+02
RINT17643 nd6886 nd6917 2.412121035800e+01
RINT17644 nd6887 nd6918 2.429181791977e+01
RINT17645 nd6888 nd6919 2.429181791977e+01
RINT17646 nd6889 nd6920 1.271962224384e+03
RINT17647 nd6890 nd6921 1.410120026542e+02
RINT17648 nd6891 nd6922 2.783177502845e+02
RINT17649 nd6892 nd6923 2.783177502845e+02
RINT17650 nd6893 nd6924 2.783177502845e+02
RINT17651 nd6894 nd6925 2.783177502845e+02
RINT17652 nd6895 nd6926 2.783177502845e+02
RINT17653 nd6896 nd6927 2.783177502845e+02
RINT17654 nd6897 nd6928 2.783177502845e+02
RINT17655 nd6898 nd6929 5.371885815399e+01
RINT17656 nd6899 nd6930 5.533517256115e+01
RINT17657 nd6900 nd6931 1.270102159742e+03
RINT17658 nd6901 nd6932 9.135281555084e+01
RINT17659 nd6902 nd6933 2.026342478141e+03
RINT17660 nd6903 nd6934 8.443093658921e+00
RINT17661 nd6904 nd6935 8.443093658921e+00
RINT17662 nd6905 nd6936 8.443093658921e+00
RINT17663 nd6906 nd6937 8.443093658921e+00
RINT17664 nd6907 nd6938 8.443093658921e+00
RINT17665 nd6908 nd6939 8.443093658921e+00
RINT17666 nd6909 nd6940 8.443093658921e+00
RINT17667 nd6910 nd6941 8.443093658921e+00
RINT17668 nd6911 nd6942 8.443093658921e+00
RINT17669 nd6912 nd6943 8.443093658921e+00
RINT17670 nd6913 nd6944 1.357228719451e+01
RINT17671 nd6914 nd6945 1.171973671568e+01
RINT17672 nd6915 nd6946 1.171973671568e+01
RINT17673 nd6916 nd6947 6.799630807155e+02
RINT17674 nd6917 nd6948 2.412121035800e+01
RINT17675 nd6918 nd6949 2.429181791977e+01
RINT17676 nd6919 nd6950 2.429181791977e+01
RINT17677 nd6920 nd6951 1.271962224384e+03
RINT17678 nd6921 nd6952 1.410120026542e+02
RINT17679 nd6922 nd6953 2.783177502845e+02
RINT17680 nd6923 nd6954 2.783177502845e+02
RINT17681 nd6924 nd6955 2.783177502845e+02
RINT17682 nd6925 nd6956 2.783177502845e+02
RINT17683 nd6926 nd6957 2.783177502845e+02
RINT17684 nd6927 nd6958 2.783177502845e+02
RINT17685 nd6928 nd6959 2.783177502845e+02
RINT17686 nd6929 nd6960 5.371885815399e+01
RINT17687 nd6930 nd6961 5.533517256115e+01
RINT17688 nd6931 nd6962 1.270102159742e+03
RINT17689 nd6932 nd6963 9.135281555084e+01
RINT17690 nd6933 nd6964 2.026342478141e+03
RINT17691 nd6934 nd6965 8.443093658921e+00
RINT17692 nd6935 nd6966 8.443093658921e+00
RINT17693 nd6936 nd6967 8.443093658921e+00
RINT17694 nd6937 nd6968 8.443093658921e+00
RINT17695 nd6938 nd6969 8.443093658921e+00
RINT17696 nd6939 nd6970 8.443093658921e+00
RINT17697 nd6940 nd6971 8.443093658921e+00
RINT17698 nd6941 nd6972 8.443093658921e+00
RINT17699 nd6942 nd6973 8.443093658921e+00
RINT17700 nd6943 nd6974 8.443093658921e+00
RINT17701 nd6944 nd6975 1.357228719451e+01
RINT17702 nd6945 nd6976 1.171973671568e+01
RINT17703 nd6946 nd6977 1.171973671568e+01
RINT17704 nd6947 nd6978 6.799630807155e+02
RINT17705 nd6948 nd6979 2.412121035800e+01
RINT17706 nd6949 nd6980 2.429181791977e+01
RINT17707 nd6950 nd6981 2.429181791977e+01
RINT17708 nd6951 nd6982 1.271962224384e+03
RINT17709 nd6952 nd6983 1.410120026542e+02
RINT17710 nd6953 nd6984 2.783177502845e+02
RINT17711 nd6954 nd6985 2.783177502845e+02
RINT17712 nd6955 nd6986 2.783177502845e+02
RINT17713 nd6956 nd6987 2.783177502845e+02
RINT17714 nd6957 nd6988 2.783177502845e+02
RINT17715 nd6958 nd6989 2.783177502845e+02
RINT17716 nd6959 nd6990 2.783177502845e+02
RINT17717 nd6960 nd6991 5.371885815399e+01
RINT17718 nd6961 nd6992 5.533517256115e+01
RINT17719 nd6962 nd6993 1.270102159742e+03
RINT17720 nd6963 nd6994 9.135281555084e+01
RINT17721 nd6964 nd6995 2.026342478141e+03
RINT17722 nd6965 nd6996 8.443093658921e+00
RINT17723 nd6966 nd6997 8.443093658921e+00
RINT17724 nd6967 nd6998 8.443093658921e+00
RINT17725 nd6968 nd6999 8.443093658921e+00
RINT17726 nd6969 nd7000 8.443093658921e+00
RINT17727 nd6970 nd7001 8.443093658921e+00
RINT17728 nd6971 nd7002 8.443093658921e+00
RINT17729 nd6972 nd7003 8.443093658921e+00
RINT17730 nd6973 nd7004 8.443093658921e+00
RINT17731 nd6974 nd7005 8.443093658921e+00
RINT17732 nd6975 nd7006 1.357228719451e+01
RINT17733 nd6976 nd7007 1.171973671568e+01
RINT17734 nd6977 nd7008 1.171973671568e+01
RINT17735 nd6978 nd7009 6.799630807155e+02
RINT17736 nd6979 nd7010 2.412121035800e+01
RINT17737 nd6980 nd7011 2.429181791977e+01
RINT17738 nd6981 nd7012 2.429181791977e+01
RINT17739 nd6982 nd7013 1.271962224384e+03
RINT17740 nd6983 nd7014 1.410120026542e+02
RINT17741 nd6984 nd7015 2.783177502845e+02
RINT17742 nd6985 nd7016 2.783177502845e+02
RINT17743 nd6986 nd7017 2.783177502845e+02
RINT17744 nd6987 nd7018 2.783177502845e+02
RINT17745 nd6988 nd7019 2.783177502845e+02
RINT17746 nd6989 nd7020 2.783177502845e+02
RINT17747 nd6990 nd7021 2.783177502845e+02
RINT17748 nd6991 nd7022 5.371885815399e+01
RINT17749 nd6992 nd7023 5.533517256115e+01
RINT17750 nd6993 nd7024 1.270102159742e+03
RINT17751 nd6994 nd7025 9.135281555084e+01
RINT17752 nd6995 nd7026 2.026342478141e+03
RINT17753 nd6996 nd7027 8.443093658921e+00
RINT17754 nd6997 nd7028 8.443093658921e+00
RINT17755 nd6998 nd7029 8.443093658921e+00
RINT17756 nd6999 nd7030 8.443093658921e+00
RINT17757 nd7000 nd7031 8.443093658921e+00
RINT17758 nd7001 nd7032 8.443093658921e+00
RINT17759 nd7002 nd7033 8.443093658921e+00
RINT17760 nd7003 nd7034 8.443093658921e+00
RINT17761 nd7004 nd7035 8.443093658921e+00
RINT17762 nd7005 nd7036 8.443093658921e+00
RINT17763 nd7006 nd7037 7.494898898358e+00
RINT17764 nd7007 nd7038 6.471882044678e+00
RINT17765 nd7008 nd7039 6.471882044678e+00
RINT17766 nd7009 nd7040 3.754897366627e+02
RINT17767 nd7010 nd7041 1.332023338058e+01
RINT17768 nd7011 nd7042 1.341444641988e+01
RINT17769 nd7012 nd7043 1.341444641988e+01
RINT17770 nd7013 nd7044 3.942767563891e+03
RINT17771 nd7014 nd7045 6.216370766103e+02
RINT17772 nd7015 nd7046 1.083955004199e+03
RINT17773 nd7016 nd7047 1.083955004199e+03
RINT17774 nd7017 nd7048 1.083955004199e+03
RINT17775 nd7018 nd7049 1.083955004199e+03
RINT17776 nd7019 nd7050 1.083955004199e+03
RINT17777 nd7020 nd7051 1.083955004199e+03
RINT17778 nd7021 nd7052 1.083955004199e+03
RINT17779 nd7022 nd7053 2.368141244230e+02
RINT17780 nd7023 nd7054 2.376222816266e+02
RINT17781 nd7024 nd7055 7.013767938611e+02
RINT17782 nd7025 nd7056 5.044692223361e+01
RINT17783 nd7026 nd7057 1.118988405525e+03
RINT17784 nd7027 nd7058 4.662451689687e+00
RINT17785 nd7028 nd7059 4.662451689687e+00
RINT17786 nd7029 nd7060 4.662451689687e+00
RINT17787 nd7030 nd7061 4.662451689687e+00
RINT17788 nd7031 nd7062 4.662451689687e+00
RINT17789 nd7032 nd7063 4.662451689687e+00
RINT17790 nd7033 nd7064 4.662451689687e+00
RINT17791 nd7034 nd7065 4.662451689687e+00
RINT17792 nd7035 nd7066 4.662451689687e+00
RINT17793 nd7036 nd7067 4.662451689687e+00
RINT17794 nd7037 nd7068 5.918933645378e+00
RINT17795 nd7038 nd7069 5.111028301069e+00
RINT17796 nd7039 nd7070 5.111028301069e+00
RINT17797 nd7040 nd7071 2.965348653754e+02
RINT17798 nd7041 nd7072 1.051936504946e+01
RINT17799 nd7042 nd7073 1.059376775131e+01
RINT17800 nd7043 nd7074 1.059376775131e+01
RINT17801 nd7044 nd7075 3.677205321604e+03
RINT17802 nd7045 nd7076 6.128675536007e+02
RINT17803 nd7046 nd7077 1.050630091887e+03
RINT17804 nd7047 nd7078 1.050630091887e+03
RINT17805 nd7048 nd7079 1.050630091887e+03
RINT17806 nd7049 nd7080 1.050630091887e+03
RINT17807 nd7050 nd7081 1.050630091887e+03
RINT17808 nd7051 nd7082 1.050630091887e+03
RINT17809 nd7052 nd7083 1.050630091887e+03
RINT17810 nd7053 nd7084 2.334733537526e+02
RINT17811 nd7054 nd7085 2.334733537526e+02
RINT17812 nd7055 nd7086 5.538970918181e+02
RINT17813 nd7056 nd7087 3.983936132610e+01
RINT17814 nd7057 nd7088 8.836967932549e+02
RINT17815 nd7058 nd7089 3.682069971895e+00
RINT17816 nd7059 nd7090 3.682069971895e+00
RINT17817 nd7060 nd7091 3.682069971895e+00
RINT17818 nd7061 nd7092 3.682069971895e+00
RINT17819 nd7062 nd7093 3.682069971895e+00
RINT17820 nd7063 nd7094 3.682069971895e+00
RINT17821 nd7064 nd7095 3.682069971895e+00
RINT17822 nd7065 nd7096 3.682069971895e+00
RINT17823 nd7066 nd7097 3.682069971895e+00
RINT17824 nd7067 nd7098 3.682069971895e+00
RINT17825 nd7068 nd7099 1.042035668855e+01
RINT17826 nd7069 nd7100 8.998029228461e+00
RINT17827 nd7070 nd7101 8.998029228461e+00
RINT17828 nd7071 nd7102 5.220533381408e+02
RINT17829 nd7072 nd7103 1.851947369575e+01
RINT17830 nd7073 nd7104 1.865046058263e+01
RINT17831 nd7074 nd7105 1.865046058263e+01
RINT17832 nd7075 nd7106 7.408377398100e+02
RINT17833 nd7076 nd7107 1.234729566350e+02
RINT17834 nd7077 nd7108 2.116679256600e+02
RINT17835 nd7078 nd7109 2.116679256600e+02
RINT17836 nd7079 nd7110 2.116679256600e+02
RINT17837 nd7080 nd7111 2.116679256600e+02
RINT17838 nd7081 nd7112 2.116679256600e+02
RINT17839 nd7082 nd7113 2.116679256600e+02
RINT17840 nd7083 nd7114 2.116679256600e+02
RINT17841 nd7084 nd7115 4.703731681333e+01
RINT17842 nd7085 nd7116 4.703731681333e+01
RINT17843 nd7086 nd7117 9.751427556557e+02
RINT17844 nd7087 nd7118 7.013769373582e+01
RINT17845 nd7088 nd7119 1.555759253601e+03
RINT17846 nd7089 nd7120 6.482330223337e+00
RINT17847 nd7090 nd7121 6.482330223337e+00
RINT17848 nd7091 nd7122 6.482330223337e+00
RINT17849 nd7092 nd7123 6.482330223337e+00
RINT17850 nd7093 nd7124 6.482330223337e+00
RINT17851 nd7094 nd7125 6.482330223337e+00
RINT17852 nd7095 nd7126 6.482330223337e+00
RINT17853 nd7096 nd7127 6.482330223337e+00
RINT17854 nd7097 nd7128 6.482330223337e+00
RINT17855 nd7098 nd7129 6.482330223337e+00
RINT17856 nd7099 nd7130 1.042035668855e+01
RINT17857 nd7100 nd7131 8.998029228461e+00
RINT17858 nd7101 nd7132 8.998029228461e+00
RINT17859 nd7102 nd7133 5.220533381408e+02
RINT17860 nd7103 nd7134 1.851947369575e+01
RINT17861 nd7104 nd7135 1.865046058263e+01
RINT17862 nd7105 nd7136 1.865046058263e+01
RINT17863 nd7106 nd7137 7.408377398100e+02
RINT17864 nd7107 nd7138 1.234729566350e+02
RINT17865 nd7108 nd7139 2.116679256600e+02
RINT17866 nd7109 nd7140 2.116679256600e+02
RINT17867 nd7110 nd7141 2.116679256600e+02
RINT17868 nd7111 nd7142 2.116679256600e+02
RINT17869 nd7112 nd7143 2.116679256600e+02
RINT17870 nd7113 nd7144 2.116679256600e+02
RINT17871 nd7114 nd7145 2.116679256600e+02
RINT17872 nd7115 nd7146 4.703731681333e+01
RINT17873 nd7116 nd7147 4.703731681333e+01
RINT17874 nd7117 nd7148 9.751427556557e+02
RINT17875 nd7118 nd7149 7.013769373582e+01
RINT17876 nd7119 nd7150 1.555759253601e+03
RINT17877 nd7120 nd7151 6.482330223337e+00
RINT17878 nd7121 nd7152 6.482330223337e+00
RINT17879 nd7122 nd7153 6.482330223337e+00
RINT17880 nd7123 nd7154 6.482330223337e+00
RINT17881 nd7124 nd7155 6.482330223337e+00
RINT17882 nd7125 nd7156 6.482330223337e+00
RINT17883 nd7126 nd7157 6.482330223337e+00
RINT17884 nd7127 nd7158 6.482330223337e+00
RINT17885 nd7128 nd7159 6.482330223337e+00
RINT17886 nd7129 nd7160 6.482330223337e+00
RINT17887 nd7161 nd7192 9.847510605046e+01
RINT17888 nd7162 nd7193 8.503373819163e+01
RINT17889 nd7163 nd7194 8.503373819163e+01
RINT17890 nd7164 nd7195 4.933541084432e+03
RINT17891 nd7165 nd7196 1.750138877867e+02
RINT17892 nd7166 nd7197 1.762517482517e+02
RINT17893 nd7167 nd7198 1.762517482517e+02
RINT17894 nd7168 nd7199 7.001111111111e+03
RINT17895 nd7169 nd7200 1.166851851852e+03
RINT17896 nd7170 nd7201 2.000317460317e+03
RINT17897 nd7171 nd7202 2.000317460317e+03
RINT17898 nd7172 nd7203 2.000317460317e+03
RINT17899 nd7173 nd7204 2.000317460317e+03
RINT17900 nd7174 nd7205 2.000317460317e+03
RINT17901 nd7175 nd7206 2.000317460317e+03
RINT17902 nd7176 nd7207 2.000317460317e+03
RINT17903 nd7177 nd7208 4.445149911817e+02
RINT17904 nd7178 nd7209 4.445149911817e+02
RINT17905 nd7179 nd7210 9.215355015920e+03
RINT17906 nd7180 nd7211 6.628196169481e+02
RINT17907 nd7181 nd7212 1.470233333333e+04
RINT17908 nd7182 nd7213 6.125972222222e+01
RINT17909 nd7183 nd7214 6.125972222222e+01
RINT17910 nd7184 nd7215 6.125972222222e+01
RINT17911 nd7185 nd7216 6.125972222222e+01
RINT17912 nd7186 nd7217 6.125972222222e+01
RINT17913 nd7187 nd7218 6.125972222222e+01
RINT17914 nd7188 nd7219 6.125972222222e+01
RINT17915 nd7189 nd7220 6.125972222222e+01
RINT17916 nd7190 nd7221 6.125972222222e+01
RINT17917 nd7191 nd7222 6.125972222222e+01
RINT17918 nd7192 nd7223 9.847510605046e+01
RINT17919 nd7193 nd7224 8.503373819163e+01
RINT17920 nd7194 nd7225 8.503373819163e+01
RINT17921 nd7195 nd7226 4.933541084432e+03
RINT17922 nd7196 nd7227 1.750138877867e+02
RINT17923 nd7197 nd7228 1.762517482517e+02
RINT17924 nd7198 nd7229 1.762517482517e+02
RINT17925 nd7199 nd7230 7.001111111111e+03
RINT17926 nd7200 nd7231 1.166851851852e+03
RINT17927 nd7201 nd7232 2.000317460317e+03
RINT17928 nd7202 nd7233 2.000317460317e+03
RINT17929 nd7203 nd7234 2.000317460317e+03
RINT17930 nd7204 nd7235 2.000317460317e+03
RINT17931 nd7205 nd7236 2.000317460317e+03
RINT17932 nd7206 nd7237 2.000317460317e+03
RINT17933 nd7207 nd7238 2.000317460317e+03
RINT17934 nd7208 nd7239 4.445149911817e+02
RINT17935 nd7209 nd7240 4.445149911817e+02
RINT17936 nd7210 nd7241 9.215355015920e+03
RINT17937 nd7211 nd7242 6.628196169481e+02
RINT17938 nd7212 nd7243 1.470233333333e+04
RINT17939 nd7213 nd7244 6.125972222222e+01
RINT17940 nd7214 nd7245 6.125972222222e+01
RINT17941 nd7215 nd7246 6.125972222222e+01
RINT17942 nd7216 nd7247 6.125972222222e+01
RINT17943 nd7217 nd7248 6.125972222222e+01
RINT17944 nd7218 nd7249 6.125972222222e+01
RINT17945 nd7219 nd7250 6.125972222222e+01
RINT17946 nd7220 nd7251 6.125972222222e+01
RINT17947 nd7221 nd7252 6.125972222222e+01
RINT17948 nd7222 nd7253 6.125972222222e+01
RINT17949 nd7223 nd7254 5.593547666890e+01
RINT17950 nd7224 nd7255 4.830055909003e+01
RINT17951 nd7225 nd7256 4.830055909003e+01
RINT17952 nd7226 nd7257 2.802332318199e+03
RINT17953 nd7227 nd7258 9.941076105071e+01
RINT17954 nd7228 nd7259 1.001138861139e+02
RINT17955 nd7229 nd7260 1.001138861139e+02
RINT17956 nd7230 nd7261 3.475055555556e+04
RINT17957 nd7231 nd7262 5.791759259259e+03
RINT17958 nd7232 nd7263 9.928730158730e+03
RINT17959 nd7233 nd7264 9.928730158730e+03
RINT17960 nd7234 nd7265 9.928730158730e+03
RINT17961 nd7235 nd7266 9.928730158730e+03
RINT17962 nd7236 nd7267 9.928730158730e+03
RINT17963 nd7237 nd7268 9.928730158730e+03
RINT17964 nd7238 nd7269 9.928730158730e+03
RINT17965 nd7239 nd7270 2.206384479718e+03
RINT17966 nd7240 nd7271 2.206384479718e+03
RINT17967 nd7241 nd7272 5.234472915668e+03
RINT17968 nd7242 nd7273 3.764924223640e+02
RINT17969 nd7243 nd7274 8.351166666667e+03
RINT17970 nd7244 nd7275 3.479652777778e+01
RINT17971 nd7245 nd7276 3.479652777778e+01
RINT17972 nd7246 nd7277 3.479652777778e+01
RINT17973 nd7247 nd7278 3.479652777778e+01
RINT17974 nd7248 nd7279 3.479652777778e+01
RINT17975 nd7249 nd7280 3.479652777778e+01
RINT17976 nd7250 nd7281 3.479652777778e+01
RINT17977 nd7251 nd7282 3.479652777778e+01
RINT17978 nd7252 nd7283 3.479652777778e+01
RINT17979 nd7253 nd7284 3.479652777778e+01
RINT17980 nd7254 nd7285 7.082876200045e+01
RINT17981 nd7255 nd7286 6.116098419125e+01
RINT17982 nd7256 nd7287 6.116098419125e+01
RINT17983 nd7257 nd7288 3.548476577518e+03
RINT17984 nd7258 nd7289 1.258797020078e+02
RINT17985 nd7259 nd7290 1.267700399600e+02
RINT17986 nd7260 nd7291 1.267700399600e+02
RINT17987 nd7261 nd7292 3.304604427083e+05
RINT17988 nd7262 nd7293 5.507674045139e+04
RINT17989 nd7263 nd7294 9.441726934524e+04
RINT17990 nd7264 nd7295 9.441726934524e+04
RINT17991 nd7265 nd7296 9.441726934524e+04
RINT17992 nd7266 nd7297 9.441726934524e+04
RINT17993 nd7267 nd7298 9.441726934524e+04
RINT17994 nd7268 nd7299 9.441726934524e+04
RINT17995 nd7269 nd7300 9.441726934524e+04
RINT17996 nd7270 nd7301 2.098161541005e+04
RINT17997 nd7271 nd7302 2.098161541005e+04
RINT17998 nd7272 nd7303 6.628194813396e+03
RINT17999 nd7273 nd7304 4.767366574247e+02
RINT18000 nd7274 nd7305 1.057473416667e+04
RINT18001 nd7275 nd7306 4.406139236111e+01
RINT18002 nd7276 nd7307 4.406139236111e+01
RINT18003 nd7277 nd7308 4.406139236111e+01
RINT18004 nd7278 nd7309 4.406139236111e+01
RINT18005 nd7279 nd7310 4.406139236111e+01
RINT18006 nd7280 nd7311 4.406139236111e+01
RINT18007 nd7281 nd7312 4.406139236111e+01
RINT18008 nd7282 nd7313 4.406139236111e+01
RINT18009 nd7283 nd7314 4.406139236111e+01
RINT18010 nd7284 nd7315 4.406139236111e+01
RINT18011 nd7285 nd7316 1.282616767136e+02
RINT18012 nd7286 nd7317 1.107545883941e+02
RINT18013 nd7287 nd7318 1.107545883941e+02
RINT18014 nd7288 nd7319 6.425829603070e+03
RINT18015 nd7289 nd7320 2.279517697008e+02
RINT18016 nd7290 nd7321 2.295640559441e+02
RINT18017 nd7291 nd7322 2.295640559441e+02
RINT18018 nd7292 nd7323 5.984208854167e+05
RINT18019 nd7293 nd7324 9.973681423611e+04
RINT18020 nd7294 nd7325 1.709773958333e+05
RINT18021 nd7295 nd7326 1.709773958333e+05
RINT18022 nd7296 nd7327 1.709773958333e+05
RINT18023 nd7297 nd7328 1.709773958333e+05
RINT18024 nd7298 nd7329 1.709773958333e+05
RINT18025 nd7299 nd7330 1.709773958333e+05
RINT18026 nd7300 nd7331 1.709773958333e+05
RINT18027 nd7301 nd7332 3.799497685185e+04
RINT18028 nd7302 nd7333 3.799497685185e+04
RINT18029 nd7303 nd7334 1.200279881138e+04
RINT18030 nd7304 nd7335 8.633080870696e+02
RINT18031 nd7305 nd7336 1.914946833333e+04
RINT18032 nd7306 nd7337 7.978945138889e+01
RINT18033 nd7307 nd7338 7.978945138889e+01
RINT18034 nd7308 nd7339 7.978945138889e+01
RINT18035 nd7309 nd7340 7.978945138889e+01
RINT18036 nd7310 nd7341 7.978945138889e+01
RINT18037 nd7311 nd7342 7.978945138889e+01
RINT18038 nd7312 nd7343 7.978945138889e+01
RINT18039 nd7313 nd7344 7.978945138889e+01
RINT18040 nd7314 nd7345 7.978945138889e+01
RINT18041 nd7315 nd7346 7.978945138889e+01
RINT18042 nd7316 nd7347 1.282616767136e+02
RINT18043 nd7317 nd7348 1.107545883941e+02
RINT18044 nd7318 nd7349 1.107545883941e+02
RINT18045 nd7319 nd7350 6.425829603070e+03
RINT18046 nd7320 nd7351 2.279517697008e+02
RINT18047 nd7321 nd7352 2.295640559441e+02
RINT18048 nd7322 nd7353 2.295640559441e+02
RINT18049 nd7323 nd7354 5.984208854167e+05
RINT18050 nd7324 nd7355 9.973681423611e+04
RINT18051 nd7325 nd7356 1.709773958333e+05
RINT18052 nd7326 nd7357 1.709773958333e+05
RINT18053 nd7327 nd7358 1.709773958333e+05
RINT18054 nd7328 nd7359 1.709773958333e+05
RINT18055 nd7329 nd7360 1.709773958333e+05
RINT18056 nd7330 nd7361 1.709773958333e+05
RINT18057 nd7331 nd7362 1.709773958333e+05
RINT18058 nd7332 nd7363 3.799497685185e+04
RINT18059 nd7333 nd7364 3.799497685185e+04
RINT18060 nd7334 nd7365 1.200279881138e+04
RINT18061 nd7335 nd7366 8.633080870696e+02
RINT18062 nd7336 nd7367 1.914946833333e+04
RINT18063 nd7337 nd7368 7.978945138889e+01
RINT18064 nd7338 nd7369 7.978945138889e+01
RINT18065 nd7339 nd7370 7.978945138889e+01
RINT18066 nd7340 nd7371 7.978945138889e+01
RINT18067 nd7341 nd7372 7.978945138889e+01
RINT18068 nd7342 nd7373 7.978945138889e+01
RINT18069 nd7343 nd7374 7.978945138889e+01
RINT18070 nd7344 nd7375 7.978945138889e+01
RINT18071 nd7345 nd7376 7.978945138889e+01
RINT18072 nd7346 nd7377 7.978945138889e+01
RINT18073 nd7347 nd7378 1.282616767136e+02
RINT18074 nd7348 nd7379 1.107545883941e+02
RINT18075 nd7349 nd7380 1.107545883941e+02
RINT18076 nd7350 nd7381 6.425829603070e+03
RINT18077 nd7351 nd7382 2.279517697008e+02
RINT18078 nd7352 nd7383 2.295640559441e+02
RINT18079 nd7353 nd7384 2.295640559441e+02
RINT18080 nd7354 nd7385 5.984208854167e+05
RINT18081 nd7355 nd7386 9.973681423611e+04
RINT18082 nd7356 nd7387 1.709773958333e+05
RINT18083 nd7357 nd7388 1.709773958333e+05
RINT18084 nd7358 nd7389 1.709773958333e+05
RINT18085 nd7359 nd7390 1.709773958333e+05
RINT18086 nd7360 nd7391 1.709773958333e+05
RINT18087 nd7361 nd7392 1.709773958333e+05
RINT18088 nd7362 nd7393 1.709773958333e+05
RINT18089 nd7363 nd7394 3.799497685185e+04
RINT18090 nd7364 nd7395 3.799497685185e+04
RINT18091 nd7365 nd7396 1.200279881138e+04
RINT18092 nd7366 nd7397 8.633080870696e+02
RINT18093 nd7367 nd7398 1.914946833333e+04
RINT18094 nd7368 nd7399 7.978945138889e+01
RINT18095 nd7369 nd7400 7.978945138889e+01
RINT18096 nd7370 nd7401 7.978945138889e+01
RINT18097 nd7371 nd7402 7.978945138889e+01
RINT18098 nd7372 nd7403 7.978945138889e+01
RINT18099 nd7373 nd7404 7.978945138889e+01
RINT18100 nd7374 nd7405 7.978945138889e+01
RINT18101 nd7375 nd7406 7.978945138889e+01
RINT18102 nd7376 nd7407 7.978945138889e+01
RINT18103 nd7377 nd7408 7.978945138889e+01
RINT18104 nd7378 nd7409 1.282616767136e+02
RINT18105 nd7379 nd7410 1.107545883941e+02
RINT18106 nd7380 nd7411 1.107545883941e+02
RINT18107 nd7381 nd7412 6.425829603070e+03
RINT18108 nd7382 nd7413 2.279517697008e+02
RINT18109 nd7383 nd7414 2.295640559441e+02
RINT18110 nd7384 nd7415 2.295640559441e+02
RINT18111 nd7385 nd7416 5.984208854167e+05
RINT18112 nd7386 nd7417 9.973681423611e+04
RINT18113 nd7387 nd7418 1.709773958333e+05
RINT18114 nd7388 nd7419 1.709773958333e+05
RINT18115 nd7389 nd7420 1.709773958333e+05
RINT18116 nd7390 nd7421 1.709773958333e+05
RINT18117 nd7391 nd7422 1.709773958333e+05
RINT18118 nd7392 nd7423 1.709773958333e+05
RINT18119 nd7393 nd7424 1.709773958333e+05
RINT18120 nd7394 nd7425 3.799497685185e+04
RINT18121 nd7395 nd7426 3.799497685185e+04
RINT18122 nd7396 nd7427 1.200279881138e+04
RINT18123 nd7397 nd7428 8.633080870696e+02
RINT18124 nd7398 nd7429 1.914946833333e+04
RINT18125 nd7399 nd7430 7.978945138889e+01
RINT18126 nd7400 nd7431 7.978945138889e+01
RINT18127 nd7401 nd7432 7.978945138889e+01
RINT18128 nd7402 nd7433 7.978945138889e+01
RINT18129 nd7403 nd7434 7.978945138889e+01
RINT18130 nd7404 nd7435 7.978945138889e+01
RINT18131 nd7405 nd7436 7.978945138889e+01
RINT18132 nd7406 nd7437 7.978945138889e+01
RINT18133 nd7407 nd7438 7.978945138889e+01
RINT18134 nd7408 nd7439 7.978945138889e+01
RINT18135 nd7409 nd7440 1.282616767136e+02
RINT18136 nd7410 nd7441 1.107545883941e+02
RINT18137 nd7411 nd7442 1.107545883941e+02
RINT18138 nd7412 nd7443 6.425829603070e+03
RINT18139 nd7413 nd7444 2.279517697008e+02
RINT18140 nd7414 nd7445 2.295640559441e+02
RINT18141 nd7415 nd7446 2.295640559441e+02
RINT18142 nd7416 nd7447 5.984208854167e+05
RINT18143 nd7417 nd7448 9.973681423611e+04
RINT18144 nd7418 nd7449 1.709773958333e+05
RINT18145 nd7419 nd7450 1.709773958333e+05
RINT18146 nd7420 nd7451 1.709773958333e+05
RINT18147 nd7421 nd7452 1.709773958333e+05
RINT18148 nd7422 nd7453 1.709773958333e+05
RINT18149 nd7423 nd7454 1.709773958333e+05
RINT18150 nd7424 nd7455 1.709773958333e+05
RINT18151 nd7425 nd7456 3.799497685185e+04
RINT18152 nd7426 nd7457 3.799497685185e+04
RINT18153 nd7427 nd7458 1.200279881138e+04
RINT18154 nd7428 nd7459 8.633080870696e+02
RINT18155 nd7429 nd7460 1.914946833333e+04
RINT18156 nd7430 nd7461 7.978945138889e+01
RINT18157 nd7431 nd7462 7.978945138889e+01
RINT18158 nd7432 nd7463 7.978945138889e+01
RINT18159 nd7433 nd7464 7.978945138889e+01
RINT18160 nd7434 nd7465 7.978945138889e+01
RINT18161 nd7435 nd7466 7.978945138889e+01
RINT18162 nd7436 nd7467 7.978945138889e+01
RINT18163 nd7437 nd7468 7.978945138889e+01
RINT18164 nd7438 nd7469 7.978945138889e+01
RINT18165 nd7439 nd7470 7.978945138889e+01
RINT18166 nd7440 nd7471 7.082876200045e+01
RINT18167 nd7441 nd7472 6.116098419125e+01
RINT18168 nd7442 nd7473 6.116098419125e+01
RINT18169 nd7443 nd7474 3.548476577518e+03
RINT18170 nd7444 nd7475 1.258797020078e+02
RINT18171 nd7445 nd7476 1.267700399600e+02
RINT18172 nd7446 nd7477 1.267700399600e+02
RINT18173 nd7447 nd7478 3.304604427083e+05
RINT18174 nd7448 nd7479 5.507674045139e+04
RINT18175 nd7449 nd7480 9.441726934524e+04
RINT18176 nd7450 nd7481 9.441726934524e+04
RINT18177 nd7451 nd7482 9.441726934524e+04
RINT18178 nd7452 nd7483 9.441726934524e+04
RINT18179 nd7453 nd7484 9.441726934524e+04
RINT18180 nd7454 nd7485 9.441726934524e+04
RINT18181 nd7455 nd7486 9.441726934524e+04
RINT18182 nd7456 nd7487 2.098161541005e+04
RINT18183 nd7457 nd7488 2.098161541005e+04
RINT18184 nd7458 nd7489 6.628194813396e+03
RINT18185 nd7459 nd7490 4.767366574247e+02
RINT18186 nd7460 nd7491 1.057473416667e+04
RINT18187 nd7461 nd7492 4.406139236111e+01
RINT18188 nd7462 nd7493 4.406139236111e+01
RINT18189 nd7463 nd7494 4.406139236111e+01
RINT18190 nd7464 nd7495 4.406139236111e+01
RINT18191 nd7465 nd7496 4.406139236111e+01
RINT18192 nd7466 nd7497 4.406139236111e+01
RINT18193 nd7467 nd7498 4.406139236111e+01
RINT18194 nd7468 nd7499 4.406139236111e+01
RINT18195 nd7469 nd7500 4.406139236111e+01
RINT18196 nd7470 nd7501 4.406139236111e+01
RINT18197 nd7471 nd7502 7.082876200045e+01
RINT18198 nd7472 nd7503 6.116098419125e+01
RINT18199 nd7473 nd7504 6.116098419125e+01
RINT18200 nd7474 nd7505 3.548476577518e+03
RINT18201 nd7475 nd7506 1.258797020078e+02
RINT18202 nd7476 nd7507 1.267700399600e+02
RINT18203 nd7477 nd7508 1.267700399600e+02
RINT18204 nd7478 nd7509 3.304604427083e+05
RINT18205 nd7479 nd7510 5.507674045139e+04
RINT18206 nd7480 nd7511 9.441726934524e+04
RINT18207 nd7481 nd7512 9.441726934524e+04
RINT18208 nd7482 nd7513 9.441726934524e+04
RINT18209 nd7483 nd7514 9.441726934524e+04
RINT18210 nd7484 nd7515 9.441726934524e+04
RINT18211 nd7485 nd7516 9.441726934524e+04
RINT18212 nd7486 nd7517 9.441726934524e+04
RINT18213 nd7487 nd7518 2.098161541005e+04
RINT18214 nd7488 nd7519 2.098161541005e+04
RINT18215 nd7489 nd7520 6.628194813396e+03
RINT18216 nd7490 nd7521 4.767366574247e+02
RINT18217 nd7491 nd7522 1.057473416667e+04
RINT18218 nd7492 nd7523 4.406139236111e+01
RINT18219 nd7493 nd7524 4.406139236111e+01
RINT18220 nd7494 nd7525 4.406139236111e+01
RINT18221 nd7495 nd7526 4.406139236111e+01
RINT18222 nd7496 nd7527 4.406139236111e+01
RINT18223 nd7497 nd7528 4.406139236111e+01
RINT18224 nd7498 nd7529 4.406139236111e+01
RINT18225 nd7499 nd7530 4.406139236111e+01
RINT18226 nd7500 nd7531 4.406139236111e+01
RINT18227 nd7501 nd7532 4.406139236111e+01
RINT18228 nd7502 nd7533 1.282616767136e+02
RINT18229 nd7503 nd7534 1.107545883941e+02
RINT18230 nd7504 nd7535 1.107545883941e+02
RINT18231 nd7505 nd7536 6.425829603070e+03
RINT18232 nd7506 nd7537 2.279517697008e+02
RINT18233 nd7507 nd7538 2.295640559441e+02
RINT18234 nd7508 nd7539 2.295640559441e+02
RINT18235 nd7509 nd7540 5.984208854167e+05
RINT18236 nd7510 nd7541 9.973681423611e+04
RINT18237 nd7511 nd7542 1.709773958333e+05
RINT18238 nd7512 nd7543 1.709773958333e+05
RINT18239 nd7513 nd7544 1.709773958333e+05
RINT18240 nd7514 nd7545 1.709773958333e+05
RINT18241 nd7515 nd7546 1.709773958333e+05
RINT18242 nd7516 nd7547 1.709773958333e+05
RINT18243 nd7517 nd7548 1.709773958333e+05
RINT18244 nd7518 nd7549 3.799497685185e+04
RINT18245 nd7519 nd7550 3.799497685185e+04
RINT18246 nd7520 nd7551 1.200279881138e+04
RINT18247 nd7521 nd7552 8.633080870696e+02
RINT18248 nd7522 nd7553 1.914946833333e+04
RINT18249 nd7523 nd7554 7.978945138889e+01
RINT18250 nd7524 nd7555 7.978945138889e+01
RINT18251 nd7525 nd7556 7.978945138889e+01
RINT18252 nd7526 nd7557 7.978945138889e+01
RINT18253 nd7527 nd7558 7.978945138889e+01
RINT18254 nd7528 nd7559 7.978945138889e+01
RINT18255 nd7529 nd7560 7.978945138889e+01
RINT18256 nd7530 nd7561 7.978945138889e+01
RINT18257 nd7531 nd7562 7.978945138889e+01
RINT18258 nd7532 nd7563 7.978945138889e+01
RINT18259 nd7533 nd7564 1.282616767136e+02
RINT18260 nd7534 nd7565 1.107545883941e+02
RINT18261 nd7535 nd7566 1.107545883941e+02
RINT18262 nd7536 nd7567 6.425829603070e+03
RINT18263 nd7537 nd7568 2.279517697008e+02
RINT18264 nd7538 nd7569 2.295640559441e+02
RINT18265 nd7539 nd7570 2.295640559441e+02
RINT18266 nd7540 nd7571 5.984208854167e+05
RINT18267 nd7541 nd7572 9.973681423611e+04
RINT18268 nd7542 nd7573 1.709773958333e+05
RINT18269 nd7543 nd7574 1.709773958333e+05
RINT18270 nd7544 nd7575 1.709773958333e+05
RINT18271 nd7545 nd7576 1.709773958333e+05
RINT18272 nd7546 nd7577 1.709773958333e+05
RINT18273 nd7547 nd7578 1.709773958333e+05
RINT18274 nd7548 nd7579 1.709773958333e+05
RINT18275 nd7549 nd7580 3.799497685185e+04
RINT18276 nd7550 nd7581 3.799497685185e+04
RINT18277 nd7551 nd7582 1.200279881138e+04
RINT18278 nd7552 nd7583 8.633080870696e+02
RINT18279 nd7553 nd7584 1.914946833333e+04
RINT18280 nd7554 nd7585 7.978945138889e+01
RINT18281 nd7555 nd7586 7.978945138889e+01
RINT18282 nd7556 nd7587 7.978945138889e+01
RINT18283 nd7557 nd7588 7.978945138889e+01
RINT18284 nd7558 nd7589 7.978945138889e+01
RINT18285 nd7559 nd7590 7.978945138889e+01
RINT18286 nd7560 nd7591 7.978945138889e+01
RINT18287 nd7561 nd7592 7.978945138889e+01
RINT18288 nd7562 nd7593 7.978945138889e+01
RINT18289 nd7563 nd7594 7.978945138889e+01
RINT18290 nd7564 nd7595 1.282616767136e+02
RINT18291 nd7565 nd7596 1.107545883941e+02
RINT18292 nd7566 nd7597 1.107545883941e+02
RINT18293 nd7567 nd7598 6.425829603070e+03
RINT18294 nd7568 nd7599 2.279517697008e+02
RINT18295 nd7569 nd7600 2.295640559441e+02
RINT18296 nd7570 nd7601 2.295640559441e+02
RINT18297 nd7571 nd7602 5.984208854167e+05
RINT18298 nd7572 nd7603 9.973681423611e+04
RINT18299 nd7573 nd7604 1.709773958333e+05
RINT18300 nd7574 nd7605 1.709773958333e+05
RINT18301 nd7575 nd7606 1.709773958333e+05
RINT18302 nd7576 nd7607 1.709773958333e+05
RINT18303 nd7577 nd7608 1.709773958333e+05
RINT18304 nd7578 nd7609 1.709773958333e+05
RINT18305 nd7579 nd7610 1.709773958333e+05
RINT18306 nd7580 nd7611 3.799497685185e+04
RINT18307 nd7581 nd7612 3.799497685185e+04
RINT18308 nd7582 nd7613 1.200279881138e+04
RINT18309 nd7583 nd7614 8.633080870696e+02
RINT18310 nd7584 nd7615 1.914946833333e+04
RINT18311 nd7585 nd7616 7.978945138889e+01
RINT18312 nd7586 nd7617 7.978945138889e+01
RINT18313 nd7587 nd7618 7.978945138889e+01
RINT18314 nd7588 nd7619 7.978945138889e+01
RINT18315 nd7589 nd7620 7.978945138889e+01
RINT18316 nd7590 nd7621 7.978945138889e+01
RINT18317 nd7591 nd7622 7.978945138889e+01
RINT18318 nd7592 nd7623 7.978945138889e+01
RINT18319 nd7593 nd7624 7.978945138889e+01
RINT18320 nd7594 nd7625 7.978945138889e+01
RINT18321 nd7595 nd7626 1.282616767136e+02
RINT18322 nd7596 nd7627 1.107545883941e+02
RINT18323 nd7597 nd7628 1.107545883941e+02
RINT18324 nd7598 nd7629 6.425829603070e+03
RINT18325 nd7599 nd7630 2.279517697008e+02
RINT18326 nd7600 nd7631 2.295640559441e+02
RINT18327 nd7601 nd7632 2.295640559441e+02
RINT18328 nd7602 nd7633 5.984208854167e+05
RINT18329 nd7603 nd7634 9.973681423611e+04
RINT18330 nd7604 nd7635 1.709773958333e+05
RINT18331 nd7605 nd7636 1.709773958333e+05
RINT18332 nd7606 nd7637 1.709773958333e+05
RINT18333 nd7607 nd7638 1.709773958333e+05
RINT18334 nd7608 nd7639 1.709773958333e+05
RINT18335 nd7609 nd7640 1.709773958333e+05
RINT18336 nd7610 nd7641 1.709773958333e+05
RINT18337 nd7611 nd7642 3.799497685185e+04
RINT18338 nd7612 nd7643 3.799497685185e+04
RINT18339 nd7613 nd7644 1.200279881138e+04
RINT18340 nd7614 nd7645 8.633080870696e+02
RINT18341 nd7615 nd7646 1.914946833333e+04
RINT18342 nd7616 nd7647 7.978945138889e+01
RINT18343 nd7617 nd7648 7.978945138889e+01
RINT18344 nd7618 nd7649 7.978945138889e+01
RINT18345 nd7619 nd7650 7.978945138889e+01
RINT18346 nd7620 nd7651 7.978945138889e+01
RINT18347 nd7621 nd7652 7.978945138889e+01
RINT18348 nd7622 nd7653 7.978945138889e+01
RINT18349 nd7623 nd7654 7.978945138889e+01
RINT18350 nd7624 nd7655 7.978945138889e+01
RINT18351 nd7625 nd7656 7.978945138889e+01
RINT18352 nd7626 nd7657 1.282616767136e+02
RINT18353 nd7627 nd7658 1.107545883941e+02
RINT18354 nd7628 nd7659 1.107545883941e+02
RINT18355 nd7629 nd7660 6.425829603070e+03
RINT18356 nd7630 nd7661 2.279517697008e+02
RINT18357 nd7631 nd7662 2.295640559441e+02
RINT18358 nd7632 nd7663 2.295640559441e+02
RINT18359 nd7633 nd7664 5.984208854167e+05
RINT18360 nd7634 nd7665 9.973681423611e+04
RINT18361 nd7635 nd7666 1.709773958333e+05
RINT18362 nd7636 nd7667 1.709773958333e+05
RINT18363 nd7637 nd7668 1.709773958333e+05
RINT18364 nd7638 nd7669 1.709773958333e+05
RINT18365 nd7639 nd7670 1.709773958333e+05
RINT18366 nd7640 nd7671 1.709773958333e+05
RINT18367 nd7641 nd7672 1.709773958333e+05
RINT18368 nd7642 nd7673 3.799497685185e+04
RINT18369 nd7643 nd7674 3.799497685185e+04
RINT18370 nd7644 nd7675 1.200279881138e+04
RINT18371 nd7645 nd7676 8.633080870696e+02
RINT18372 nd7646 nd7677 1.914946833333e+04
RINT18373 nd7647 nd7678 7.978945138889e+01
RINT18374 nd7648 nd7679 7.978945138889e+01
RINT18375 nd7649 nd7680 7.978945138889e+01
RINT18376 nd7650 nd7681 7.978945138889e+01
RINT18377 nd7651 nd7682 7.978945138889e+01
RINT18378 nd7652 nd7683 7.978945138889e+01
RINT18379 nd7653 nd7684 7.978945138889e+01
RINT18380 nd7654 nd7685 7.978945138889e+01
RINT18381 nd7655 nd7686 7.978945138889e+01
RINT18382 nd7656 nd7687 7.978945138889e+01
RINT18383 nd7657 nd7688 7.082876200045e+01
RINT18384 nd7658 nd7689 6.116098419125e+01
RINT18385 nd7659 nd7690 6.116098419125e+01
RINT18386 nd7660 nd7691 3.548476577518e+03
RINT18387 nd7661 nd7692 1.258797020078e+02
RINT18388 nd7662 nd7693 1.267700399600e+02
RINT18389 nd7663 nd7694 1.267700399600e+02
RINT18390 nd7664 nd7695 3.304604427083e+05
RINT18391 nd7665 nd7696 5.507674045139e+04
RINT18392 nd7666 nd7697 9.441726934524e+04
RINT18393 nd7667 nd7698 9.441726934524e+04
RINT18394 nd7668 nd7699 9.441726934524e+04
RINT18395 nd7669 nd7700 9.441726934524e+04
RINT18396 nd7670 nd7701 9.441726934524e+04
RINT18397 nd7671 nd7702 9.441726934524e+04
RINT18398 nd7672 nd7703 9.441726934524e+04
RINT18399 nd7673 nd7704 2.098161541005e+04
RINT18400 nd7674 nd7705 2.098161541005e+04
RINT18401 nd7675 nd7706 6.628194813396e+03
RINT18402 nd7676 nd7707 4.767366574247e+02
RINT18403 nd7677 nd7708 1.057473416667e+04
RINT18404 nd7678 nd7709 4.406139236111e+01
RINT18405 nd7679 nd7710 4.406139236111e+01
RINT18406 nd7680 nd7711 4.406139236111e+01
RINT18407 nd7681 nd7712 4.406139236111e+01
RINT18408 nd7682 nd7713 4.406139236111e+01
RINT18409 nd7683 nd7714 4.406139236111e+01
RINT18410 nd7684 nd7715 4.406139236111e+01
RINT18411 nd7685 nd7716 4.406139236111e+01
RINT18412 nd7686 nd7717 4.406139236111e+01
RINT18413 nd7687 nd7718 4.406139236111e+01
RINT18414 nd7688 nd7719 5.593547666890e+01
RINT18415 nd7689 nd7720 4.830055909003e+01
RINT18416 nd7690 nd7721 4.830055909003e+01
RINT18417 nd7691 nd7722 2.802332318199e+03
RINT18418 nd7692 nd7723 9.941076105071e+01
RINT18419 nd7693 nd7724 1.001138861139e+02
RINT18420 nd7694 nd7725 1.001138861139e+02
RINT18421 nd7695 nd7726 3.475055555556e+04
RINT18422 nd7696 nd7727 5.791759259259e+03
RINT18423 nd7697 nd7728 9.928730158730e+03
RINT18424 nd7698 nd7729 9.928730158730e+03
RINT18425 nd7699 nd7730 9.928730158730e+03
RINT18426 nd7700 nd7731 9.928730158730e+03
RINT18427 nd7701 nd7732 9.928730158730e+03
RINT18428 nd7702 nd7733 9.928730158730e+03
RINT18429 nd7703 nd7734 9.928730158730e+03
RINT18430 nd7704 nd7735 2.206384479718e+03
RINT18431 nd7705 nd7736 2.206384479718e+03
RINT18432 nd7706 nd7737 5.234472915668e+03
RINT18433 nd7707 nd7738 3.764924223640e+02
RINT18434 nd7708 nd7739 8.351166666667e+03
RINT18435 nd7709 nd7740 3.479652777778e+01
RINT18436 nd7710 nd7741 3.479652777778e+01
RINT18437 nd7711 nd7742 3.479652777778e+01
RINT18438 nd7712 nd7743 3.479652777778e+01
RINT18439 nd7713 nd7744 3.479652777778e+01
RINT18440 nd7714 nd7745 3.479652777778e+01
RINT18441 nd7715 nd7746 3.479652777778e+01
RINT18442 nd7716 nd7747 3.479652777778e+01
RINT18443 nd7717 nd7748 3.479652777778e+01
RINT18444 nd7718 nd7749 3.479652777778e+01
RINT18445 nd7719 nd7750 9.847510605046e+01
RINT18446 nd7720 nd7751 8.503373819163e+01
RINT18447 nd7721 nd7752 8.503373819163e+01
RINT18448 nd7722 nd7753 4.933541084432e+03
RINT18449 nd7723 nd7754 1.750138877867e+02
RINT18450 nd7724 nd7755 1.762517482517e+02
RINT18451 nd7725 nd7756 1.762517482517e+02
RINT18452 nd7726 nd7757 7.001111111111e+03
RINT18453 nd7727 nd7758 1.166851851852e+03
RINT18454 nd7728 nd7759 2.000317460317e+03
RINT18455 nd7729 nd7760 2.000317460317e+03
RINT18456 nd7730 nd7761 2.000317460317e+03
RINT18457 nd7731 nd7762 2.000317460317e+03
RINT18458 nd7732 nd7763 2.000317460317e+03
RINT18459 nd7733 nd7764 2.000317460317e+03
RINT18460 nd7734 nd7765 2.000317460317e+03
RINT18461 nd7735 nd7766 4.445149911817e+02
RINT18462 nd7736 nd7767 4.445149911817e+02
RINT18463 nd7737 nd7768 9.215355015920e+03
RINT18464 nd7738 nd7769 6.628196169481e+02
RINT18465 nd7739 nd7770 1.470233333333e+04
RINT18466 nd7740 nd7771 6.125972222222e+01
RINT18467 nd7741 nd7772 6.125972222222e+01
RINT18468 nd7742 nd7773 6.125972222222e+01
RINT18469 nd7743 nd7774 6.125972222222e+01
RINT18470 nd7744 nd7775 6.125972222222e+01
RINT18471 nd7745 nd7776 6.125972222222e+01
RINT18472 nd7746 nd7777 6.125972222222e+01
RINT18473 nd7747 nd7778 6.125972222222e+01
RINT18474 nd7748 nd7779 6.125972222222e+01
RINT18475 nd7749 nd7780 6.125972222222e+01
RINT18476 nd7750 nd7781 9.847510605046e+01
RINT18477 nd7751 nd7782 8.503373819163e+01
RINT18478 nd7752 nd7783 8.503373819163e+01
RINT18479 nd7753 nd7784 4.933541084432e+03
RINT18480 nd7754 nd7785 1.750138877867e+02
RINT18481 nd7755 nd7786 1.762517482517e+02
RINT18482 nd7756 nd7787 1.762517482517e+02
RINT18483 nd7757 nd7788 7.001111111111e+03
RINT18484 nd7758 nd7789 1.166851851852e+03
RINT18485 nd7759 nd7790 2.000317460317e+03
RINT18486 nd7760 nd7791 2.000317460317e+03
RINT18487 nd7761 nd7792 2.000317460317e+03
RINT18488 nd7762 nd7793 2.000317460317e+03
RINT18489 nd7763 nd7794 2.000317460317e+03
RINT18490 nd7764 nd7795 2.000317460317e+03
RINT18491 nd7765 nd7796 2.000317460317e+03
RINT18492 nd7766 nd7797 4.445149911817e+02
RINT18493 nd7767 nd7798 4.445149911817e+02
RINT18494 nd7768 nd7799 9.215355015920e+03
RINT18495 nd7769 nd7800 6.628196169481e+02
RINT18496 nd7770 nd7801 1.470233333333e+04
RINT18497 nd7771 nd7802 6.125972222222e+01
RINT18498 nd7772 nd7803 6.125972222222e+01
RINT18499 nd7773 nd7804 6.125972222222e+01
RINT18500 nd7774 nd7805 6.125972222222e+01
RINT18501 nd7775 nd7806 6.125972222222e+01
RINT18502 nd7776 nd7807 6.125972222222e+01
RINT18503 nd7777 nd7808 6.125972222222e+01
RINT18504 nd7778 nd7809 6.125972222222e+01
RINT18505 nd7779 nd7810 6.125972222222e+01
RINT18506 nd7780 nd7811 6.125972222222e+01
RINT18507 nd7812 nd7843 1.042035668855e+01
RINT18508 nd7813 nd7844 8.998029228461e+00
RINT18509 nd7814 nd7845 8.998029228461e+00
RINT18510 nd7815 nd7846 5.220533381408e+02
RINT18511 nd7816 nd7847 1.851947369575e+01
RINT18512 nd7817 nd7848 1.865046058263e+01
RINT18513 nd7818 nd7849 1.865046058263e+01
RINT18514 nd7819 nd7850 7.408377398100e+02
RINT18515 nd7820 nd7851 1.234729566350e+02
RINT18516 nd7821 nd7852 2.116679256600e+02
RINT18517 nd7822 nd7853 2.116679256600e+02
RINT18518 nd7823 nd7854 2.116679256600e+02
RINT18519 nd7824 nd7855 2.116679256600e+02
RINT18520 nd7825 nd7856 2.116679256600e+02
RINT18521 nd7826 nd7857 2.116679256600e+02
RINT18522 nd7827 nd7858 2.116679256600e+02
RINT18523 nd7828 nd7859 4.703731681333e+01
RINT18524 nd7829 nd7860 4.703731681333e+01
RINT18525 nd7830 nd7861 9.751427556557e+02
RINT18526 nd7831 nd7862 7.013769373582e+01
RINT18527 nd7832 nd7863 1.555759253601e+03
RINT18528 nd7833 nd7864 6.482330223337e+00
RINT18529 nd7834 nd7865 6.482330223337e+00
RINT18530 nd7835 nd7866 6.482330223337e+00
RINT18531 nd7836 nd7867 6.482330223337e+00
RINT18532 nd7837 nd7868 6.482330223337e+00
RINT18533 nd7838 nd7869 6.482330223337e+00
RINT18534 nd7839 nd7870 6.482330223337e+00
RINT18535 nd7840 nd7871 6.482330223337e+00
RINT18536 nd7841 nd7872 6.482330223337e+00
RINT18537 nd7842 nd7873 6.482330223337e+00
RINT18538 nd7843 nd7874 1.042035668855e+01
RINT18539 nd7844 nd7875 8.998029228461e+00
RINT18540 nd7845 nd7876 8.998029228461e+00
RINT18541 nd7846 nd7877 5.220533381408e+02
RINT18542 nd7847 nd7878 1.851947369575e+01
RINT18543 nd7848 nd7879 1.865046058263e+01
RINT18544 nd7849 nd7880 1.865046058263e+01
RINT18545 nd7850 nd7881 7.408377398100e+02
RINT18546 nd7851 nd7882 1.234729566350e+02
RINT18547 nd7852 nd7883 2.116679256600e+02
RINT18548 nd7853 nd7884 2.116679256600e+02
RINT18549 nd7854 nd7885 2.116679256600e+02
RINT18550 nd7855 nd7886 2.116679256600e+02
RINT18551 nd7856 nd7887 2.116679256600e+02
RINT18552 nd7857 nd7888 2.116679256600e+02
RINT18553 nd7858 nd7889 2.116679256600e+02
RINT18554 nd7859 nd7890 4.703731681333e+01
RINT18555 nd7860 nd7891 4.703731681333e+01
RINT18556 nd7861 nd7892 9.751427556557e+02
RINT18557 nd7862 nd7893 7.013769373582e+01
RINT18558 nd7863 nd7894 1.555759253601e+03
RINT18559 nd7864 nd7895 6.482330223337e+00
RINT18560 nd7865 nd7896 6.482330223337e+00
RINT18561 nd7866 nd7897 6.482330223337e+00
RINT18562 nd7867 nd7898 6.482330223337e+00
RINT18563 nd7868 nd7899 6.482330223337e+00
RINT18564 nd7869 nd7900 6.482330223337e+00
RINT18565 nd7870 nd7901 6.482330223337e+00
RINT18566 nd7871 nd7902 6.482330223337e+00
RINT18567 nd7872 nd7903 6.482330223337e+00
RINT18568 nd7873 nd7904 6.482330223337e+00
RINT18569 nd7874 nd7905 5.918933645378e+00
RINT18570 nd7875 nd7906 5.111028301069e+00
RINT18571 nd7876 nd7907 5.111028301069e+00
RINT18572 nd7877 nd7908 2.965348653754e+02
RINT18573 nd7878 nd7909 1.051936504946e+01
RINT18574 nd7879 nd7910 1.059376775131e+01
RINT18575 nd7880 nd7911 1.059376775131e+01
RINT18576 nd7881 nd7912 3.677205321604e+03
RINT18577 nd7882 nd7913 6.128675536007e+02
RINT18578 nd7883 nd7914 1.050630091887e+03
RINT18579 nd7884 nd7915 1.050630091887e+03
RINT18580 nd7885 nd7916 1.050630091887e+03
RINT18581 nd7886 nd7917 1.050630091887e+03
RINT18582 nd7887 nd7918 1.050630091887e+03
RINT18583 nd7888 nd7919 1.050630091887e+03
RINT18584 nd7889 nd7920 1.050630091887e+03
RINT18585 nd7890 nd7921 2.334733537526e+02
RINT18586 nd7891 nd7922 2.334733537526e+02
RINT18587 nd7892 nd7923 5.538970918181e+02
RINT18588 nd7893 nd7924 3.983936132610e+01
RINT18589 nd7894 nd7925 8.836967932549e+02
RINT18590 nd7895 nd7926 3.682069971895e+00
RINT18591 nd7896 nd7927 3.682069971895e+00
RINT18592 nd7897 nd7928 3.682069971895e+00
RINT18593 nd7898 nd7929 3.682069971895e+00
RINT18594 nd7899 nd7930 3.682069971895e+00
RINT18595 nd7900 nd7931 3.682069971895e+00
RINT18596 nd7901 nd7932 3.682069971895e+00
RINT18597 nd7902 nd7933 3.682069971895e+00
RINT18598 nd7903 nd7934 3.682069971895e+00
RINT18599 nd7904 nd7935 3.682069971895e+00
RINT18600 nd7905 nd7936 7.494898898358e+00
RINT18601 nd7906 nd7937 6.471882044678e+00
RINT18602 nd7907 nd7938 6.471882044678e+00
RINT18603 nd7908 nd7939 3.754897366627e+02
RINT18604 nd7909 nd7940 1.332023338058e+01
RINT18605 nd7910 nd7941 1.341444641988e+01
RINT18606 nd7911 nd7942 1.341444641988e+01
RINT18607 nd7912 nd7943 3.942767563891e+03
RINT18608 nd7913 nd7944 6.216370766103e+02
RINT18609 nd7914 nd7945 1.083955004199e+03
RINT18610 nd7915 nd7946 1.083955004199e+03
RINT18611 nd7916 nd7947 1.083955004199e+03
RINT18612 nd7917 nd7948 1.083955004199e+03
RINT18613 nd7918 nd7949 1.083955004199e+03
RINT18614 nd7919 nd7950 1.083955004199e+03
RINT18615 nd7920 nd7951 1.083955004199e+03
RINT18616 nd7921 nd7952 2.368141244230e+02
RINT18617 nd7922 nd7953 2.376222816265e+02
RINT18618 nd7923 nd7954 7.013767938611e+02
RINT18619 nd7924 nd7955 5.044692223361e+01
RINT18620 nd7925 nd7956 1.118988405525e+03
RINT18621 nd7926 nd7957 4.662451689687e+00
RINT18622 nd7927 nd7958 4.662451689687e+00
RINT18623 nd7928 nd7959 4.662451689687e+00
RINT18624 nd7929 nd7960 4.662451689687e+00
RINT18625 nd7930 nd7961 4.662451689687e+00
RINT18626 nd7931 nd7962 4.662451689687e+00
RINT18627 nd7932 nd7963 4.662451689687e+00
RINT18628 nd7933 nd7964 4.662451689687e+00
RINT18629 nd7934 nd7965 4.662451689687e+00
RINT18630 nd7935 nd7966 4.662451689687e+00
RINT18631 nd7936 nd7967 1.357228719451e+01
RINT18632 nd7937 nd7968 1.171973671568e+01
RINT18633 nd7938 nd7969 1.171973671568e+01
RINT18634 nd7939 nd7970 6.799630807155e+02
RINT18635 nd7940 nd7971 2.412121035800e+01
RINT18636 nd7941 nd7972 2.429181791977e+01
RINT18637 nd7942 nd7973 2.429181791977e+01
RINT18638 nd7943 nd7974 1.271962224384e+03
RINT18639 nd7944 nd7975 1.410120026542e+02
RINT18640 nd7945 nd7976 2.783177502845e+02
RINT18641 nd7946 nd7977 2.783177502845e+02
RINT18642 nd7947 nd7978 2.783177502845e+02
RINT18643 nd7948 nd7979 2.783177502845e+02
RINT18644 nd7949 nd7980 2.783177502845e+02
RINT18645 nd7950 nd7981 2.783177502845e+02
RINT18646 nd7951 nd7982 2.783177502845e+02
RINT18647 nd7952 nd7983 5.371885815399e+01
RINT18648 nd7953 nd7984 5.533517256115e+01
RINT18649 nd7954 nd7985 1.270102159742e+03
RINT18650 nd7955 nd7986 9.135281555084e+01
RINT18651 nd7956 nd7987 2.026342478141e+03
RINT18652 nd7957 nd7988 8.443093658921e+00
RINT18653 nd7958 nd7989 8.443093658921e+00
RINT18654 nd7959 nd7990 8.443093658921e+00
RINT18655 nd7960 nd7991 8.443093658921e+00
RINT18656 nd7961 nd7992 8.443093658921e+00
RINT18657 nd7962 nd7993 8.443093658921e+00
RINT18658 nd7963 nd7994 8.443093658921e+00
RINT18659 nd7964 nd7995 8.443093658921e+00
RINT18660 nd7965 nd7996 8.443093658921e+00
RINT18661 nd7966 nd7997 8.443093658921e+00
RINT18662 nd7967 nd7998 1.357228719451e+01
RINT18663 nd7968 nd7999 1.171973671568e+01
RINT18664 nd7969 nd8000 1.171973671568e+01
RINT18665 nd7970 nd8001 6.799630807155e+02
RINT18666 nd7971 nd8002 2.412121035800e+01
RINT18667 nd7972 nd8003 2.429181791977e+01
RINT18668 nd7973 nd8004 2.429181791977e+01
RINT18669 nd7974 nd8005 1.271962224384e+03
RINT18670 nd7975 nd8006 1.410120026542e+02
RINT18671 nd7976 nd8007 2.783177502845e+02
RINT18672 nd7977 nd8008 2.783177502845e+02
RINT18673 nd7978 nd8009 2.783177502845e+02
RINT18674 nd7979 nd8010 2.783177502845e+02
RINT18675 nd7980 nd8011 2.783177502845e+02
RINT18676 nd7981 nd8012 2.783177502845e+02
RINT18677 nd7982 nd8013 2.783177502845e+02
RINT18678 nd7983 nd8014 5.371885815399e+01
RINT18679 nd7984 nd8015 5.533517256115e+01
RINT18680 nd7985 nd8016 1.270102159742e+03
RINT18681 nd7986 nd8017 9.135281555084e+01
RINT18682 nd7987 nd8018 2.026342478141e+03
RINT18683 nd7988 nd8019 8.443093658921e+00
RINT18684 nd7989 nd8020 8.443093658921e+00
RINT18685 nd7990 nd8021 8.443093658921e+00
RINT18686 nd7991 nd8022 8.443093658921e+00
RINT18687 nd7992 nd8023 8.443093658921e+00
RINT18688 nd7993 nd8024 8.443093658921e+00
RINT18689 nd7994 nd8025 8.443093658921e+00
RINT18690 nd7995 nd8026 8.443093658921e+00
RINT18691 nd7996 nd8027 8.443093658921e+00
RINT18692 nd7997 nd8028 8.443093658921e+00
RINT18693 nd7998 nd8029 1.357228719451e+01
RINT18694 nd7999 nd8030 1.171973671568e+01
RINT18695 nd8000 nd8031 1.171973671568e+01
RINT18696 nd8001 nd8032 6.799630807155e+02
RINT18697 nd8002 nd8033 2.412121035800e+01
RINT18698 nd8003 nd8034 2.429181791977e+01
RINT18699 nd8004 nd8035 2.429181791977e+01
RINT18700 nd8005 nd8036 1.271962224384e+03
RINT18701 nd8006 nd8037 1.410120026542e+02
RINT18702 nd8007 nd8038 2.783177502845e+02
RINT18703 nd8008 nd8039 2.783177502845e+02
RINT18704 nd8009 nd8040 2.783177502845e+02
RINT18705 nd8010 nd8041 2.783177502845e+02
RINT18706 nd8011 nd8042 2.783177502845e+02
RINT18707 nd8012 nd8043 2.783177502845e+02
RINT18708 nd8013 nd8044 2.783177502845e+02
RINT18709 nd8014 nd8045 5.371885815399e+01
RINT18710 nd8015 nd8046 5.533517256115e+01
RINT18711 nd8016 nd8047 1.270102159742e+03
RINT18712 nd8017 nd8048 9.135281555084e+01
RINT18713 nd8018 nd8049 2.026342478141e+03
RINT18714 nd8019 nd8050 8.443093658921e+00
RINT18715 nd8020 nd8051 8.443093658921e+00
RINT18716 nd8021 nd8052 8.443093658921e+00
RINT18717 nd8022 nd8053 8.443093658921e+00
RINT18718 nd8023 nd8054 8.443093658921e+00
RINT18719 nd8024 nd8055 8.443093658921e+00
RINT18720 nd8025 nd8056 8.443093658921e+00
RINT18721 nd8026 nd8057 8.443093658921e+00
RINT18722 nd8027 nd8058 8.443093658921e+00
RINT18723 nd8028 nd8059 8.443093658921e+00
RINT18724 nd8029 nd8060 1.357228719451e+01
RINT18725 nd8030 nd8061 1.171973671568e+01
RINT18726 nd8031 nd8062 1.171973671568e+01
RINT18727 nd8032 nd8063 6.799630807155e+02
RINT18728 nd8033 nd8064 2.412121035800e+01
RINT18729 nd8034 nd8065 2.429181791977e+01
RINT18730 nd8035 nd8066 2.429181791977e+01
RINT18731 nd8036 nd8067 1.271962224384e+03
RINT18732 nd8037 nd8068 1.410120026542e+02
RINT18733 nd8038 nd8069 2.783177502845e+02
RINT18734 nd8039 nd8070 2.783177502845e+02
RINT18735 nd8040 nd8071 2.783177502845e+02
RINT18736 nd8041 nd8072 2.783177502845e+02
RINT18737 nd8042 nd8073 2.783177502845e+02
RINT18738 nd8043 nd8074 2.783177502845e+02
RINT18739 nd8044 nd8075 2.783177502845e+02
RINT18740 nd8045 nd8076 5.371885815399e+01
RINT18741 nd8046 nd8077 5.533517256115e+01
RINT18742 nd8047 nd8078 1.270102159742e+03
RINT18743 nd8048 nd8079 9.135281555084e+01
RINT18744 nd8049 nd8080 2.026342478141e+03
RINT18745 nd8050 nd8081 8.443093658921e+00
RINT18746 nd8051 nd8082 8.443093658921e+00
RINT18747 nd8052 nd8083 8.443093658921e+00
RINT18748 nd8053 nd8084 8.443093658921e+00
RINT18749 nd8054 nd8085 8.443093658921e+00
RINT18750 nd8055 nd8086 8.443093658921e+00
RINT18751 nd8056 nd8087 8.443093658921e+00
RINT18752 nd8057 nd8088 8.443093658921e+00
RINT18753 nd8058 nd8089 8.443093658921e+00
RINT18754 nd8059 nd8090 8.443093658921e+00
RINT18755 nd8060 nd8091 1.357228719451e+01
RINT18756 nd8061 nd8092 1.171973671568e+01
RINT18757 nd8062 nd8093 1.171973671568e+01
RINT18758 nd8063 nd8094 6.799630807155e+02
RINT18759 nd8064 nd8095 2.412121035800e+01
RINT18760 nd8065 nd8096 2.429181791977e+01
RINT18761 nd8066 nd8097 2.429181791977e+01
RINT18762 nd8067 nd8098 1.271962224384e+03
RINT18763 nd8068 nd8099 1.410120026542e+02
RINT18764 nd8069 nd8100 2.783177502845e+02
RINT18765 nd8070 nd8101 2.783177502845e+02
RINT18766 nd8071 nd8102 2.783177502845e+02
RINT18767 nd8072 nd8103 2.783177502845e+02
RINT18768 nd8073 nd8104 2.783177502845e+02
RINT18769 nd8074 nd8105 2.783177502845e+02
RINT18770 nd8075 nd8106 2.783177502845e+02
RINT18771 nd8076 nd8107 5.371885815399e+01
RINT18772 nd8077 nd8108 5.533517256115e+01
RINT18773 nd8078 nd8109 1.270102159742e+03
RINT18774 nd8079 nd8110 9.135281555084e+01
RINT18775 nd8080 nd8111 2.026342478141e+03
RINT18776 nd8081 nd8112 8.443093658921e+00
RINT18777 nd8082 nd8113 8.443093658921e+00
RINT18778 nd8083 nd8114 8.443093658921e+00
RINT18779 nd8084 nd8115 8.443093658921e+00
RINT18780 nd8085 nd8116 8.443093658921e+00
RINT18781 nd8086 nd8117 8.443093658921e+00
RINT18782 nd8087 nd8118 8.443093658921e+00
RINT18783 nd8088 nd8119 8.443093658921e+00
RINT18784 nd8089 nd8120 8.443093658921e+00
RINT18785 nd8090 nd8121 8.443093658921e+00
RINT18786 nd8091 nd8122 7.494898898358e+00
RINT18787 nd8092 nd8123 6.471882044678e+00
RINT18788 nd8093 nd8124 6.471882044678e+00
RINT18789 nd8094 nd8125 3.754897366627e+02
RINT18790 nd8095 nd8126 1.332023338058e+01
RINT18791 nd8096 nd8127 1.341444641988e+01
RINT18792 nd8097 nd8128 1.341444641988e+01
RINT18793 nd8098 nd8129 3.942767563891e+03
RINT18794 nd8099 nd8130 6.216370766103e+02
RINT18795 nd8100 nd8131 1.083955004199e+03
RINT18796 nd8101 nd8132 1.083955004199e+03
RINT18797 nd8102 nd8133 1.083955004199e+03
RINT18798 nd8103 nd8134 1.083955004199e+03
RINT18799 nd8104 nd8135 1.083955004199e+03
RINT18800 nd8105 nd8136 1.083955004199e+03
RINT18801 nd8106 nd8137 1.083955004199e+03
RINT18802 nd8107 nd8138 2.368141244230e+02
RINT18803 nd8108 nd8139 2.376222816266e+02
RINT18804 nd8109 nd8140 7.013767938611e+02
RINT18805 nd8110 nd8141 5.044692223361e+01
RINT18806 nd8111 nd8142 1.118988405525e+03
RINT18807 nd8112 nd8143 4.662451689687e+00
RINT18808 nd8113 nd8144 4.662451689687e+00
RINT18809 nd8114 nd8145 4.662451689687e+00
RINT18810 nd8115 nd8146 4.662451689687e+00
RINT18811 nd8116 nd8147 4.662451689687e+00
RINT18812 nd8117 nd8148 4.662451689687e+00
RINT18813 nd8118 nd8149 4.662451689687e+00
RINT18814 nd8119 nd8150 4.662451689687e+00
RINT18815 nd8120 nd8151 4.662451689687e+00
RINT18816 nd8121 nd8152 4.662451689687e+00
RINT18817 nd8122 nd8153 7.494898898358e+00
RINT18818 nd8123 nd8154 6.471882044678e+00
RINT18819 nd8124 nd8155 6.471882044678e+00
RINT18820 nd8125 nd8156 3.754897366627e+02
RINT18821 nd8126 nd8157 1.332023338058e+01
RINT18822 nd8127 nd8158 1.341444641988e+01
RINT18823 nd8128 nd8159 1.341444641988e+01
RINT18824 nd8129 nd8160 3.942767563891e+03
RINT18825 nd8130 nd8161 6.216370766103e+02
RINT18826 nd8131 nd8162 1.083955004199e+03
RINT18827 nd8132 nd8163 1.083955004199e+03
RINT18828 nd8133 nd8164 1.083955004199e+03
RINT18829 nd8134 nd8165 1.083955004199e+03
RINT18830 nd8135 nd8166 1.083955004199e+03
RINT18831 nd8136 nd8167 1.083955004199e+03
RINT18832 nd8137 nd8168 1.083955004199e+03
RINT18833 nd8138 nd8169 2.368141244230e+02
RINT18834 nd8139 nd8170 2.376222816266e+02
RINT18835 nd8140 nd8171 7.013767938611e+02
RINT18836 nd8141 nd8172 5.044692223361e+01
RINT18837 nd8142 nd8173 1.118988405525e+03
RINT18838 nd8143 nd8174 4.662451689687e+00
RINT18839 nd8144 nd8175 4.662451689687e+00
RINT18840 nd8145 nd8176 4.662451689687e+00
RINT18841 nd8146 nd8177 4.662451689687e+00
RINT18842 nd8147 nd8178 4.662451689687e+00
RINT18843 nd8148 nd8179 4.662451689687e+00
RINT18844 nd8149 nd8180 4.662451689687e+00
RINT18845 nd8150 nd8181 4.662451689687e+00
RINT18846 nd8151 nd8182 4.662451689687e+00
RINT18847 nd8152 nd8183 4.662451689687e+00
RINT18848 nd8153 nd8184 1.357228719451e+01
RINT18849 nd8154 nd8185 1.171973671568e+01
RINT18850 nd8155 nd8186 1.171973671568e+01
RINT18851 nd8156 nd8187 6.799630807155e+02
RINT18852 nd8157 nd8188 2.412121035800e+01
RINT18853 nd8158 nd8189 2.429181791977e+01
RINT18854 nd8159 nd8190 2.429181791977e+01
RINT18855 nd8160 nd8191 1.271962224384e+03
RINT18856 nd8161 nd8192 1.410120026542e+02
RINT18857 nd8162 nd8193 2.783177502845e+02
RINT18858 nd8163 nd8194 2.783177502845e+02
RINT18859 nd8164 nd8195 2.783177502845e+02
RINT18860 nd8165 nd8196 2.783177502845e+02
RINT18861 nd8166 nd8197 2.783177502845e+02
RINT18862 nd8167 nd8198 2.783177502845e+02
RINT18863 nd8168 nd8199 2.783177502845e+02
RINT18864 nd8169 nd8200 5.371885815399e+01
RINT18865 nd8170 nd8201 5.533517256115e+01
RINT18866 nd8171 nd8202 1.270102159742e+03
RINT18867 nd8172 nd8203 9.135281555084e+01
RINT18868 nd8173 nd8204 2.026342478141e+03
RINT18869 nd8174 nd8205 8.443093658921e+00
RINT18870 nd8175 nd8206 8.443093658921e+00
RINT18871 nd8176 nd8207 8.443093658921e+00
RINT18872 nd8177 nd8208 8.443093658921e+00
RINT18873 nd8178 nd8209 8.443093658921e+00
RINT18874 nd8179 nd8210 8.443093658921e+00
RINT18875 nd8180 nd8211 8.443093658921e+00
RINT18876 nd8181 nd8212 8.443093658921e+00
RINT18877 nd8182 nd8213 8.443093658921e+00
RINT18878 nd8183 nd8214 8.443093658921e+00
RINT18879 nd8184 nd8215 1.357228719451e+01
RINT18880 nd8185 nd8216 1.171973671568e+01
RINT18881 nd8186 nd8217 1.171973671568e+01
RINT18882 nd8187 nd8218 6.799630807155e+02
RINT18883 nd8188 nd8219 2.412121035800e+01
RINT18884 nd8189 nd8220 2.429181791977e+01
RINT18885 nd8190 nd8221 2.429181791977e+01
RINT18886 nd8191 nd8222 1.271962224384e+03
RINT18887 nd8192 nd8223 1.410120026542e+02
RINT18888 nd8193 nd8224 2.783177502845e+02
RINT18889 nd8194 nd8225 2.783177502845e+02
RINT18890 nd8195 nd8226 2.783177502845e+02
RINT18891 nd8196 nd8227 2.783177502845e+02
RINT18892 nd8197 nd8228 2.783177502845e+02
RINT18893 nd8198 nd8229 2.783177502845e+02
RINT18894 nd8199 nd8230 2.783177502845e+02
RINT18895 nd8200 nd8231 5.371885815399e+01
RINT18896 nd8201 nd8232 5.533517256115e+01
RINT18897 nd8202 nd8233 1.270102159742e+03
RINT18898 nd8203 nd8234 9.135281555084e+01
RINT18899 nd8204 nd8235 2.026342478141e+03
RINT18900 nd8205 nd8236 8.443093658921e+00
RINT18901 nd8206 nd8237 8.443093658921e+00
RINT18902 nd8207 nd8238 8.443093658921e+00
RINT18903 nd8208 nd8239 8.443093658921e+00
RINT18904 nd8209 nd8240 8.443093658921e+00
RINT18905 nd8210 nd8241 8.443093658921e+00
RINT18906 nd8211 nd8242 8.443093658921e+00
RINT18907 nd8212 nd8243 8.443093658921e+00
RINT18908 nd8213 nd8244 8.443093658921e+00
RINT18909 nd8214 nd8245 8.443093658921e+00
RINT18910 nd8215 nd8246 1.357228719451e+01
RINT18911 nd8216 nd8247 1.171973671568e+01
RINT18912 nd8217 nd8248 1.171973671568e+01
RINT18913 nd8218 nd8249 6.799630807155e+02
RINT18914 nd8219 nd8250 2.412121035800e+01
RINT18915 nd8220 nd8251 2.429181791977e+01
RINT18916 nd8221 nd8252 2.429181791977e+01
RINT18917 nd8222 nd8253 1.271962224384e+03
RINT18918 nd8223 nd8254 1.410120026542e+02
RINT18919 nd8224 nd8255 2.783177502845e+02
RINT18920 nd8225 nd8256 2.783177502845e+02
RINT18921 nd8226 nd8257 2.783177502845e+02
RINT18922 nd8227 nd8258 2.783177502845e+02
RINT18923 nd8228 nd8259 2.783177502845e+02
RINT18924 nd8229 nd8260 2.783177502845e+02
RINT18925 nd8230 nd8261 2.783177502845e+02
RINT18926 nd8231 nd8262 5.371885815399e+01
RINT18927 nd8232 nd8263 5.533517256115e+01
RINT18928 nd8233 nd8264 1.270102159742e+03
RINT18929 nd8234 nd8265 9.135281555084e+01
RINT18930 nd8235 nd8266 2.026342478141e+03
RINT18931 nd8236 nd8267 8.443093658921e+00
RINT18932 nd8237 nd8268 8.443093658921e+00
RINT18933 nd8238 nd8269 8.443093658921e+00
RINT18934 nd8239 nd8270 8.443093658921e+00
RINT18935 nd8240 nd8271 8.443093658921e+00
RINT18936 nd8241 nd8272 8.443093658921e+00
RINT18937 nd8242 nd8273 8.443093658921e+00
RINT18938 nd8243 nd8274 8.443093658921e+00
RINT18939 nd8244 nd8275 8.443093658921e+00
RINT18940 nd8245 nd8276 8.443093658921e+00
RINT18941 nd8246 nd8277 1.357228719451e+01
RINT18942 nd8247 nd8278 1.171973671568e+01
RINT18943 nd8248 nd8279 1.171973671568e+01
RINT18944 nd8249 nd8280 6.799630807155e+02
RINT18945 nd8250 nd8281 2.412121035800e+01
RINT18946 nd8251 nd8282 2.429181791977e+01
RINT18947 nd8252 nd8283 2.429181791977e+01
RINT18948 nd8253 nd8284 1.271962224384e+03
RINT18949 nd8254 nd8285 1.410120026542e+02
RINT18950 nd8255 nd8286 2.783177502845e+02
RINT18951 nd8256 nd8287 2.783177502845e+02
RINT18952 nd8257 nd8288 2.783177502845e+02
RINT18953 nd8258 nd8289 2.783177502845e+02
RINT18954 nd8259 nd8290 2.783177502845e+02
RINT18955 nd8260 nd8291 2.783177502845e+02
RINT18956 nd8261 nd8292 2.783177502845e+02
RINT18957 nd8262 nd8293 5.371885815399e+01
RINT18958 nd8263 nd8294 5.533517256115e+01
RINT18959 nd8264 nd8295 1.270102159742e+03
RINT18960 nd8265 nd8296 9.135281555084e+01
RINT18961 nd8266 nd8297 2.026342478141e+03
RINT18962 nd8267 nd8298 8.443093658921e+00
RINT18963 nd8268 nd8299 8.443093658921e+00
RINT18964 nd8269 nd8300 8.443093658921e+00
RINT18965 nd8270 nd8301 8.443093658921e+00
RINT18966 nd8271 nd8302 8.443093658921e+00
RINT18967 nd8272 nd8303 8.443093658921e+00
RINT18968 nd8273 nd8304 8.443093658921e+00
RINT18969 nd8274 nd8305 8.443093658921e+00
RINT18970 nd8275 nd8306 8.443093658921e+00
RINT18971 nd8276 nd8307 8.443093658921e+00
RINT18972 nd8277 nd8308 1.357228719451e+01
RINT18973 nd8278 nd8309 1.171973671568e+01
RINT18974 nd8279 nd8310 1.171973671568e+01
RINT18975 nd8280 nd8311 6.799630807155e+02
RINT18976 nd8281 nd8312 2.412121035800e+01
RINT18977 nd8282 nd8313 2.429181791977e+01
RINT18978 nd8283 nd8314 2.429181791977e+01
RINT18979 nd8284 nd8315 1.271962224384e+03
RINT18980 nd8285 nd8316 1.410120026542e+02
RINT18981 nd8286 nd8317 2.783177502845e+02
RINT18982 nd8287 nd8318 2.783177502845e+02
RINT18983 nd8288 nd8319 2.783177502845e+02
RINT18984 nd8289 nd8320 2.783177502845e+02
RINT18985 nd8290 nd8321 2.783177502845e+02
RINT18986 nd8291 nd8322 2.783177502845e+02
RINT18987 nd8292 nd8323 2.783177502845e+02
RINT18988 nd8293 nd8324 5.371885815399e+01
RINT18989 nd8294 nd8325 5.533517256115e+01
RINT18990 nd8295 nd8326 1.270102159742e+03
RINT18991 nd8296 nd8327 9.135281555084e+01
RINT18992 nd8297 nd8328 2.026342478141e+03
RINT18993 nd8298 nd8329 8.443093658921e+00
RINT18994 nd8299 nd8330 8.443093658921e+00
RINT18995 nd8300 nd8331 8.443093658921e+00
RINT18996 nd8301 nd8332 8.443093658921e+00
RINT18997 nd8302 nd8333 8.443093658921e+00
RINT18998 nd8303 nd8334 8.443093658921e+00
RINT18999 nd8304 nd8335 8.443093658921e+00
RINT19000 nd8305 nd8336 8.443093658921e+00
RINT19001 nd8306 nd8337 8.443093658921e+00
RINT19002 nd8307 nd8338 8.443093658921e+00
RINT19003 nd8308 nd8339 7.494898898358e+00
RINT19004 nd8309 nd8340 6.471882044678e+00
RINT19005 nd8310 nd8341 6.471882044678e+00
RINT19006 nd8311 nd8342 3.754897366627e+02
RINT19007 nd8312 nd8343 1.332023338058e+01
RINT19008 nd8313 nd8344 1.341444641988e+01
RINT19009 nd8314 nd8345 1.341444641988e+01
RINT19010 nd8315 nd8346 3.942767563891e+03
RINT19011 nd8316 nd8347 6.216370766103e+02
RINT19012 nd8317 nd8348 1.083955004199e+03
RINT19013 nd8318 nd8349 1.083955004199e+03
RINT19014 nd8319 nd8350 1.083955004199e+03
RINT19015 nd8320 nd8351 1.083955004199e+03
RINT19016 nd8321 nd8352 1.083955004199e+03
RINT19017 nd8322 nd8353 1.083955004199e+03
RINT19018 nd8323 nd8354 1.083955004199e+03
RINT19019 nd8324 nd8355 2.368141244230e+02
RINT19020 nd8325 nd8356 2.376222816266e+02
RINT19021 nd8326 nd8357 7.013767938611e+02
RINT19022 nd8327 nd8358 5.044692223361e+01
RINT19023 nd8328 nd8359 1.118988405525e+03
RINT19024 nd8329 nd8360 4.662451689687e+00
RINT19025 nd8330 nd8361 4.662451689687e+00
RINT19026 nd8331 nd8362 4.662451689687e+00
RINT19027 nd8332 nd8363 4.662451689687e+00
RINT19028 nd8333 nd8364 4.662451689687e+00
RINT19029 nd8334 nd8365 4.662451689687e+00
RINT19030 nd8335 nd8366 4.662451689687e+00
RINT19031 nd8336 nd8367 4.662451689687e+00
RINT19032 nd8337 nd8368 4.662451689687e+00
RINT19033 nd8338 nd8369 4.662451689687e+00
RINT19034 nd8339 nd8370 5.918933645378e+00
RINT19035 nd8340 nd8371 5.111028301069e+00
RINT19036 nd8341 nd8372 5.111028301069e+00
RINT19037 nd8342 nd8373 2.965348653754e+02
RINT19038 nd8343 nd8374 1.051936504946e+01
RINT19039 nd8344 nd8375 1.059376775131e+01
RINT19040 nd8345 nd8376 1.059376775131e+01
RINT19041 nd8346 nd8377 3.677205321604e+03
RINT19042 nd8347 nd8378 6.128675536007e+02
RINT19043 nd8348 nd8379 1.050630091887e+03
RINT19044 nd8349 nd8380 1.050630091887e+03
RINT19045 nd8350 nd8381 1.050630091887e+03
RINT19046 nd8351 nd8382 1.050630091887e+03
RINT19047 nd8352 nd8383 1.050630091887e+03
RINT19048 nd8353 nd8384 1.050630091887e+03
RINT19049 nd8354 nd8385 1.050630091887e+03
RINT19050 nd8355 nd8386 2.334733537526e+02
RINT19051 nd8356 nd8387 2.334733537526e+02
RINT19052 nd8357 nd8388 5.538970918181e+02
RINT19053 nd8358 nd8389 3.983936132610e+01
RINT19054 nd8359 nd8390 8.836967932549e+02
RINT19055 nd8360 nd8391 3.682069971895e+00
RINT19056 nd8361 nd8392 3.682069971895e+00
RINT19057 nd8362 nd8393 3.682069971895e+00
RINT19058 nd8363 nd8394 3.682069971895e+00
RINT19059 nd8364 nd8395 3.682069971895e+00
RINT19060 nd8365 nd8396 3.682069971895e+00
RINT19061 nd8366 nd8397 3.682069971895e+00
RINT19062 nd8367 nd8398 3.682069971895e+00
RINT19063 nd8368 nd8399 3.682069971895e+00
RINT19064 nd8369 nd8400 3.682069971895e+00
RINT19065 nd8370 nd8401 1.042035668855e+01
RINT19066 nd8371 nd8402 8.998029228461e+00
RINT19067 nd8372 nd8403 8.998029228461e+00
RINT19068 nd8373 nd8404 5.220533381408e+02
RINT19069 nd8374 nd8405 1.851947369575e+01
RINT19070 nd8375 nd8406 1.865046058263e+01
RINT19071 nd8376 nd8407 1.865046058263e+01
RINT19072 nd8377 nd8408 7.408377398100e+02
RINT19073 nd8378 nd8409 1.234729566350e+02
RINT19074 nd8379 nd8410 2.116679256600e+02
RINT19075 nd8380 nd8411 2.116679256600e+02
RINT19076 nd8381 nd8412 2.116679256600e+02
RINT19077 nd8382 nd8413 2.116679256600e+02
RINT19078 nd8383 nd8414 2.116679256600e+02
RINT19079 nd8384 nd8415 2.116679256600e+02
RINT19080 nd8385 nd8416 2.116679256600e+02
RINT19081 nd8386 nd8417 4.703731681333e+01
RINT19082 nd8387 nd8418 4.703731681333e+01
RINT19083 nd8388 nd8419 9.751427556557e+02
RINT19084 nd8389 nd8420 7.013769373582e+01
RINT19085 nd8390 nd8421 1.555759253601e+03
RINT19086 nd8391 nd8422 6.482330223337e+00
RINT19087 nd8392 nd8423 6.482330223337e+00
RINT19088 nd8393 nd8424 6.482330223337e+00
RINT19089 nd8394 nd8425 6.482330223337e+00
RINT19090 nd8395 nd8426 6.482330223337e+00
RINT19091 nd8396 nd8427 6.482330223337e+00
RINT19092 nd8397 nd8428 6.482330223337e+00
RINT19093 nd8398 nd8429 6.482330223337e+00
RINT19094 nd8399 nd8430 6.482330223337e+00
RINT19095 nd8400 nd8431 6.482330223337e+00
RINT19096 nd8401 nd8432 1.042035668855e+01
RINT19097 nd8402 nd8433 8.998029228461e+00
RINT19098 nd8403 nd8434 8.998029228461e+00
RINT19099 nd8404 nd8435 5.220533381408e+02
RINT19100 nd8405 nd8436 1.851947369575e+01
RINT19101 nd8406 nd8437 1.865046058263e+01
RINT19102 nd8407 nd8438 1.865046058263e+01
RINT19103 nd8408 nd8439 7.408377398100e+02
RINT19104 nd8409 nd8440 1.234729566350e+02
RINT19105 nd8410 nd8441 2.116679256600e+02
RINT19106 nd8411 nd8442 2.116679256600e+02
RINT19107 nd8412 nd8443 2.116679256600e+02
RINT19108 nd8413 nd8444 2.116679256600e+02
RINT19109 nd8414 nd8445 2.116679256600e+02
RINT19110 nd8415 nd8446 2.116679256600e+02
RINT19111 nd8416 nd8447 2.116679256600e+02
RINT19112 nd8417 nd8448 4.703731681333e+01
RINT19113 nd8418 nd8449 4.703731681333e+01
RINT19114 nd8419 nd8450 9.751427556557e+02
RINT19115 nd8420 nd8451 7.013769373582e+01
RINT19116 nd8421 nd8452 1.555759253601e+03
RINT19117 nd8422 nd8453 6.482330223337e+00
RINT19118 nd8423 nd8454 6.482330223337e+00
RINT19119 nd8424 nd8455 6.482330223337e+00
RINT19120 nd8425 nd8456 6.482330223337e+00
RINT19121 nd8426 nd8457 6.482330223337e+00
RINT19122 nd8427 nd8458 6.482330223337e+00
RINT19123 nd8428 nd8459 6.482330223337e+00
RINT19124 nd8429 nd8460 6.482330223337e+00
RINT19125 nd8430 nd8461 6.482330223337e+00
RINT19126 nd8431 nd8462 6.482330223337e+00
RINT19127 nd8463 nd8494 1.042035668855e+01
RINT19128 nd8464 nd8495 8.998029228461e+00
RINT19129 nd8465 nd8496 8.998029228461e+00
RINT19130 nd8466 nd8497 5.220533381408e+02
RINT19131 nd8467 nd8498 1.851947369575e+01
RINT19132 nd8468 nd8499 1.865046058263e+01
RINT19133 nd8469 nd8500 1.865046058263e+01
RINT19134 nd8470 nd8501 7.408377398100e+02
RINT19135 nd8471 nd8502 1.234729566350e+02
RINT19136 nd8472 nd8503 2.116679256600e+02
RINT19137 nd8473 nd8504 2.116679256600e+02
RINT19138 nd8474 nd8505 2.116679256600e+02
RINT19139 nd8475 nd8506 2.116679256600e+02
RINT19140 nd8476 nd8507 2.116679256600e+02
RINT19141 nd8477 nd8508 2.116679256600e+02
RINT19142 nd8478 nd8509 2.116679256600e+02
RINT19143 nd8479 nd8510 4.703731681333e+01
RINT19144 nd8480 nd8511 4.703731681333e+01
RINT19145 nd8481 nd8512 9.751427556557e+02
RINT19146 nd8482 nd8513 7.013769373582e+01
RINT19147 nd8483 nd8514 1.555759253601e+03
RINT19148 nd8484 nd8515 6.482330223337e+00
RINT19149 nd8485 nd8516 6.482330223337e+00
RINT19150 nd8486 nd8517 6.482330223337e+00
RINT19151 nd8487 nd8518 6.482330223337e+00
RINT19152 nd8488 nd8519 6.482330223337e+00
RINT19153 nd8489 nd8520 6.482330223337e+00
RINT19154 nd8490 nd8521 6.482330223337e+00
RINT19155 nd8491 nd8522 6.482330223337e+00
RINT19156 nd8492 nd8523 6.482330223337e+00
RINT19157 nd8493 nd8524 6.482330223337e+00
RINT19158 nd8494 nd8525 1.042035668855e+01
RINT19159 nd8495 nd8526 8.998029228461e+00
RINT19160 nd8496 nd8527 8.998029228461e+00
RINT19161 nd8497 nd8528 5.220533381408e+02
RINT19162 nd8498 nd8529 1.851947369575e+01
RINT19163 nd8499 nd8530 1.865046058263e+01
RINT19164 nd8500 nd8531 1.865046058263e+01
RINT19165 nd8501 nd8532 7.408377398100e+02
RINT19166 nd8502 nd8533 1.234729566350e+02
RINT19167 nd8503 nd8534 2.116679256600e+02
RINT19168 nd8504 nd8535 2.116679256600e+02
RINT19169 nd8505 nd8536 2.116679256600e+02
RINT19170 nd8506 nd8537 2.116679256600e+02
RINT19171 nd8507 nd8538 2.116679256600e+02
RINT19172 nd8508 nd8539 2.116679256600e+02
RINT19173 nd8509 nd8540 2.116679256600e+02
RINT19174 nd8510 nd8541 4.703731681333e+01
RINT19175 nd8511 nd8542 4.703731681333e+01
RINT19176 nd8512 nd8543 9.751427556557e+02
RINT19177 nd8513 nd8544 7.013769373582e+01
RINT19178 nd8514 nd8545 1.555759253601e+03
RINT19179 nd8515 nd8546 6.482330223337e+00
RINT19180 nd8516 nd8547 6.482330223337e+00
RINT19181 nd8517 nd8548 6.482330223337e+00
RINT19182 nd8518 nd8549 6.482330223337e+00
RINT19183 nd8519 nd8550 6.482330223337e+00
RINT19184 nd8520 nd8551 6.482330223337e+00
RINT19185 nd8521 nd8552 6.482330223337e+00
RINT19186 nd8522 nd8553 6.482330223337e+00
RINT19187 nd8523 nd8554 6.482330223337e+00
RINT19188 nd8524 nd8555 6.482330223337e+00
RINT19189 nd8525 nd8556 5.918933645378e+00
RINT19190 nd8526 nd8557 5.111028301069e+00
RINT19191 nd8527 nd8558 5.111028301069e+00
RINT19192 nd8528 nd8559 2.965348653754e+02
RINT19193 nd8529 nd8560 1.051936504946e+01
RINT19194 nd8530 nd8561 1.059376775131e+01
RINT19195 nd8531 nd8562 1.059376775131e+01
RINT19196 nd8532 nd8563 3.677205321604e+03
RINT19197 nd8533 nd8564 6.128675536007e+02
RINT19198 nd8534 nd8565 1.050630091887e+03
RINT19199 nd8535 nd8566 1.050630091887e+03
RINT19200 nd8536 nd8567 1.050630091887e+03
RINT19201 nd8537 nd8568 1.050630091887e+03
RINT19202 nd8538 nd8569 1.050630091887e+03
RINT19203 nd8539 nd8570 1.050630091887e+03
RINT19204 nd8540 nd8571 1.050630091887e+03
RINT19205 nd8541 nd8572 2.334733537526e+02
RINT19206 nd8542 nd8573 2.334733537526e+02
RINT19207 nd8543 nd8574 5.538970918181e+02
RINT19208 nd8544 nd8575 3.983936132610e+01
RINT19209 nd8545 nd8576 8.836967932549e+02
RINT19210 nd8546 nd8577 3.682069971895e+00
RINT19211 nd8547 nd8578 3.682069971895e+00
RINT19212 nd8548 nd8579 3.682069971895e+00
RINT19213 nd8549 nd8580 3.682069971895e+00
RINT19214 nd8550 nd8581 3.682069971895e+00
RINT19215 nd8551 nd8582 3.682069971895e+00
RINT19216 nd8552 nd8583 3.682069971895e+00
RINT19217 nd8553 nd8584 3.682069971895e+00
RINT19218 nd8554 nd8585 3.682069971895e+00
RINT19219 nd8555 nd8586 3.682069971895e+00
RINT19220 nd8556 nd8587 7.494898898358e+00
RINT19221 nd8557 nd8588 6.471882044678e+00
RINT19222 nd8558 nd8589 6.471882044678e+00
RINT19223 nd8559 nd8590 3.754897366627e+02
RINT19224 nd8560 nd8591 1.332023338058e+01
RINT19225 nd8561 nd8592 1.341444641988e+01
RINT19226 nd8562 nd8593 1.341444641988e+01
RINT19227 nd8563 nd8594 3.942767563891e+03
RINT19228 nd8564 nd8595 6.216370766103e+02
RINT19229 nd8565 nd8596 1.083955004199e+03
RINT19230 nd8566 nd8597 1.083955004199e+03
RINT19231 nd8567 nd8598 1.083955004199e+03
RINT19232 nd8568 nd8599 1.083955004199e+03
RINT19233 nd8569 nd8600 1.083955004199e+03
RINT19234 nd8570 nd8601 1.083955004199e+03
RINT19235 nd8571 nd8602 1.083955004199e+03
RINT19236 nd8572 nd8603 2.368141244230e+02
RINT19237 nd8573 nd8604 2.376222816265e+02
RINT19238 nd8574 nd8605 7.013767938611e+02
RINT19239 nd8575 nd8606 5.044692223361e+01
RINT19240 nd8576 nd8607 1.118988405525e+03
RINT19241 nd8577 nd8608 4.662451689687e+00
RINT19242 nd8578 nd8609 4.662451689687e+00
RINT19243 nd8579 nd8610 4.662451689687e+00
RINT19244 nd8580 nd8611 4.662451689687e+00
RINT19245 nd8581 nd8612 4.662451689687e+00
RINT19246 nd8582 nd8613 4.662451689687e+00
RINT19247 nd8583 nd8614 4.662451689687e+00
RINT19248 nd8584 nd8615 4.662451689687e+00
RINT19249 nd8585 nd8616 4.662451689687e+00
RINT19250 nd8586 nd8617 4.662451689687e+00
RINT19251 nd8587 nd8618 1.357228719451e+01
RINT19252 nd8588 nd8619 1.171973671568e+01
RINT19253 nd8589 nd8620 1.171973671568e+01
RINT19254 nd8590 nd8621 6.799630807155e+02
RINT19255 nd8591 nd8622 2.412121035800e+01
RINT19256 nd8592 nd8623 2.429181791977e+01
RINT19257 nd8593 nd8624 2.429181791977e+01
RINT19258 nd8594 nd8625 1.271962224384e+03
RINT19259 nd8595 nd8626 1.410120026542e+02
RINT19260 nd8596 nd8627 2.783177502845e+02
RINT19261 nd8597 nd8628 2.783177502845e+02
RINT19262 nd8598 nd8629 2.783177502845e+02
RINT19263 nd8599 nd8630 2.783177502845e+02
RINT19264 nd8600 nd8631 2.783177502845e+02
RINT19265 nd8601 nd8632 2.783177502845e+02
RINT19266 nd8602 nd8633 2.783177502845e+02
RINT19267 nd8603 nd8634 5.371885815399e+01
RINT19268 nd8604 nd8635 5.533517256115e+01
RINT19269 nd8605 nd8636 1.270102159742e+03
RINT19270 nd8606 nd8637 9.135281555084e+01
RINT19271 nd8607 nd8638 2.026342478141e+03
RINT19272 nd8608 nd8639 8.443093658921e+00
RINT19273 nd8609 nd8640 8.443093658921e+00
RINT19274 nd8610 nd8641 8.443093658921e+00
RINT19275 nd8611 nd8642 8.443093658921e+00
RINT19276 nd8612 nd8643 8.443093658921e+00
RINT19277 nd8613 nd8644 8.443093658921e+00
RINT19278 nd8614 nd8645 8.443093658921e+00
RINT19279 nd8615 nd8646 8.443093658921e+00
RINT19280 nd8616 nd8647 8.443093658921e+00
RINT19281 nd8617 nd8648 8.443093658921e+00
RINT19282 nd8618 nd8649 1.357228719451e+01
RINT19283 nd8619 nd8650 1.171973671568e+01
RINT19284 nd8620 nd8651 1.171973671568e+01
RINT19285 nd8621 nd8652 6.799630807155e+02
RINT19286 nd8622 nd8653 2.412121035800e+01
RINT19287 nd8623 nd8654 2.429181791977e+01
RINT19288 nd8624 nd8655 2.429181791977e+01
RINT19289 nd8625 nd8656 1.271962224384e+03
RINT19290 nd8626 nd8657 1.410120026542e+02
RINT19291 nd8627 nd8658 2.783177502845e+02
RINT19292 nd8628 nd8659 2.783177502845e+02
RINT19293 nd8629 nd8660 2.783177502845e+02
RINT19294 nd8630 nd8661 2.783177502845e+02
RINT19295 nd8631 nd8662 2.783177502845e+02
RINT19296 nd8632 nd8663 2.783177502845e+02
RINT19297 nd8633 nd8664 2.783177502845e+02
RINT19298 nd8634 nd8665 5.371885815399e+01
RINT19299 nd8635 nd8666 5.533517256115e+01
RINT19300 nd8636 nd8667 1.270102159742e+03
RINT19301 nd8637 nd8668 9.135281555084e+01
RINT19302 nd8638 nd8669 2.026342478141e+03
RINT19303 nd8639 nd8670 8.443093658921e+00
RINT19304 nd8640 nd8671 8.443093658921e+00
RINT19305 nd8641 nd8672 8.443093658921e+00
RINT19306 nd8642 nd8673 8.443093658921e+00
RINT19307 nd8643 nd8674 8.443093658921e+00
RINT19308 nd8644 nd8675 8.443093658921e+00
RINT19309 nd8645 nd8676 8.443093658921e+00
RINT19310 nd8646 nd8677 8.443093658921e+00
RINT19311 nd8647 nd8678 8.443093658921e+00
RINT19312 nd8648 nd8679 8.443093658921e+00
RINT19313 nd8649 nd8680 1.357228719451e+01
RINT19314 nd8650 nd8681 1.171973671568e+01
RINT19315 nd8651 nd8682 1.171973671568e+01
RINT19316 nd8652 nd8683 6.799630807155e+02
RINT19317 nd8653 nd8684 2.412121035800e+01
RINT19318 nd8654 nd8685 2.429181791977e+01
RINT19319 nd8655 nd8686 2.429181791977e+01
RINT19320 nd8656 nd8687 1.271962224384e+03
RINT19321 nd8657 nd8688 1.410120026542e+02
RINT19322 nd8658 nd8689 2.783177502845e+02
RINT19323 nd8659 nd8690 2.783177502845e+02
RINT19324 nd8660 nd8691 2.783177502845e+02
RINT19325 nd8661 nd8692 2.783177502845e+02
RINT19326 nd8662 nd8693 2.783177502845e+02
RINT19327 nd8663 nd8694 2.783177502845e+02
RINT19328 nd8664 nd8695 2.783177502845e+02
RINT19329 nd8665 nd8696 5.371885815399e+01
RINT19330 nd8666 nd8697 5.533517256115e+01
RINT19331 nd8667 nd8698 1.270102159742e+03
RINT19332 nd8668 nd8699 9.135281555084e+01
RINT19333 nd8669 nd8700 2.026342478141e+03
RINT19334 nd8670 nd8701 8.443093658921e+00
RINT19335 nd8671 nd8702 8.443093658921e+00
RINT19336 nd8672 nd8703 8.443093658921e+00
RINT19337 nd8673 nd8704 8.443093658921e+00
RINT19338 nd8674 nd8705 8.443093658921e+00
RINT19339 nd8675 nd8706 8.443093658921e+00
RINT19340 nd8676 nd8707 8.443093658921e+00
RINT19341 nd8677 nd8708 8.443093658921e+00
RINT19342 nd8678 nd8709 8.443093658921e+00
RINT19343 nd8679 nd8710 8.443093658921e+00
RINT19344 nd8680 nd8711 1.357228719451e+01
RINT19345 nd8681 nd8712 1.171973671568e+01
RINT19346 nd8682 nd8713 1.171973671568e+01
RINT19347 nd8683 nd8714 6.799630807155e+02
RINT19348 nd8684 nd8715 2.412121035800e+01
RINT19349 nd8685 nd8716 2.429181791977e+01
RINT19350 nd8686 nd8717 2.429181791977e+01
RINT19351 nd8687 nd8718 1.271962224384e+03
RINT19352 nd8688 nd8719 1.410120026542e+02
RINT19353 nd8689 nd8720 2.783177502845e+02
RINT19354 nd8690 nd8721 2.783177502845e+02
RINT19355 nd8691 nd8722 2.783177502845e+02
RINT19356 nd8692 nd8723 2.783177502845e+02
RINT19357 nd8693 nd8724 2.783177502845e+02
RINT19358 nd8694 nd8725 2.783177502845e+02
RINT19359 nd8695 nd8726 2.783177502845e+02
RINT19360 nd8696 nd8727 5.371885815399e+01
RINT19361 nd8697 nd8728 5.533517256115e+01
RINT19362 nd8698 nd8729 1.270102159742e+03
RINT19363 nd8699 nd8730 9.135281555084e+01
RINT19364 nd8700 nd8731 2.026342478141e+03
RINT19365 nd8701 nd8732 8.443093658921e+00
RINT19366 nd8702 nd8733 8.443093658921e+00
RINT19367 nd8703 nd8734 8.443093658921e+00
RINT19368 nd8704 nd8735 8.443093658921e+00
RINT19369 nd8705 nd8736 8.443093658921e+00
RINT19370 nd8706 nd8737 8.443093658921e+00
RINT19371 nd8707 nd8738 8.443093658921e+00
RINT19372 nd8708 nd8739 8.443093658921e+00
RINT19373 nd8709 nd8740 8.443093658921e+00
RINT19374 nd8710 nd8741 8.443093658921e+00
RINT19375 nd8711 nd8742 1.357228719451e+01
RINT19376 nd8712 nd8743 1.171973671568e+01
RINT19377 nd8713 nd8744 1.171973671568e+01
RINT19378 nd8714 nd8745 6.799630807155e+02
RINT19379 nd8715 nd8746 2.412121035800e+01
RINT19380 nd8716 nd8747 2.429181791977e+01
RINT19381 nd8717 nd8748 2.429181791977e+01
RINT19382 nd8718 nd8749 1.271962224384e+03
RINT19383 nd8719 nd8750 1.410120026542e+02
RINT19384 nd8720 nd8751 2.783177502845e+02
RINT19385 nd8721 nd8752 2.783177502845e+02
RINT19386 nd8722 nd8753 2.783177502845e+02
RINT19387 nd8723 nd8754 2.783177502845e+02
RINT19388 nd8724 nd8755 2.783177502845e+02
RINT19389 nd8725 nd8756 2.783177502845e+02
RINT19390 nd8726 nd8757 2.783177502845e+02
RINT19391 nd8727 nd8758 5.371885815399e+01
RINT19392 nd8728 nd8759 5.533517256115e+01
RINT19393 nd8729 nd8760 1.270102159742e+03
RINT19394 nd8730 nd8761 9.135281555084e+01
RINT19395 nd8731 nd8762 2.026342478141e+03
RINT19396 nd8732 nd8763 8.443093658921e+00
RINT19397 nd8733 nd8764 8.443093658921e+00
RINT19398 nd8734 nd8765 8.443093658921e+00
RINT19399 nd8735 nd8766 8.443093658921e+00
RINT19400 nd8736 nd8767 8.443093658921e+00
RINT19401 nd8737 nd8768 8.443093658921e+00
RINT19402 nd8738 nd8769 8.443093658921e+00
RINT19403 nd8739 nd8770 8.443093658921e+00
RINT19404 nd8740 nd8771 8.443093658921e+00
RINT19405 nd8741 nd8772 8.443093658921e+00
RINT19406 nd8742 nd8773 7.494898898358e+00
RINT19407 nd8743 nd8774 6.471882044678e+00
RINT19408 nd8744 nd8775 6.471882044678e+00
RINT19409 nd8745 nd8776 3.754897366627e+02
RINT19410 nd8746 nd8777 1.332023338058e+01
RINT19411 nd8747 nd8778 1.341444641988e+01
RINT19412 nd8748 nd8779 1.341444641988e+01
RINT19413 nd8749 nd8780 3.942767563891e+03
RINT19414 nd8750 nd8781 6.216370766103e+02
RINT19415 nd8751 nd8782 1.083955004199e+03
RINT19416 nd8752 nd8783 1.083955004199e+03
RINT19417 nd8753 nd8784 1.083955004199e+03
RINT19418 nd8754 nd8785 1.083955004199e+03
RINT19419 nd8755 nd8786 1.083955004199e+03
RINT19420 nd8756 nd8787 1.083955004199e+03
RINT19421 nd8757 nd8788 1.083955004199e+03
RINT19422 nd8758 nd8789 2.368141244230e+02
RINT19423 nd8759 nd8790 2.376222816266e+02
RINT19424 nd8760 nd8791 7.013767938611e+02
RINT19425 nd8761 nd8792 5.044692223361e+01
RINT19426 nd8762 nd8793 1.118988405525e+03
RINT19427 nd8763 nd8794 4.662451689687e+00
RINT19428 nd8764 nd8795 4.662451689687e+00
RINT19429 nd8765 nd8796 4.662451689687e+00
RINT19430 nd8766 nd8797 4.662451689687e+00
RINT19431 nd8767 nd8798 4.662451689687e+00
RINT19432 nd8768 nd8799 4.662451689687e+00
RINT19433 nd8769 nd8800 4.662451689687e+00
RINT19434 nd8770 nd8801 4.662451689687e+00
RINT19435 nd8771 nd8802 4.662451689687e+00
RINT19436 nd8772 nd8803 4.662451689687e+00
RINT19437 nd8773 nd8804 7.494898898358e+00
RINT19438 nd8774 nd8805 6.471882044678e+00
RINT19439 nd8775 nd8806 6.471882044678e+00
RINT19440 nd8776 nd8807 3.754897366627e+02
RINT19441 nd8777 nd8808 1.332023338058e+01
RINT19442 nd8778 nd8809 1.341444641988e+01
RINT19443 nd8779 nd8810 1.341444641988e+01
RINT19444 nd8780 nd8811 3.942767563891e+03
RINT19445 nd8781 nd8812 6.216370766103e+02
RINT19446 nd8782 nd8813 1.083955004199e+03
RINT19447 nd8783 nd8814 1.083955004199e+03
RINT19448 nd8784 nd8815 1.083955004199e+03
RINT19449 nd8785 nd8816 1.083955004199e+03
RINT19450 nd8786 nd8817 1.083955004199e+03
RINT19451 nd8787 nd8818 1.083955004199e+03
RINT19452 nd8788 nd8819 1.083955004199e+03
RINT19453 nd8789 nd8820 2.368141244230e+02
RINT19454 nd8790 nd8821 2.376222816266e+02
RINT19455 nd8791 nd8822 7.013767938611e+02
RINT19456 nd8792 nd8823 5.044692223361e+01
RINT19457 nd8793 nd8824 1.118988405525e+03
RINT19458 nd8794 nd8825 4.662451689687e+00
RINT19459 nd8795 nd8826 4.662451689687e+00
RINT19460 nd8796 nd8827 4.662451689687e+00
RINT19461 nd8797 nd8828 4.662451689687e+00
RINT19462 nd8798 nd8829 4.662451689687e+00
RINT19463 nd8799 nd8830 4.662451689687e+00
RINT19464 nd8800 nd8831 4.662451689687e+00
RINT19465 nd8801 nd8832 4.662451689687e+00
RINT19466 nd8802 nd8833 4.662451689687e+00
RINT19467 nd8803 nd8834 4.662451689687e+00
RINT19468 nd8804 nd8835 1.357228719451e+01
RINT19469 nd8805 nd8836 1.171973671568e+01
RINT19470 nd8806 nd8837 1.171973671568e+01
RINT19471 nd8807 nd8838 6.799630807155e+02
RINT19472 nd8808 nd8839 2.412121035800e+01
RINT19473 nd8809 nd8840 2.429181791977e+01
RINT19474 nd8810 nd8841 2.429181791977e+01
RINT19475 nd8811 nd8842 1.271962224384e+03
RINT19476 nd8812 nd8843 1.410120026542e+02
RINT19477 nd8813 nd8844 2.783177502845e+02
RINT19478 nd8814 nd8845 2.783177502845e+02
RINT19479 nd8815 nd8846 2.783177502845e+02
RINT19480 nd8816 nd8847 2.783177502845e+02
RINT19481 nd8817 nd8848 2.783177502845e+02
RINT19482 nd8818 nd8849 2.783177502845e+02
RINT19483 nd8819 nd8850 2.783177502845e+02
RINT19484 nd8820 nd8851 5.371885815399e+01
RINT19485 nd8821 nd8852 5.533517256115e+01
RINT19486 nd8822 nd8853 1.270102159742e+03
RINT19487 nd8823 nd8854 9.135281555084e+01
RINT19488 nd8824 nd8855 2.026342478141e+03
RINT19489 nd8825 nd8856 8.443093658921e+00
RINT19490 nd8826 nd8857 8.443093658921e+00
RINT19491 nd8827 nd8858 8.443093658921e+00
RINT19492 nd8828 nd8859 8.443093658921e+00
RINT19493 nd8829 nd8860 8.443093658921e+00
RINT19494 nd8830 nd8861 8.443093658921e+00
RINT19495 nd8831 nd8862 8.443093658921e+00
RINT19496 nd8832 nd8863 8.443093658921e+00
RINT19497 nd8833 nd8864 8.443093658921e+00
RINT19498 nd8834 nd8865 8.443093658921e+00
RINT19499 nd8835 nd8866 1.357228719451e+01
RINT19500 nd8836 nd8867 1.171973671568e+01
RINT19501 nd8837 nd8868 1.171973671568e+01
RINT19502 nd8838 nd8869 6.799630807155e+02
RINT19503 nd8839 nd8870 2.412121035800e+01
RINT19504 nd8840 nd8871 2.429181791977e+01
RINT19505 nd8841 nd8872 2.429181791977e+01
RINT19506 nd8842 nd8873 1.271962224384e+03
RINT19507 nd8843 nd8874 1.410120026542e+02
RINT19508 nd8844 nd8875 2.783177502845e+02
RINT19509 nd8845 nd8876 2.783177502845e+02
RINT19510 nd8846 nd8877 2.783177502845e+02
RINT19511 nd8847 nd8878 2.783177502845e+02
RINT19512 nd8848 nd8879 2.783177502845e+02
RINT19513 nd8849 nd8880 2.783177502845e+02
RINT19514 nd8850 nd8881 2.783177502845e+02
RINT19515 nd8851 nd8882 5.371885815399e+01
RINT19516 nd8852 nd8883 5.533517256115e+01
RINT19517 nd8853 nd8884 1.270102159742e+03
RINT19518 nd8854 nd8885 9.135281555084e+01
RINT19519 nd8855 nd8886 2.026342478141e+03
RINT19520 nd8856 nd8887 8.443093658921e+00
RINT19521 nd8857 nd8888 8.443093658921e+00
RINT19522 nd8858 nd8889 8.443093658921e+00
RINT19523 nd8859 nd8890 8.443093658921e+00
RINT19524 nd8860 nd8891 8.443093658921e+00
RINT19525 nd8861 nd8892 8.443093658921e+00
RINT19526 nd8862 nd8893 8.443093658921e+00
RINT19527 nd8863 nd8894 8.443093658921e+00
RINT19528 nd8864 nd8895 8.443093658921e+00
RINT19529 nd8865 nd8896 8.443093658921e+00
RINT19530 nd8866 nd8897 1.357228719451e+01
RINT19531 nd8867 nd8898 1.171973671568e+01
RINT19532 nd8868 nd8899 1.171973671568e+01
RINT19533 nd8869 nd8900 6.799630807155e+02
RINT19534 nd8870 nd8901 2.412121035800e+01
RINT19535 nd8871 nd8902 2.429181791977e+01
RINT19536 nd8872 nd8903 2.429181791977e+01
RINT19537 nd8873 nd8904 1.271962224384e+03
RINT19538 nd8874 nd8905 1.410120026542e+02
RINT19539 nd8875 nd8906 2.783177502845e+02
RINT19540 nd8876 nd8907 2.783177502845e+02
RINT19541 nd8877 nd8908 2.783177502845e+02
RINT19542 nd8878 nd8909 2.783177502845e+02
RINT19543 nd8879 nd8910 2.783177502845e+02
RINT19544 nd8880 nd8911 2.783177502845e+02
RINT19545 nd8881 nd8912 2.783177502845e+02
RINT19546 nd8882 nd8913 5.371885815399e+01
RINT19547 nd8883 nd8914 5.533517256115e+01
RINT19548 nd8884 nd8915 1.270102159742e+03
RINT19549 nd8885 nd8916 9.135281555084e+01
RINT19550 nd8886 nd8917 2.026342478141e+03
RINT19551 nd8887 nd8918 8.443093658921e+00
RINT19552 nd8888 nd8919 8.443093658921e+00
RINT19553 nd8889 nd8920 8.443093658921e+00
RINT19554 nd8890 nd8921 8.443093658921e+00
RINT19555 nd8891 nd8922 8.443093658921e+00
RINT19556 nd8892 nd8923 8.443093658921e+00
RINT19557 nd8893 nd8924 8.443093658921e+00
RINT19558 nd8894 nd8925 8.443093658921e+00
RINT19559 nd8895 nd8926 8.443093658921e+00
RINT19560 nd8896 nd8927 8.443093658921e+00
RINT19561 nd8897 nd8928 1.357228719451e+01
RINT19562 nd8898 nd8929 1.171973671568e+01
RINT19563 nd8899 nd8930 1.171973671568e+01
RINT19564 nd8900 nd8931 6.799630807155e+02
RINT19565 nd8901 nd8932 2.412121035800e+01
RINT19566 nd8902 nd8933 2.429181791977e+01
RINT19567 nd8903 nd8934 2.429181791977e+01
RINT19568 nd8904 nd8935 1.271962224384e+03
RINT19569 nd8905 nd8936 1.410120026542e+02
RINT19570 nd8906 nd8937 2.783177502845e+02
RINT19571 nd8907 nd8938 2.783177502845e+02
RINT19572 nd8908 nd8939 2.783177502845e+02
RINT19573 nd8909 nd8940 2.783177502845e+02
RINT19574 nd8910 nd8941 2.783177502845e+02
RINT19575 nd8911 nd8942 2.783177502845e+02
RINT19576 nd8912 nd8943 2.783177502845e+02
RINT19577 nd8913 nd8944 5.371885815399e+01
RINT19578 nd8914 nd8945 5.533517256115e+01
RINT19579 nd8915 nd8946 1.270102159742e+03
RINT19580 nd8916 nd8947 9.135281555084e+01
RINT19581 nd8917 nd8948 2.026342478141e+03
RINT19582 nd8918 nd8949 8.443093658921e+00
RINT19583 nd8919 nd8950 8.443093658921e+00
RINT19584 nd8920 nd8951 8.443093658921e+00
RINT19585 nd8921 nd8952 8.443093658921e+00
RINT19586 nd8922 nd8953 8.443093658921e+00
RINT19587 nd8923 nd8954 8.443093658921e+00
RINT19588 nd8924 nd8955 8.443093658921e+00
RINT19589 nd8925 nd8956 8.443093658921e+00
RINT19590 nd8926 nd8957 8.443093658921e+00
RINT19591 nd8927 nd8958 8.443093658921e+00
RINT19592 nd8928 nd8959 1.357228719451e+01
RINT19593 nd8929 nd8960 1.171973671568e+01
RINT19594 nd8930 nd8961 1.171973671568e+01
RINT19595 nd8931 nd8962 6.799630807155e+02
RINT19596 nd8932 nd8963 2.412121035800e+01
RINT19597 nd8933 nd8964 2.429181791977e+01
RINT19598 nd8934 nd8965 2.429181791977e+01
RINT19599 nd8935 nd8966 1.271962224384e+03
RINT19600 nd8936 nd8967 1.410120026542e+02
RINT19601 nd8937 nd8968 2.783177502845e+02
RINT19602 nd8938 nd8969 2.783177502845e+02
RINT19603 nd8939 nd8970 2.783177502845e+02
RINT19604 nd8940 nd8971 2.783177502845e+02
RINT19605 nd8941 nd8972 2.783177502845e+02
RINT19606 nd8942 nd8973 2.783177502845e+02
RINT19607 nd8943 nd8974 2.783177502845e+02
RINT19608 nd8944 nd8975 5.371885815399e+01
RINT19609 nd8945 nd8976 5.533517256115e+01
RINT19610 nd8946 nd8977 1.270102159742e+03
RINT19611 nd8947 nd8978 9.135281555084e+01
RINT19612 nd8948 nd8979 2.026342478141e+03
RINT19613 nd8949 nd8980 8.443093658921e+00
RINT19614 nd8950 nd8981 8.443093658921e+00
RINT19615 nd8951 nd8982 8.443093658921e+00
RINT19616 nd8952 nd8983 8.443093658921e+00
RINT19617 nd8953 nd8984 8.443093658921e+00
RINT19618 nd8954 nd8985 8.443093658921e+00
RINT19619 nd8955 nd8986 8.443093658921e+00
RINT19620 nd8956 nd8987 8.443093658921e+00
RINT19621 nd8957 nd8988 8.443093658921e+00
RINT19622 nd8958 nd8989 8.443093658921e+00
RINT19623 nd8959 nd8990 7.494898898358e+00
RINT19624 nd8960 nd8991 6.471882044678e+00
RINT19625 nd8961 nd8992 6.471882044678e+00
RINT19626 nd8962 nd8993 3.754897366627e+02
RINT19627 nd8963 nd8994 1.332023338058e+01
RINT19628 nd8964 nd8995 1.341444641988e+01
RINT19629 nd8965 nd8996 1.341444641988e+01
RINT19630 nd8966 nd8997 3.942767563891e+03
RINT19631 nd8967 nd8998 6.216370766103e+02
RINT19632 nd8968 nd8999 1.083955004199e+03
RINT19633 nd8969 nd9000 1.083955004199e+03
RINT19634 nd8970 nd9001 1.083955004199e+03
RINT19635 nd8971 nd9002 1.083955004199e+03
RINT19636 nd8972 nd9003 1.083955004199e+03
RINT19637 nd8973 nd9004 1.083955004199e+03
RINT19638 nd8974 nd9005 1.083955004199e+03
RINT19639 nd8975 nd9006 2.368141244230e+02
RINT19640 nd8976 nd9007 2.376222816266e+02
RINT19641 nd8977 nd9008 7.013767938611e+02
RINT19642 nd8978 nd9009 5.044692223361e+01
RINT19643 nd8979 nd9010 1.118988405525e+03
RINT19644 nd8980 nd9011 4.662451689687e+00
RINT19645 nd8981 nd9012 4.662451689687e+00
RINT19646 nd8982 nd9013 4.662451689687e+00
RINT19647 nd8983 nd9014 4.662451689687e+00
RINT19648 nd8984 nd9015 4.662451689687e+00
RINT19649 nd8985 nd9016 4.662451689687e+00
RINT19650 nd8986 nd9017 4.662451689687e+00
RINT19651 nd8987 nd9018 4.662451689687e+00
RINT19652 nd8988 nd9019 4.662451689687e+00
RINT19653 nd8989 nd9020 4.662451689687e+00
RINT19654 nd8990 nd9021 5.918933645378e+00
RINT19655 nd8991 nd9022 5.111028301069e+00
RINT19656 nd8992 nd9023 5.111028301069e+00
RINT19657 nd8993 nd9024 2.965348653754e+02
RINT19658 nd8994 nd9025 1.051936504946e+01
RINT19659 nd8995 nd9026 1.059376775131e+01
RINT19660 nd8996 nd9027 1.059376775131e+01
RINT19661 nd8997 nd9028 3.677205321604e+03
RINT19662 nd8998 nd9029 6.128675536007e+02
RINT19663 nd8999 nd9030 1.050630091887e+03
RINT19664 nd9000 nd9031 1.050630091887e+03
RINT19665 nd9001 nd9032 1.050630091887e+03
RINT19666 nd9002 nd9033 1.050630091887e+03
RINT19667 nd9003 nd9034 1.050630091887e+03
RINT19668 nd9004 nd9035 1.050630091887e+03
RINT19669 nd9005 nd9036 1.050630091887e+03
RINT19670 nd9006 nd9037 2.334733537526e+02
RINT19671 nd9007 nd9038 2.334733537526e+02
RINT19672 nd9008 nd9039 5.538970918181e+02
RINT19673 nd9009 nd9040 3.983936132610e+01
RINT19674 nd9010 nd9041 8.836967932549e+02
RINT19675 nd9011 nd9042 3.682069971895e+00
RINT19676 nd9012 nd9043 3.682069971895e+00
RINT19677 nd9013 nd9044 3.682069971895e+00
RINT19678 nd9014 nd9045 3.682069971895e+00
RINT19679 nd9015 nd9046 3.682069971895e+00
RINT19680 nd9016 nd9047 3.682069971895e+00
RINT19681 nd9017 nd9048 3.682069971895e+00
RINT19682 nd9018 nd9049 3.682069971895e+00
RINT19683 nd9019 nd9050 3.682069971895e+00
RINT19684 nd9020 nd9051 3.682069971895e+00
RINT19685 nd9021 nd9052 1.042035668855e+01
RINT19686 nd9022 nd9053 8.998029228461e+00
RINT19687 nd9023 nd9054 8.998029228461e+00
RINT19688 nd9024 nd9055 5.220533381408e+02
RINT19689 nd9025 nd9056 1.851947369575e+01
RINT19690 nd9026 nd9057 1.865046058263e+01
RINT19691 nd9027 nd9058 1.865046058263e+01
RINT19692 nd9028 nd9059 7.408377398100e+02
RINT19693 nd9029 nd9060 1.234729566350e+02
RINT19694 nd9030 nd9061 2.116679256600e+02
RINT19695 nd9031 nd9062 2.116679256600e+02
RINT19696 nd9032 nd9063 2.116679256600e+02
RINT19697 nd9033 nd9064 2.116679256600e+02
RINT19698 nd9034 nd9065 2.116679256600e+02
RINT19699 nd9035 nd9066 2.116679256600e+02
RINT19700 nd9036 nd9067 2.116679256600e+02
RINT19701 nd9037 nd9068 4.703731681333e+01
RINT19702 nd9038 nd9069 4.703731681333e+01
RINT19703 nd9039 nd9070 9.751427556557e+02
RINT19704 nd9040 nd9071 7.013769373582e+01
RINT19705 nd9041 nd9072 1.555759253601e+03
RINT19706 nd9042 nd9073 6.482330223337e+00
RINT19707 nd9043 nd9074 6.482330223337e+00
RINT19708 nd9044 nd9075 6.482330223337e+00
RINT19709 nd9045 nd9076 6.482330223337e+00
RINT19710 nd9046 nd9077 6.482330223337e+00
RINT19711 nd9047 nd9078 6.482330223337e+00
RINT19712 nd9048 nd9079 6.482330223337e+00
RINT19713 nd9049 nd9080 6.482330223337e+00
RINT19714 nd9050 nd9081 6.482330223337e+00
RINT19715 nd9051 nd9082 6.482330223337e+00
RINT19716 nd9052 nd9083 1.042035668855e+01
RINT19717 nd9053 nd9084 8.998029228461e+00
RINT19718 nd9054 nd9085 8.998029228461e+00
RINT19719 nd9055 nd9086 5.220533381408e+02
RINT19720 nd9056 nd9087 1.851947369575e+01
RINT19721 nd9057 nd9088 1.865046058263e+01
RINT19722 nd9058 nd9089 1.865046058263e+01
RINT19723 nd9059 nd9090 7.408377398100e+02
RINT19724 nd9060 nd9091 1.234729566350e+02
RINT19725 nd9061 nd9092 2.116679256600e+02
RINT19726 nd9062 nd9093 2.116679256600e+02
RINT19727 nd9063 nd9094 2.116679256600e+02
RINT19728 nd9064 nd9095 2.116679256600e+02
RINT19729 nd9065 nd9096 2.116679256600e+02
RINT19730 nd9066 nd9097 2.116679256600e+02
RINT19731 nd9067 nd9098 2.116679256600e+02
RINT19732 nd9068 nd9099 4.703731681333e+01
RINT19733 nd9069 nd9100 4.703731681333e+01
RINT19734 nd9070 nd9101 9.751427556557e+02
RINT19735 nd9071 nd9102 7.013769373582e+01
RINT19736 nd9072 nd9103 1.555759253601e+03
RINT19737 nd9073 nd9104 6.482330223337e+00
RINT19738 nd9074 nd9105 6.482330223337e+00
RINT19739 nd9075 nd9106 6.482330223337e+00
RINT19740 nd9076 nd9107 6.482330223337e+00
RINT19741 nd9077 nd9108 6.482330223337e+00
RINT19742 nd9078 nd9109 6.482330223337e+00
RINT19743 nd9079 nd9110 6.482330223337e+00
RINT19744 nd9080 nd9111 6.482330223337e+00
RINT19745 nd9081 nd9112 6.482330223337e+00
RINT19746 nd9082 nd9113 6.482330223337e+00
RINT19747 nd9114 nd9145 1.042035668855e+01
RINT19748 nd9115 nd9146 8.998029228461e+00
RINT19749 nd9116 nd9147 8.998029228461e+00
RINT19750 nd9117 nd9148 5.220533381408e+02
RINT19751 nd9118 nd9149 1.851947369575e+01
RINT19752 nd9119 nd9150 1.865046058263e+01
RINT19753 nd9120 nd9151 1.865046058263e+01
RINT19754 nd9121 nd9152 7.408377398100e+02
RINT19755 nd9122 nd9153 1.234729566350e+02
RINT19756 nd9123 nd9154 2.116679256600e+02
RINT19757 nd9124 nd9155 2.116679256600e+02
RINT19758 nd9125 nd9156 2.116679256600e+02
RINT19759 nd9126 nd9157 2.116679256600e+02
RINT19760 nd9127 nd9158 2.116679256600e+02
RINT19761 nd9128 nd9159 2.116679256600e+02
RINT19762 nd9129 nd9160 2.116679256600e+02
RINT19763 nd9130 nd9161 4.703731681333e+01
RINT19764 nd9131 nd9162 4.703731681333e+01
RINT19765 nd9132 nd9163 9.751427556557e+02
RINT19766 nd9133 nd9164 7.013769373581e+01
RINT19767 nd9134 nd9165 1.555759253601e+03
RINT19768 nd9135 nd9166 6.482330223337e+00
RINT19769 nd9136 nd9167 6.482330223337e+00
RINT19770 nd9137 nd9168 6.482330223337e+00
RINT19771 nd9138 nd9169 6.482330223337e+00
RINT19772 nd9139 nd9170 6.482330223337e+00
RINT19773 nd9140 nd9171 6.482330223337e+00
RINT19774 nd9141 nd9172 6.482330223337e+00
RINT19775 nd9142 nd9173 6.482330223337e+00
RINT19776 nd9143 nd9174 6.482330223337e+00
RINT19777 nd9144 nd9175 6.482330223337e+00
RINT19778 nd9145 nd9176 1.042035668855e+01
RINT19779 nd9146 nd9177 8.998029228461e+00
RINT19780 nd9147 nd9178 8.998029228461e+00
RINT19781 nd9148 nd9179 5.220533381408e+02
RINT19782 nd9149 nd9180 1.851947369575e+01
RINT19783 nd9150 nd9181 1.865046058263e+01
RINT19784 nd9151 nd9182 1.865046058263e+01
RINT19785 nd9152 nd9183 7.408377398100e+02
RINT19786 nd9153 nd9184 1.234729566350e+02
RINT19787 nd9154 nd9185 2.116679256600e+02
RINT19788 nd9155 nd9186 2.116679256600e+02
RINT19789 nd9156 nd9187 2.116679256600e+02
RINT19790 nd9157 nd9188 2.116679256600e+02
RINT19791 nd9158 nd9189 2.116679256600e+02
RINT19792 nd9159 nd9190 2.116679256600e+02
RINT19793 nd9160 nd9191 2.116679256600e+02
RINT19794 nd9161 nd9192 4.703731681333e+01
RINT19795 nd9162 nd9193 4.703731681333e+01
RINT19796 nd9163 nd9194 9.751427556557e+02
RINT19797 nd9164 nd9195 7.013769373581e+01
RINT19798 nd9165 nd9196 1.555759253601e+03
RINT19799 nd9166 nd9197 6.482330223337e+00
RINT19800 nd9167 nd9198 6.482330223337e+00
RINT19801 nd9168 nd9199 6.482330223337e+00
RINT19802 nd9169 nd9200 6.482330223337e+00
RINT19803 nd9170 nd9201 6.482330223337e+00
RINT19804 nd9171 nd9202 6.482330223337e+00
RINT19805 nd9172 nd9203 6.482330223337e+00
RINT19806 nd9173 nd9204 6.482330223337e+00
RINT19807 nd9174 nd9205 6.482330223337e+00
RINT19808 nd9175 nd9206 6.482330223337e+00
RINT19809 nd9176 nd9207 5.918933645377e+00
RINT19810 nd9177 nd9208 5.111028301069e+00
RINT19811 nd9178 nd9209 5.111028301069e+00
RINT19812 nd9179 nd9210 2.965348653754e+02
RINT19813 nd9180 nd9211 1.051936504946e+01
RINT19814 nd9181 nd9212 1.059376775131e+01
RINT19815 nd9182 nd9213 1.059376775131e+01
RINT19816 nd9183 nd9214 3.677205321604e+03
RINT19817 nd9184 nd9215 6.128675536007e+02
RINT19818 nd9185 nd9216 1.050630091887e+03
RINT19819 nd9186 nd9217 1.050630091887e+03
RINT19820 nd9187 nd9218 1.050630091887e+03
RINT19821 nd9188 nd9219 1.050630091887e+03
RINT19822 nd9189 nd9220 1.050630091887e+03
RINT19823 nd9190 nd9221 1.050630091887e+03
RINT19824 nd9191 nd9222 1.050630091887e+03
RINT19825 nd9192 nd9223 2.334733537526e+02
RINT19826 nd9193 nd9224 2.334733537526e+02
RINT19827 nd9194 nd9225 5.538970918181e+02
RINT19828 nd9195 nd9226 3.983936132610e+01
RINT19829 nd9196 nd9227 8.836967932549e+02
RINT19830 nd9197 nd9228 3.682069971895e+00
RINT19831 nd9198 nd9229 3.682069971895e+00
RINT19832 nd9199 nd9230 3.682069971895e+00
RINT19833 nd9200 nd9231 3.682069971895e+00
RINT19834 nd9201 nd9232 3.682069971895e+00
RINT19835 nd9202 nd9233 3.682069971895e+00
RINT19836 nd9203 nd9234 3.682069971895e+00
RINT19837 nd9204 nd9235 3.682069971895e+00
RINT19838 nd9205 nd9236 3.682069971895e+00
RINT19839 nd9206 nd9237 3.682069971895e+00
RINT19840 nd9207 nd9238 7.494898898358e+00
RINT19841 nd9208 nd9239 6.471882044678e+00
RINT19842 nd9209 nd9240 6.471882044678e+00
RINT19843 nd9210 nd9241 3.754897366627e+02
RINT19844 nd9211 nd9242 1.332023338058e+01
RINT19845 nd9212 nd9243 1.341444641988e+01
RINT19846 nd9213 nd9244 1.341444641988e+01
RINT19847 nd9214 nd9245 3.942767563891e+03
RINT19848 nd9215 nd9246 6.216370766103e+02
RINT19849 nd9216 nd9247 1.083955004199e+03
RINT19850 nd9217 nd9248 1.083955004199e+03
RINT19851 nd9218 nd9249 1.083955004199e+03
RINT19852 nd9219 nd9250 1.083955004199e+03
RINT19853 nd9220 nd9251 1.083955004199e+03
RINT19854 nd9221 nd9252 1.083955004199e+03
RINT19855 nd9222 nd9253 1.083955004199e+03
RINT19856 nd9223 nd9254 2.368141244230e+02
RINT19857 nd9224 nd9255 2.376222816265e+02
RINT19858 nd9225 nd9256 7.013767938611e+02
RINT19859 nd9226 nd9257 5.044692223361e+01
RINT19860 nd9227 nd9258 1.118988405525e+03
RINT19861 nd9228 nd9259 4.662451689687e+00
RINT19862 nd9229 nd9260 4.662451689687e+00
RINT19863 nd9230 nd9261 4.662451689687e+00
RINT19864 nd9231 nd9262 4.662451689687e+00
RINT19865 nd9232 nd9263 4.662451689687e+00
RINT19866 nd9233 nd9264 4.662451689687e+00
RINT19867 nd9234 nd9265 4.662451689687e+00
RINT19868 nd9235 nd9266 4.662451689687e+00
RINT19869 nd9236 nd9267 4.662451689687e+00
RINT19870 nd9237 nd9268 4.662451689687e+00
RINT19871 nd9238 nd9269 1.357228719451e+01
RINT19872 nd9239 nd9270 1.171973671568e+01
RINT19873 nd9240 nd9271 1.171973671568e+01
RINT19874 nd9241 nd9272 6.799630807155e+02
RINT19875 nd9242 nd9273 2.412121035800e+01
RINT19876 nd9243 nd9274 2.429181791977e+01
RINT19877 nd9244 nd9275 2.429181791977e+01
RINT19878 nd9245 nd9276 1.271962224384e+03
RINT19879 nd9246 nd9277 1.410120026542e+02
RINT19880 nd9247 nd9278 2.783177502845e+02
RINT19881 nd9248 nd9279 2.783177502845e+02
RINT19882 nd9249 nd9280 2.783177502845e+02
RINT19883 nd9250 nd9281 2.783177502845e+02
RINT19884 nd9251 nd9282 2.783177502845e+02
RINT19885 nd9252 nd9283 2.783177502845e+02
RINT19886 nd9253 nd9284 2.783177502845e+02
RINT19887 nd9254 nd9285 5.371885815399e+01
RINT19888 nd9255 nd9286 5.533517256115e+01
RINT19889 nd9256 nd9287 1.270102159742e+03
RINT19890 nd9257 nd9288 9.135281555084e+01
RINT19891 nd9258 nd9289 2.026342478141e+03
RINT19892 nd9259 nd9290 8.443093658921e+00
RINT19893 nd9260 nd9291 8.443093658921e+00
RINT19894 nd9261 nd9292 8.443093658921e+00
RINT19895 nd9262 nd9293 8.443093658921e+00
RINT19896 nd9263 nd9294 8.443093658921e+00
RINT19897 nd9264 nd9295 8.443093658921e+00
RINT19898 nd9265 nd9296 8.443093658921e+00
RINT19899 nd9266 nd9297 8.443093658921e+00
RINT19900 nd9267 nd9298 8.443093658921e+00
RINT19901 nd9268 nd9299 8.443093658921e+00
RINT19902 nd9269 nd9300 1.357228719451e+01
RINT19903 nd9270 nd9301 1.171973671568e+01
RINT19904 nd9271 nd9302 1.171973671568e+01
RINT19905 nd9272 nd9303 6.799630807155e+02
RINT19906 nd9273 nd9304 2.412121035800e+01
RINT19907 nd9274 nd9305 2.429181791977e+01
RINT19908 nd9275 nd9306 2.429181791977e+01
RINT19909 nd9276 nd9307 1.271962224384e+03
RINT19910 nd9277 nd9308 1.410120026542e+02
RINT19911 nd9278 nd9309 2.783177502845e+02
RINT19912 nd9279 nd9310 2.783177502845e+02
RINT19913 nd9280 nd9311 2.783177502845e+02
RINT19914 nd9281 nd9312 2.783177502845e+02
RINT19915 nd9282 nd9313 2.783177502845e+02
RINT19916 nd9283 nd9314 2.783177502845e+02
RINT19917 nd9284 nd9315 2.783177502845e+02
RINT19918 nd9285 nd9316 5.371885815399e+01
RINT19919 nd9286 nd9317 5.533517256115e+01
RINT19920 nd9287 nd9318 1.270102159742e+03
RINT19921 nd9288 nd9319 9.135281555084e+01
RINT19922 nd9289 nd9320 2.026342478141e+03
RINT19923 nd9290 nd9321 8.443093658921e+00
RINT19924 nd9291 nd9322 8.443093658921e+00
RINT19925 nd9292 nd9323 8.443093658921e+00
RINT19926 nd9293 nd9324 8.443093658921e+00
RINT19927 nd9294 nd9325 8.443093658921e+00
RINT19928 nd9295 nd9326 8.443093658921e+00
RINT19929 nd9296 nd9327 8.443093658921e+00
RINT19930 nd9297 nd9328 8.443093658921e+00
RINT19931 nd9298 nd9329 8.443093658921e+00
RINT19932 nd9299 nd9330 8.443093658921e+00
RINT19933 nd9300 nd9331 1.357228719451e+01
RINT19934 nd9301 nd9332 1.171973671568e+01
RINT19935 nd9302 nd9333 1.171973671568e+01
RINT19936 nd9303 nd9334 6.799630807155e+02
RINT19937 nd9304 nd9335 2.412121035800e+01
RINT19938 nd9305 nd9336 2.429181791977e+01
RINT19939 nd9306 nd9337 2.429181791977e+01
RINT19940 nd9307 nd9338 1.271962224384e+03
RINT19941 nd9308 nd9339 1.410120026542e+02
RINT19942 nd9309 nd9340 2.783177502845e+02
RINT19943 nd9310 nd9341 2.783177502845e+02
RINT19944 nd9311 nd9342 2.783177502845e+02
RINT19945 nd9312 nd9343 2.783177502845e+02
RINT19946 nd9313 nd9344 2.783177502845e+02
RINT19947 nd9314 nd9345 2.783177502845e+02
RINT19948 nd9315 nd9346 2.783177502845e+02
RINT19949 nd9316 nd9347 5.371885815399e+01
RINT19950 nd9317 nd9348 5.533517256115e+01
RINT19951 nd9318 nd9349 1.270102159742e+03
RINT19952 nd9319 nd9350 9.135281555084e+01
RINT19953 nd9320 nd9351 2.026342478141e+03
RINT19954 nd9321 nd9352 8.443093658921e+00
RINT19955 nd9322 nd9353 8.443093658921e+00
RINT19956 nd9323 nd9354 8.443093658921e+00
RINT19957 nd9324 nd9355 8.443093658921e+00
RINT19958 nd9325 nd9356 8.443093658921e+00
RINT19959 nd9326 nd9357 8.443093658921e+00
RINT19960 nd9327 nd9358 8.443093658921e+00
RINT19961 nd9328 nd9359 8.443093658921e+00
RINT19962 nd9329 nd9360 8.443093658921e+00
RINT19963 nd9330 nd9361 8.443093658921e+00
RINT19964 nd9331 nd9362 1.357228719451e+01
RINT19965 nd9332 nd9363 1.171973671568e+01
RINT19966 nd9333 nd9364 1.171973671568e+01
RINT19967 nd9334 nd9365 6.799630807155e+02
RINT19968 nd9335 nd9366 2.412121035800e+01
RINT19969 nd9336 nd9367 2.429181791977e+01
RINT19970 nd9337 nd9368 2.429181791977e+01
RINT19971 nd9338 nd9369 1.271962224384e+03
RINT19972 nd9339 nd9370 1.410120026542e+02
RINT19973 nd9340 nd9371 2.783177502845e+02
RINT19974 nd9341 nd9372 2.783177502845e+02
RINT19975 nd9342 nd9373 2.783177502845e+02
RINT19976 nd9343 nd9374 2.783177502845e+02
RINT19977 nd9344 nd9375 2.783177502845e+02
RINT19978 nd9345 nd9376 2.783177502845e+02
RINT19979 nd9346 nd9377 2.783177502845e+02
RINT19980 nd9347 nd9378 5.371885815399e+01
RINT19981 nd9348 nd9379 5.533517256115e+01
RINT19982 nd9349 nd9380 1.270102159742e+03
RINT19983 nd9350 nd9381 9.135281555084e+01
RINT19984 nd9351 nd9382 2.026342478141e+03
RINT19985 nd9352 nd9383 8.443093658921e+00
RINT19986 nd9353 nd9384 8.443093658921e+00
RINT19987 nd9354 nd9385 8.443093658921e+00
RINT19988 nd9355 nd9386 8.443093658921e+00
RINT19989 nd9356 nd9387 8.443093658921e+00
RINT19990 nd9357 nd9388 8.443093658921e+00
RINT19991 nd9358 nd9389 8.443093658921e+00
RINT19992 nd9359 nd9390 8.443093658921e+00
RINT19993 nd9360 nd9391 8.443093658921e+00
RINT19994 nd9361 nd9392 8.443093658921e+00
RINT19995 nd9362 nd9393 1.357228719451e+01
RINT19996 nd9363 nd9394 1.171973671568e+01
RINT19997 nd9364 nd9395 1.171973671568e+01
RINT19998 nd9365 nd9396 6.799630807155e+02
RINT19999 nd9366 nd9397 2.412121035800e+01
RINT20000 nd9367 nd9398 2.429181791977e+01
RINT20001 nd9368 nd9399 2.429181791977e+01
RINT20002 nd9369 nd9400 1.271962224384e+03
RINT20003 nd9370 nd9401 1.410120026542e+02
RINT20004 nd9371 nd9402 2.783177502845e+02
RINT20005 nd9372 nd9403 2.783177502845e+02
RINT20006 nd9373 nd9404 2.783177502845e+02
RINT20007 nd9374 nd9405 2.783177502845e+02
RINT20008 nd9375 nd9406 2.783177502845e+02
RINT20009 nd9376 nd9407 2.783177502845e+02
RINT20010 nd9377 nd9408 2.783177502845e+02
RINT20011 nd9378 nd9409 5.371885815399e+01
RINT20012 nd9379 nd9410 5.533517256115e+01
RINT20013 nd9380 nd9411 1.270102159742e+03
RINT20014 nd9381 nd9412 9.135281555084e+01
RINT20015 nd9382 nd9413 2.026342478141e+03
RINT20016 nd9383 nd9414 8.443093658921e+00
RINT20017 nd9384 nd9415 8.443093658921e+00
RINT20018 nd9385 nd9416 8.443093658921e+00
RINT20019 nd9386 nd9417 8.443093658921e+00
RINT20020 nd9387 nd9418 8.443093658921e+00
RINT20021 nd9388 nd9419 8.443093658921e+00
RINT20022 nd9389 nd9420 8.443093658921e+00
RINT20023 nd9390 nd9421 8.443093658921e+00
RINT20024 nd9391 nd9422 8.443093658921e+00
RINT20025 nd9392 nd9423 8.443093658921e+00
RINT20026 nd9393 nd9424 7.494898898358e+00
RINT20027 nd9394 nd9425 6.471882044678e+00
RINT20028 nd9395 nd9426 6.471882044678e+00
RINT20029 nd9396 nd9427 3.754897366627e+02
RINT20030 nd9397 nd9428 1.332023338058e+01
RINT20031 nd9398 nd9429 1.341444641988e+01
RINT20032 nd9399 nd9430 1.341444641988e+01
RINT20033 nd9400 nd9431 3.942767563891e+03
RINT20034 nd9401 nd9432 6.216370766103e+02
RINT20035 nd9402 nd9433 1.083955004199e+03
RINT20036 nd9403 nd9434 1.083955004199e+03
RINT20037 nd9404 nd9435 1.083955004199e+03
RINT20038 nd9405 nd9436 1.083955004199e+03
RINT20039 nd9406 nd9437 1.083955004199e+03
RINT20040 nd9407 nd9438 1.083955004199e+03
RINT20041 nd9408 nd9439 1.083955004199e+03
RINT20042 nd9409 nd9440 2.368141244230e+02
RINT20043 nd9410 nd9441 2.376222816266e+02
RINT20044 nd9411 nd9442 7.013767938611e+02
RINT20045 nd9412 nd9443 5.044692223361e+01
RINT20046 nd9413 nd9444 1.118988405525e+03
RINT20047 nd9414 nd9445 4.662451689687e+00
RINT20048 nd9415 nd9446 4.662451689687e+00
RINT20049 nd9416 nd9447 4.662451689687e+00
RINT20050 nd9417 nd9448 4.662451689687e+00
RINT20051 nd9418 nd9449 4.662451689687e+00
RINT20052 nd9419 nd9450 4.662451689687e+00
RINT20053 nd9420 nd9451 4.662451689687e+00
RINT20054 nd9421 nd9452 4.662451689687e+00
RINT20055 nd9422 nd9453 4.662451689687e+00
RINT20056 nd9423 nd9454 4.662451689687e+00
RINT20057 nd9424 nd9455 7.494898898358e+00
RINT20058 nd9425 nd9456 6.471882044678e+00
RINT20059 nd9426 nd9457 6.471882044678e+00
RINT20060 nd9427 nd9458 3.754897366627e+02
RINT20061 nd9428 nd9459 1.332023338058e+01
RINT20062 nd9429 nd9460 1.341444641988e+01
RINT20063 nd9430 nd9461 1.341444641988e+01
RINT20064 nd9431 nd9462 3.942767563891e+03
RINT20065 nd9432 nd9463 6.216370766103e+02
RINT20066 nd9433 nd9464 1.083955004199e+03
RINT20067 nd9434 nd9465 1.083955004199e+03
RINT20068 nd9435 nd9466 1.083955004199e+03
RINT20069 nd9436 nd9467 1.083955004199e+03
RINT20070 nd9437 nd9468 1.083955004199e+03
RINT20071 nd9438 nd9469 1.083955004199e+03
RINT20072 nd9439 nd9470 1.083955004199e+03
RINT20073 nd9440 nd9471 2.368141244230e+02
RINT20074 nd9441 nd9472 2.376222816266e+02
RINT20075 nd9442 nd9473 7.013767938611e+02
RINT20076 nd9443 nd9474 5.044692223361e+01
RINT20077 nd9444 nd9475 1.118988405525e+03
RINT20078 nd9445 nd9476 4.662451689687e+00
RINT20079 nd9446 nd9477 4.662451689687e+00
RINT20080 nd9447 nd9478 4.662451689687e+00
RINT20081 nd9448 nd9479 4.662451689687e+00
RINT20082 nd9449 nd9480 4.662451689687e+00
RINT20083 nd9450 nd9481 4.662451689687e+00
RINT20084 nd9451 nd9482 4.662451689687e+00
RINT20085 nd9452 nd9483 4.662451689687e+00
RINT20086 nd9453 nd9484 4.662451689687e+00
RINT20087 nd9454 nd9485 4.662451689687e+00
RINT20088 nd9455 nd9486 1.357228719451e+01
RINT20089 nd9456 nd9487 1.171973671568e+01
RINT20090 nd9457 nd9488 1.171973671568e+01
RINT20091 nd9458 nd9489 6.799630807155e+02
RINT20092 nd9459 nd9490 2.412121035800e+01
RINT20093 nd9460 nd9491 2.429181791977e+01
RINT20094 nd9461 nd9492 2.429181791977e+01
RINT20095 nd9462 nd9493 1.271962224384e+03
RINT20096 nd9463 nd9494 1.410120026542e+02
RINT20097 nd9464 nd9495 2.783177502845e+02
RINT20098 nd9465 nd9496 2.783177502845e+02
RINT20099 nd9466 nd9497 2.783177502845e+02
RINT20100 nd9467 nd9498 2.783177502845e+02
RINT20101 nd9468 nd9499 2.783177502845e+02
RINT20102 nd9469 nd9500 2.783177502845e+02
RINT20103 nd9470 nd9501 2.783177502845e+02
RINT20104 nd9471 nd9502 5.371885815399e+01
RINT20105 nd9472 nd9503 5.533517256115e+01
RINT20106 nd9473 nd9504 1.270102159742e+03
RINT20107 nd9474 nd9505 9.135281555084e+01
RINT20108 nd9475 nd9506 2.026342478141e+03
RINT20109 nd9476 nd9507 8.443093658921e+00
RINT20110 nd9477 nd9508 8.443093658921e+00
RINT20111 nd9478 nd9509 8.443093658921e+00
RINT20112 nd9479 nd9510 8.443093658921e+00
RINT20113 nd9480 nd9511 8.443093658921e+00
RINT20114 nd9481 nd9512 8.443093658921e+00
RINT20115 nd9482 nd9513 8.443093658921e+00
RINT20116 nd9483 nd9514 8.443093658921e+00
RINT20117 nd9484 nd9515 8.443093658921e+00
RINT20118 nd9485 nd9516 8.443093658921e+00
RINT20119 nd9486 nd9517 1.357228719451e+01
RINT20120 nd9487 nd9518 1.171973671568e+01
RINT20121 nd9488 nd9519 1.171973671568e+01
RINT20122 nd9489 nd9520 6.799630807155e+02
RINT20123 nd9490 nd9521 2.412121035800e+01
RINT20124 nd9491 nd9522 2.429181791977e+01
RINT20125 nd9492 nd9523 2.429181791977e+01
RINT20126 nd9493 nd9524 1.271962224384e+03
RINT20127 nd9494 nd9525 1.410120026542e+02
RINT20128 nd9495 nd9526 2.783177502845e+02
RINT20129 nd9496 nd9527 2.783177502845e+02
RINT20130 nd9497 nd9528 2.783177502845e+02
RINT20131 nd9498 nd9529 2.783177502845e+02
RINT20132 nd9499 nd9530 2.783177502845e+02
RINT20133 nd9500 nd9531 2.783177502845e+02
RINT20134 nd9501 nd9532 2.783177502845e+02
RINT20135 nd9502 nd9533 5.371885815399e+01
RINT20136 nd9503 nd9534 5.533517256115e+01
RINT20137 nd9504 nd9535 1.270102159742e+03
RINT20138 nd9505 nd9536 9.135281555084e+01
RINT20139 nd9506 nd9537 2.026342478141e+03
RINT20140 nd9507 nd9538 8.443093658921e+00
RINT20141 nd9508 nd9539 8.443093658921e+00
RINT20142 nd9509 nd9540 8.443093658921e+00
RINT20143 nd9510 nd9541 8.443093658921e+00
RINT20144 nd9511 nd9542 8.443093658921e+00
RINT20145 nd9512 nd9543 8.443093658921e+00
RINT20146 nd9513 nd9544 8.443093658921e+00
RINT20147 nd9514 nd9545 8.443093658921e+00
RINT20148 nd9515 nd9546 8.443093658921e+00
RINT20149 nd9516 nd9547 8.443093658921e+00
RINT20150 nd9517 nd9548 1.357228719451e+01
RINT20151 nd9518 nd9549 1.171973671568e+01
RINT20152 nd9519 nd9550 1.171973671568e+01
RINT20153 nd9520 nd9551 6.799630807155e+02
RINT20154 nd9521 nd9552 2.412121035800e+01
RINT20155 nd9522 nd9553 2.429181791977e+01
RINT20156 nd9523 nd9554 2.429181791977e+01
RINT20157 nd9524 nd9555 1.271962224384e+03
RINT20158 nd9525 nd9556 1.410120026542e+02
RINT20159 nd9526 nd9557 2.783177502845e+02
RINT20160 nd9527 nd9558 2.783177502845e+02
RINT20161 nd9528 nd9559 2.783177502845e+02
RINT20162 nd9529 nd9560 2.783177502845e+02
RINT20163 nd9530 nd9561 2.783177502845e+02
RINT20164 nd9531 nd9562 2.783177502845e+02
RINT20165 nd9532 nd9563 2.783177502845e+02
RINT20166 nd9533 nd9564 5.371885815399e+01
RINT20167 nd9534 nd9565 5.533517256115e+01
RINT20168 nd9535 nd9566 1.270102159742e+03
RINT20169 nd9536 nd9567 9.135281555084e+01
RINT20170 nd9537 nd9568 2.026342478141e+03
RINT20171 nd9538 nd9569 8.443093658921e+00
RINT20172 nd9539 nd9570 8.443093658921e+00
RINT20173 nd9540 nd9571 8.443093658921e+00
RINT20174 nd9541 nd9572 8.443093658921e+00
RINT20175 nd9542 nd9573 8.443093658921e+00
RINT20176 nd9543 nd9574 8.443093658921e+00
RINT20177 nd9544 nd9575 8.443093658921e+00
RINT20178 nd9545 nd9576 8.443093658921e+00
RINT20179 nd9546 nd9577 8.443093658921e+00
RINT20180 nd9547 nd9578 8.443093658921e+00
RINT20181 nd9548 nd9579 1.357228719451e+01
RINT20182 nd9549 nd9580 1.171973671568e+01
RINT20183 nd9550 nd9581 1.171973671568e+01
RINT20184 nd9551 nd9582 6.799630807155e+02
RINT20185 nd9552 nd9583 2.412121035800e+01
RINT20186 nd9553 nd9584 2.429181791977e+01
RINT20187 nd9554 nd9585 2.429181791977e+01
RINT20188 nd9555 nd9586 1.271962224384e+03
RINT20189 nd9556 nd9587 1.410120026542e+02
RINT20190 nd9557 nd9588 2.783177502845e+02
RINT20191 nd9558 nd9589 2.783177502845e+02
RINT20192 nd9559 nd9590 2.783177502845e+02
RINT20193 nd9560 nd9591 2.783177502845e+02
RINT20194 nd9561 nd9592 2.783177502845e+02
RINT20195 nd9562 nd9593 2.783177502845e+02
RINT20196 nd9563 nd9594 2.783177502845e+02
RINT20197 nd9564 nd9595 5.371885815399e+01
RINT20198 nd9565 nd9596 5.533517256115e+01
RINT20199 nd9566 nd9597 1.270102159742e+03
RINT20200 nd9567 nd9598 9.135281555084e+01
RINT20201 nd9568 nd9599 2.026342478141e+03
RINT20202 nd9569 nd9600 8.443093658921e+00
RINT20203 nd9570 nd9601 8.443093658921e+00
RINT20204 nd9571 nd9602 8.443093658921e+00
RINT20205 nd9572 nd9603 8.443093658921e+00
RINT20206 nd9573 nd9604 8.443093658921e+00
RINT20207 nd9574 nd9605 8.443093658921e+00
RINT20208 nd9575 nd9606 8.443093658921e+00
RINT20209 nd9576 nd9607 8.443093658921e+00
RINT20210 nd9577 nd9608 8.443093658921e+00
RINT20211 nd9578 nd9609 8.443093658921e+00
RINT20212 nd9579 nd9610 1.357228719451e+01
RINT20213 nd9580 nd9611 1.171973671568e+01
RINT20214 nd9581 nd9612 1.171973671568e+01
RINT20215 nd9582 nd9613 6.799630807155e+02
RINT20216 nd9583 nd9614 2.412121035800e+01
RINT20217 nd9584 nd9615 2.429181791977e+01
RINT20218 nd9585 nd9616 2.429181791977e+01
RINT20219 nd9586 nd9617 1.271962224384e+03
RINT20220 nd9587 nd9618 1.410120026542e+02
RINT20221 nd9588 nd9619 2.783177502845e+02
RINT20222 nd9589 nd9620 2.783177502845e+02
RINT20223 nd9590 nd9621 2.783177502845e+02
RINT20224 nd9591 nd9622 2.783177502845e+02
RINT20225 nd9592 nd9623 2.783177502845e+02
RINT20226 nd9593 nd9624 2.783177502845e+02
RINT20227 nd9594 nd9625 2.783177502845e+02
RINT20228 nd9595 nd9626 5.371885815399e+01
RINT20229 nd9596 nd9627 5.533517256115e+01
RINT20230 nd9597 nd9628 1.270102159742e+03
RINT20231 nd9598 nd9629 9.135281555084e+01
RINT20232 nd9599 nd9630 2.026342478141e+03
RINT20233 nd9600 nd9631 8.443093658921e+00
RINT20234 nd9601 nd9632 8.443093658921e+00
RINT20235 nd9602 nd9633 8.443093658921e+00
RINT20236 nd9603 nd9634 8.443093658921e+00
RINT20237 nd9604 nd9635 8.443093658921e+00
RINT20238 nd9605 nd9636 8.443093658921e+00
RINT20239 nd9606 nd9637 8.443093658921e+00
RINT20240 nd9607 nd9638 8.443093658921e+00
RINT20241 nd9608 nd9639 8.443093658921e+00
RINT20242 nd9609 nd9640 8.443093658921e+00
RINT20243 nd9610 nd9641 7.494898898358e+00
RINT20244 nd9611 nd9642 6.471882044678e+00
RINT20245 nd9612 nd9643 6.471882044678e+00
RINT20246 nd9613 nd9644 3.754897366627e+02
RINT20247 nd9614 nd9645 1.332023338058e+01
RINT20248 nd9615 nd9646 1.341444641988e+01
RINT20249 nd9616 nd9647 1.341444641988e+01
RINT20250 nd9617 nd9648 3.942767563891e+03
RINT20251 nd9618 nd9649 6.216370766103e+02
RINT20252 nd9619 nd9650 1.083955004199e+03
RINT20253 nd9620 nd9651 1.083955004199e+03
RINT20254 nd9621 nd9652 1.083955004199e+03
RINT20255 nd9622 nd9653 1.083955004199e+03
RINT20256 nd9623 nd9654 1.083955004199e+03
RINT20257 nd9624 nd9655 1.083955004199e+03
RINT20258 nd9625 nd9656 1.083955004199e+03
RINT20259 nd9626 nd9657 2.368141244230e+02
RINT20260 nd9627 nd9658 2.376222816266e+02
RINT20261 nd9628 nd9659 7.013767938611e+02
RINT20262 nd9629 nd9660 5.044692223361e+01
RINT20263 nd9630 nd9661 1.118988405525e+03
RINT20264 nd9631 nd9662 4.662451689687e+00
RINT20265 nd9632 nd9663 4.662451689687e+00
RINT20266 nd9633 nd9664 4.662451689687e+00
RINT20267 nd9634 nd9665 4.662451689687e+00
RINT20268 nd9635 nd9666 4.662451689687e+00
RINT20269 nd9636 nd9667 4.662451689687e+00
RINT20270 nd9637 nd9668 4.662451689687e+00
RINT20271 nd9638 nd9669 4.662451689687e+00
RINT20272 nd9639 nd9670 4.662451689687e+00
RINT20273 nd9640 nd9671 4.662451689687e+00
RINT20274 nd9641 nd9672 5.918933645378e+00
RINT20275 nd9642 nd9673 5.111028301069e+00
RINT20276 nd9643 nd9674 5.111028301069e+00
RINT20277 nd9644 nd9675 2.965348653754e+02
RINT20278 nd9645 nd9676 1.051936504946e+01
RINT20279 nd9646 nd9677 1.059376775131e+01
RINT20280 nd9647 nd9678 1.059376775131e+01
RINT20281 nd9648 nd9679 3.677205321604e+03
RINT20282 nd9649 nd9680 6.128675536007e+02
RINT20283 nd9650 nd9681 1.050630091887e+03
RINT20284 nd9651 nd9682 1.050630091887e+03
RINT20285 nd9652 nd9683 1.050630091887e+03
RINT20286 nd9653 nd9684 1.050630091887e+03
RINT20287 nd9654 nd9685 1.050630091887e+03
RINT20288 nd9655 nd9686 1.050630091887e+03
RINT20289 nd9656 nd9687 1.050630091887e+03
RINT20290 nd9657 nd9688 2.334733537526e+02
RINT20291 nd9658 nd9689 2.334733537526e+02
RINT20292 nd9659 nd9690 5.538970918181e+02
RINT20293 nd9660 nd9691 3.983936132610e+01
RINT20294 nd9661 nd9692 8.836967932549e+02
RINT20295 nd9662 nd9693 3.682069971895e+00
RINT20296 nd9663 nd9694 3.682069971895e+00
RINT20297 nd9664 nd9695 3.682069971895e+00
RINT20298 nd9665 nd9696 3.682069971895e+00
RINT20299 nd9666 nd9697 3.682069971895e+00
RINT20300 nd9667 nd9698 3.682069971895e+00
RINT20301 nd9668 nd9699 3.682069971895e+00
RINT20302 nd9669 nd9700 3.682069971895e+00
RINT20303 nd9670 nd9701 3.682069971895e+00
RINT20304 nd9671 nd9702 3.682069971895e+00
RINT20305 nd9672 nd9703 1.042035668855e+01
RINT20306 nd9673 nd9704 8.998029228461e+00
RINT20307 nd9674 nd9705 8.998029228461e+00
RINT20308 nd9675 nd9706 5.220533381408e+02
RINT20309 nd9676 nd9707 1.851947369575e+01
RINT20310 nd9677 nd9708 1.865046058263e+01
RINT20311 nd9678 nd9709 1.865046058263e+01
RINT20312 nd9679 nd9710 7.408377398100e+02
RINT20313 nd9680 nd9711 1.234729566350e+02
RINT20314 nd9681 nd9712 2.116679256600e+02
RINT20315 nd9682 nd9713 2.116679256600e+02
RINT20316 nd9683 nd9714 2.116679256600e+02
RINT20317 nd9684 nd9715 2.116679256600e+02
RINT20318 nd9685 nd9716 2.116679256600e+02
RINT20319 nd9686 nd9717 2.116679256600e+02
RINT20320 nd9687 nd9718 2.116679256600e+02
RINT20321 nd9688 nd9719 4.703731681333e+01
RINT20322 nd9689 nd9720 4.703731681333e+01
RINT20323 nd9690 nd9721 9.751427556557e+02
RINT20324 nd9691 nd9722 7.013769373581e+01
RINT20325 nd9692 nd9723 1.555759253601e+03
RINT20326 nd9693 nd9724 6.482330223337e+00
RINT20327 nd9694 nd9725 6.482330223337e+00
RINT20328 nd9695 nd9726 6.482330223337e+00
RINT20329 nd9696 nd9727 6.482330223337e+00
RINT20330 nd9697 nd9728 6.482330223337e+00
RINT20331 nd9698 nd9729 6.482330223337e+00
RINT20332 nd9699 nd9730 6.482330223337e+00
RINT20333 nd9700 nd9731 6.482330223337e+00
RINT20334 nd9701 nd9732 6.482330223337e+00
RINT20335 nd9702 nd9733 6.482330223337e+00
RINT20336 nd9703 nd9734 1.042035668855e+01
RINT20337 nd9704 nd9735 8.998029228461e+00
RINT20338 nd9705 nd9736 8.998029228461e+00
RINT20339 nd9706 nd9737 5.220533381408e+02
RINT20340 nd9707 nd9738 1.851947369575e+01
RINT20341 nd9708 nd9739 1.865046058263e+01
RINT20342 nd9709 nd9740 1.865046058263e+01
RINT20343 nd9710 nd9741 7.408377398100e+02
RINT20344 nd9711 nd9742 1.234729566350e+02
RINT20345 nd9712 nd9743 2.116679256600e+02
RINT20346 nd9713 nd9744 2.116679256600e+02
RINT20347 nd9714 nd9745 2.116679256600e+02
RINT20348 nd9715 nd9746 2.116679256600e+02
RINT20349 nd9716 nd9747 2.116679256600e+02
RINT20350 nd9717 nd9748 2.116679256600e+02
RINT20351 nd9718 nd9749 2.116679256600e+02
RINT20352 nd9719 nd9750 4.703731681333e+01
RINT20353 nd9720 nd9751 4.703731681333e+01
RINT20354 nd9721 nd9752 9.751427556557e+02
RINT20355 nd9722 nd9753 7.013769373581e+01
RINT20356 nd9723 nd9754 1.555759253601e+03
RINT20357 nd9724 nd9755 6.482330223337e+00
RINT20358 nd9725 nd9756 6.482330223337e+00
RINT20359 nd9726 nd9757 6.482330223337e+00
RINT20360 nd9727 nd9758 6.482330223337e+00
RINT20361 nd9728 nd9759 6.482330223337e+00
RINT20362 nd9729 nd9760 6.482330223337e+00
RINT20363 nd9730 nd9761 6.482330223337e+00
RINT20364 nd9731 nd9762 6.482330223337e+00
RINT20365 nd9732 nd9763 6.482330223337e+00
RINT20366 nd9733 nd9764 6.482330223337e+00
RINT20367 nd9765 nd9796 1.042035668855e+01
RINT20368 nd9766 nd9797 8.998029228461e+00
RINT20369 nd9767 nd9798 8.998029228461e+00
RINT20370 nd9768 nd9799 5.220533381408e+02
RINT20371 nd9769 nd9800 1.851947369575e+01
RINT20372 nd9770 nd9801 1.865046058263e+01
RINT20373 nd9771 nd9802 1.865046058263e+01
RINT20374 nd9772 nd9803 7.408377398100e+02
RINT20375 nd9773 nd9804 1.234729566350e+02
RINT20376 nd9774 nd9805 2.116679256600e+02
RINT20377 nd9775 nd9806 2.116679256600e+02
RINT20378 nd9776 nd9807 2.116679256600e+02
RINT20379 nd9777 nd9808 2.116679256600e+02
RINT20380 nd9778 nd9809 2.116679256600e+02
RINT20381 nd9779 nd9810 2.116679256600e+02
RINT20382 nd9780 nd9811 2.116679256600e+02
RINT20383 nd9781 nd9812 4.703731681333e+01
RINT20384 nd9782 nd9813 4.703731681333e+01
RINT20385 nd9783 nd9814 9.751427556557e+02
RINT20386 nd9784 nd9815 7.013769373582e+01
RINT20387 nd9785 nd9816 1.555759253601e+03
RINT20388 nd9786 nd9817 6.482330223337e+00
RINT20389 nd9787 nd9818 6.482330223337e+00
RINT20390 nd9788 nd9819 6.482330223337e+00
RINT20391 nd9789 nd9820 6.482330223337e+00
RINT20392 nd9790 nd9821 6.482330223337e+00
RINT20393 nd9791 nd9822 6.482330223337e+00
RINT20394 nd9792 nd9823 6.482330223337e+00
RINT20395 nd9793 nd9824 6.482330223337e+00
RINT20396 nd9794 nd9825 6.482330223337e+00
RINT20397 nd9795 nd9826 6.482330223337e+00
RINT20398 nd9796 nd9827 1.042035668855e+01
RINT20399 nd9797 nd9828 8.998029228461e+00
RINT20400 nd9798 nd9829 8.998029228461e+00
RINT20401 nd9799 nd9830 5.220533381408e+02
RINT20402 nd9800 nd9831 1.851947369575e+01
RINT20403 nd9801 nd9832 1.865046058263e+01
RINT20404 nd9802 nd9833 1.865046058263e+01
RINT20405 nd9803 nd9834 7.408377398100e+02
RINT20406 nd9804 nd9835 1.234729566350e+02
RINT20407 nd9805 nd9836 2.116679256600e+02
RINT20408 nd9806 nd9837 2.116679256600e+02
RINT20409 nd9807 nd9838 2.116679256600e+02
RINT20410 nd9808 nd9839 2.116679256600e+02
RINT20411 nd9809 nd9840 2.116679256600e+02
RINT20412 nd9810 nd9841 2.116679256600e+02
RINT20413 nd9811 nd9842 2.116679256600e+02
RINT20414 nd9812 nd9843 4.703731681333e+01
RINT20415 nd9813 nd9844 4.703731681333e+01
RINT20416 nd9814 nd9845 9.751427556557e+02
RINT20417 nd9815 nd9846 7.013769373582e+01
RINT20418 nd9816 nd9847 1.555759253601e+03
RINT20419 nd9817 nd9848 6.482330223337e+00
RINT20420 nd9818 nd9849 6.482330223337e+00
RINT20421 nd9819 nd9850 6.482330223337e+00
RINT20422 nd9820 nd9851 6.482330223337e+00
RINT20423 nd9821 nd9852 6.482330223337e+00
RINT20424 nd9822 nd9853 6.482330223337e+00
RINT20425 nd9823 nd9854 6.482330223337e+00
RINT20426 nd9824 nd9855 6.482330223337e+00
RINT20427 nd9825 nd9856 6.482330223337e+00
RINT20428 nd9826 nd9857 6.482330223337e+00
RINT20429 nd9827 nd9858 5.918933645378e+00
RINT20430 nd9828 nd9859 5.111028301069e+00
RINT20431 nd9829 nd9860 5.111028301069e+00
RINT20432 nd9830 nd9861 2.965348653754e+02
RINT20433 nd9831 nd9862 1.051936504946e+01
RINT20434 nd9832 nd9863 1.059376775131e+01
RINT20435 nd9833 nd9864 1.059376775131e+01
RINT20436 nd9834 nd9865 3.677205321604e+03
RINT20437 nd9835 nd9866 6.128675536007e+02
RINT20438 nd9836 nd9867 1.050630091887e+03
RINT20439 nd9837 nd9868 1.050630091887e+03
RINT20440 nd9838 nd9869 1.050630091887e+03
RINT20441 nd9839 nd9870 1.050630091887e+03
RINT20442 nd9840 nd9871 1.050630091887e+03
RINT20443 nd9841 nd9872 1.050630091887e+03
RINT20444 nd9842 nd9873 1.050630091887e+03
RINT20445 nd9843 nd9874 2.334733537526e+02
RINT20446 nd9844 nd9875 2.334733537526e+02
RINT20447 nd9845 nd9876 5.538970918181e+02
RINT20448 nd9846 nd9877 3.983936132610e+01
RINT20449 nd9847 nd9878 8.836967932549e+02
RINT20450 nd9848 nd9879 3.682069971895e+00
RINT20451 nd9849 nd9880 3.682069971895e+00
RINT20452 nd9850 nd9881 3.682069971895e+00
RINT20453 nd9851 nd9882 3.682069971895e+00
RINT20454 nd9852 nd9883 3.682069971895e+00
RINT20455 nd9853 nd9884 3.682069971895e+00
RINT20456 nd9854 nd9885 3.682069971895e+00
RINT20457 nd9855 nd9886 3.682069971895e+00
RINT20458 nd9856 nd9887 3.682069971895e+00
RINT20459 nd9857 nd9888 3.682069971895e+00
RINT20460 nd9858 nd9889 7.494898898358e+00
RINT20461 nd9859 nd9890 6.471882044678e+00
RINT20462 nd9860 nd9891 6.471882044678e+00
RINT20463 nd9861 nd9892 3.754897366627e+02
RINT20464 nd9862 nd9893 1.332023338058e+01
RINT20465 nd9863 nd9894 1.341444641988e+01
RINT20466 nd9864 nd9895 1.341444641988e+01
RINT20467 nd9865 nd9896 3.942767563891e+03
RINT20468 nd9866 nd9897 6.216370766103e+02
RINT20469 nd9867 nd9898 1.083955004199e+03
RINT20470 nd9868 nd9899 1.083955004199e+03
RINT20471 nd9869 nd9900 1.083955004199e+03
RINT20472 nd9870 nd9901 1.083955004199e+03
RINT20473 nd9871 nd9902 1.083955004199e+03
RINT20474 nd9872 nd9903 1.083955004199e+03
RINT20475 nd9873 nd9904 1.083955004199e+03
RINT20476 nd9874 nd9905 2.368141244230e+02
RINT20477 nd9875 nd9906 2.376222816265e+02
RINT20478 nd9876 nd9907 7.013767938611e+02
RINT20479 nd9877 nd9908 5.044692223361e+01
RINT20480 nd9878 nd9909 1.118988405525e+03
RINT20481 nd9879 nd9910 4.662451689687e+00
RINT20482 nd9880 nd9911 4.662451689687e+00
RINT20483 nd9881 nd9912 4.662451689687e+00
RINT20484 nd9882 nd9913 4.662451689687e+00
RINT20485 nd9883 nd9914 4.662451689687e+00
RINT20486 nd9884 nd9915 4.662451689687e+00
RINT20487 nd9885 nd9916 4.662451689687e+00
RINT20488 nd9886 nd9917 4.662451689687e+00
RINT20489 nd9887 nd9918 4.662451689687e+00
RINT20490 nd9888 nd9919 4.662451689687e+00
RINT20491 nd9889 nd9920 1.357228719451e+01
RINT20492 nd9890 nd9921 1.171973671568e+01
RINT20493 nd9891 nd9922 1.171973671568e+01
RINT20494 nd9892 nd9923 6.799630807155e+02
RINT20495 nd9893 nd9924 2.412121035800e+01
RINT20496 nd9894 nd9925 2.429181791977e+01
RINT20497 nd9895 nd9926 2.429181791977e+01
RINT20498 nd9896 nd9927 1.271962224384e+03
RINT20499 nd9897 nd9928 1.410120026542e+02
RINT20500 nd9898 nd9929 2.783177502845e+02
RINT20501 nd9899 nd9930 2.783177502845e+02
RINT20502 nd9900 nd9931 2.783177502845e+02
RINT20503 nd9901 nd9932 2.783177502845e+02
RINT20504 nd9902 nd9933 2.783177502845e+02
RINT20505 nd9903 nd9934 2.783177502845e+02
RINT20506 nd9904 nd9935 2.783177502845e+02
RINT20507 nd9905 nd9936 5.371885815399e+01
RINT20508 nd9906 nd9937 5.533517256115e+01
RINT20509 nd9907 nd9938 1.270102159742e+03
RINT20510 nd9908 nd9939 9.135281555084e+01
RINT20511 nd9909 nd9940 2.026342478141e+03
RINT20512 nd9910 nd9941 8.443093658921e+00
RINT20513 nd9911 nd9942 8.443093658921e+00
RINT20514 nd9912 nd9943 8.443093658921e+00
RINT20515 nd9913 nd9944 8.443093658921e+00
RINT20516 nd9914 nd9945 8.443093658921e+00
RINT20517 nd9915 nd9946 8.443093658921e+00
RINT20518 nd9916 nd9947 8.443093658921e+00
RINT20519 nd9917 nd9948 8.443093658921e+00
RINT20520 nd9918 nd9949 8.443093658921e+00
RINT20521 nd9919 nd9950 8.443093658921e+00
RINT20522 nd9920 nd9951 1.357228719451e+01
RINT20523 nd9921 nd9952 1.171973671568e+01
RINT20524 nd9922 nd9953 1.171973671568e+01
RINT20525 nd9923 nd9954 6.799630807155e+02
RINT20526 nd9924 nd9955 2.412121035800e+01
RINT20527 nd9925 nd9956 2.429181791977e+01
RINT20528 nd9926 nd9957 2.429181791977e+01
RINT20529 nd9927 nd9958 1.271962224384e+03
RINT20530 nd9928 nd9959 1.410120026542e+02
RINT20531 nd9929 nd9960 2.783177502845e+02
RINT20532 nd9930 nd9961 2.783177502845e+02
RINT20533 nd9931 nd9962 2.783177502845e+02
RINT20534 nd9932 nd9963 2.783177502845e+02
RINT20535 nd9933 nd9964 2.783177502845e+02
RINT20536 nd9934 nd9965 2.783177502845e+02
RINT20537 nd9935 nd9966 2.783177502845e+02
RINT20538 nd9936 nd9967 5.371885815399e+01
RINT20539 nd9937 nd9968 5.533517256115e+01
RINT20540 nd9938 nd9969 1.270102159742e+03
RINT20541 nd9939 nd9970 9.135281555084e+01
RINT20542 nd9940 nd9971 2.026342478141e+03
RINT20543 nd9941 nd9972 8.443093658921e+00
RINT20544 nd9942 nd9973 8.443093658921e+00
RINT20545 nd9943 nd9974 8.443093658921e+00
RINT20546 nd9944 nd9975 8.443093658921e+00
RINT20547 nd9945 nd9976 8.443093658921e+00
RINT20548 nd9946 nd9977 8.443093658921e+00
RINT20549 nd9947 nd9978 8.443093658921e+00
RINT20550 nd9948 nd9979 8.443093658921e+00
RINT20551 nd9949 nd9980 8.443093658921e+00
RINT20552 nd9950 nd9981 8.443093658921e+00
RINT20553 nd9951 nd9982 1.357228719451e+01
RINT20554 nd9952 nd9983 1.171973671568e+01
RINT20555 nd9953 nd9984 1.171973671568e+01
RINT20556 nd9954 nd9985 6.799630807155e+02
RINT20557 nd9955 nd9986 2.412121035800e+01
RINT20558 nd9956 nd9987 2.429181791977e+01
RINT20559 nd9957 nd9988 2.429181791977e+01
RINT20560 nd9958 nd9989 1.271962224384e+03
RINT20561 nd9959 nd9990 1.410120026542e+02
RINT20562 nd9960 nd9991 2.783177502845e+02
RINT20563 nd9961 nd9992 2.783177502845e+02
RINT20564 nd9962 nd9993 2.783177502845e+02
RINT20565 nd9963 nd9994 2.783177502845e+02
RINT20566 nd9964 nd9995 2.783177502845e+02
RINT20567 nd9965 nd9996 2.783177502845e+02
RINT20568 nd9966 nd9997 2.783177502845e+02
RINT20569 nd9967 nd9998 5.371885815399e+01
RINT20570 nd9968 nd9999 5.533517256115e+01
RINT20571 nd9969 nd10000 1.270102159742e+03
RINT20572 nd9970 nd10001 9.135281555084e+01
RINT20573 nd9971 nd10002 2.026342478141e+03
RINT20574 nd9972 nd10003 8.443093658921e+00
RINT20575 nd9973 nd10004 8.443093658921e+00
RINT20576 nd9974 nd10005 8.443093658921e+00
RINT20577 nd9975 nd10006 8.443093658921e+00
RINT20578 nd9976 nd10007 8.443093658921e+00
RINT20579 nd9977 nd10008 8.443093658921e+00
RINT20580 nd9978 nd10009 8.443093658921e+00
RINT20581 nd9979 nd10010 8.443093658921e+00
RINT20582 nd9980 nd10011 8.443093658921e+00
RINT20583 nd9981 nd10012 8.443093658921e+00
RINT20584 nd9982 nd10013 1.357228719451e+01
RINT20585 nd9983 nd10014 1.171973671568e+01
RINT20586 nd9984 nd10015 1.171973671568e+01
RINT20587 nd9985 nd10016 6.799630807155e+02
RINT20588 nd9986 nd10017 2.412121035800e+01
RINT20589 nd9987 nd10018 2.429181791977e+01
RINT20590 nd9988 nd10019 2.429181791977e+01
RINT20591 nd9989 nd10020 1.271962224384e+03
RINT20592 nd9990 nd10021 1.410120026542e+02
RINT20593 nd9991 nd10022 2.783177502845e+02
RINT20594 nd9992 nd10023 2.783177502845e+02
RINT20595 nd9993 nd10024 2.783177502845e+02
RINT20596 nd9994 nd10025 2.783177502845e+02
RINT20597 nd9995 nd10026 2.783177502845e+02
RINT20598 nd9996 nd10027 2.783177502845e+02
RINT20599 nd9997 nd10028 2.783177502845e+02
RINT20600 nd9998 nd10029 5.371885815399e+01
RINT20601 nd9999 nd10030 5.533517256115e+01
RINT20602 nd10000 nd10031 1.270102159742e+03
RINT20603 nd10001 nd10032 9.135281555084e+01
RINT20604 nd10002 nd10033 2.026342478141e+03
RINT20605 nd10003 nd10034 8.443093658921e+00
RINT20606 nd10004 nd10035 8.443093658921e+00
RINT20607 nd10005 nd10036 8.443093658921e+00
RINT20608 nd10006 nd10037 8.443093658921e+00
RINT20609 nd10007 nd10038 8.443093658921e+00
RINT20610 nd10008 nd10039 8.443093658921e+00
RINT20611 nd10009 nd10040 8.443093658921e+00
RINT20612 nd10010 nd10041 8.443093658921e+00
RINT20613 nd10011 nd10042 8.443093658921e+00
RINT20614 nd10012 nd10043 8.443093658921e+00
RINT20615 nd10013 nd10044 1.357228719451e+01
RINT20616 nd10014 nd10045 1.171973671568e+01
RINT20617 nd10015 nd10046 1.171973671568e+01
RINT20618 nd10016 nd10047 6.799630807155e+02
RINT20619 nd10017 nd10048 2.412121035800e+01
RINT20620 nd10018 nd10049 2.429181791977e+01
RINT20621 nd10019 nd10050 2.429181791977e+01
RINT20622 nd10020 nd10051 1.271962224384e+03
RINT20623 nd10021 nd10052 1.410120026542e+02
RINT20624 nd10022 nd10053 2.783177502845e+02
RINT20625 nd10023 nd10054 2.783177502845e+02
RINT20626 nd10024 nd10055 2.783177502845e+02
RINT20627 nd10025 nd10056 2.783177502845e+02
RINT20628 nd10026 nd10057 2.783177502845e+02
RINT20629 nd10027 nd10058 2.783177502845e+02
RINT20630 nd10028 nd10059 2.783177502845e+02
RINT20631 nd10029 nd10060 5.371885815399e+01
RINT20632 nd10030 nd10061 5.533517256115e+01
RINT20633 nd10031 nd10062 1.270102159742e+03
RINT20634 nd10032 nd10063 9.135281555084e+01
RINT20635 nd10033 nd10064 2.026342478141e+03
RINT20636 nd10034 nd10065 8.443093658921e+00
RINT20637 nd10035 nd10066 8.443093658921e+00
RINT20638 nd10036 nd10067 8.443093658921e+00
RINT20639 nd10037 nd10068 8.443093658921e+00
RINT20640 nd10038 nd10069 8.443093658921e+00
RINT20641 nd10039 nd10070 8.443093658921e+00
RINT20642 nd10040 nd10071 8.443093658921e+00
RINT20643 nd10041 nd10072 8.443093658921e+00
RINT20644 nd10042 nd10073 8.443093658921e+00
RINT20645 nd10043 nd10074 8.443093658921e+00
RINT20646 nd10044 nd10075 7.494898898358e+00
RINT20647 nd10045 nd10076 6.471882044678e+00
RINT20648 nd10046 nd10077 6.471882044678e+00
RINT20649 nd10047 nd10078 3.754897366627e+02
RINT20650 nd10048 nd10079 1.332023338058e+01
RINT20651 nd10049 nd10080 1.341444641988e+01
RINT20652 nd10050 nd10081 1.341444641988e+01
RINT20653 nd10051 nd10082 3.942767563891e+03
RINT20654 nd10052 nd10083 6.216370766103e+02
RINT20655 nd10053 nd10084 1.083955004199e+03
RINT20656 nd10054 nd10085 1.083955004199e+03
RINT20657 nd10055 nd10086 1.083955004199e+03
RINT20658 nd10056 nd10087 1.083955004199e+03
RINT20659 nd10057 nd10088 1.083955004199e+03
RINT20660 nd10058 nd10089 1.083955004199e+03
RINT20661 nd10059 nd10090 1.083955004199e+03
RINT20662 nd10060 nd10091 2.368141244230e+02
RINT20663 nd10061 nd10092 2.376222816266e+02
RINT20664 nd10062 nd10093 7.013767938611e+02
RINT20665 nd10063 nd10094 5.044692223361e+01
RINT20666 nd10064 nd10095 1.118988405525e+03
RINT20667 nd10065 nd10096 4.662451689687e+00
RINT20668 nd10066 nd10097 4.662451689687e+00
RINT20669 nd10067 nd10098 4.662451689687e+00
RINT20670 nd10068 nd10099 4.662451689687e+00
RINT20671 nd10069 nd10100 4.662451689687e+00
RINT20672 nd10070 nd10101 4.662451689687e+00
RINT20673 nd10071 nd10102 4.662451689687e+00
RINT20674 nd10072 nd10103 4.662451689687e+00
RINT20675 nd10073 nd10104 4.662451689687e+00
RINT20676 nd10074 nd10105 4.662451689687e+00
RINT20677 nd10075 nd10106 7.494898898358e+00
RINT20678 nd10076 nd10107 6.471882044678e+00
RINT20679 nd10077 nd10108 6.471882044678e+00
RINT20680 nd10078 nd10109 3.754897366627e+02
RINT20681 nd10079 nd10110 1.332023338058e+01
RINT20682 nd10080 nd10111 1.341444641988e+01
RINT20683 nd10081 nd10112 1.341444641988e+01
RINT20684 nd10082 nd10113 3.942767563891e+03
RINT20685 nd10083 nd10114 6.216370766103e+02
RINT20686 nd10084 nd10115 1.083955004199e+03
RINT20687 nd10085 nd10116 1.083955004199e+03
RINT20688 nd10086 nd10117 1.083955004199e+03
RINT20689 nd10087 nd10118 1.083955004199e+03
RINT20690 nd10088 nd10119 1.083955004199e+03
RINT20691 nd10089 nd10120 1.083955004199e+03
RINT20692 nd10090 nd10121 1.083955004199e+03
RINT20693 nd10091 nd10122 2.368141244230e+02
RINT20694 nd10092 nd10123 2.376222816266e+02
RINT20695 nd10093 nd10124 7.013767938611e+02
RINT20696 nd10094 nd10125 5.044692223361e+01
RINT20697 nd10095 nd10126 1.118988405525e+03
RINT20698 nd10096 nd10127 4.662451689687e+00
RINT20699 nd10097 nd10128 4.662451689687e+00
RINT20700 nd10098 nd10129 4.662451689687e+00
RINT20701 nd10099 nd10130 4.662451689687e+00
RINT20702 nd10100 nd10131 4.662451689687e+00
RINT20703 nd10101 nd10132 4.662451689687e+00
RINT20704 nd10102 nd10133 4.662451689687e+00
RINT20705 nd10103 nd10134 4.662451689687e+00
RINT20706 nd10104 nd10135 4.662451689687e+00
RINT20707 nd10105 nd10136 4.662451689687e+00
RINT20708 nd10106 nd10137 1.357228719451e+01
RINT20709 nd10107 nd10138 1.171973671568e+01
RINT20710 nd10108 nd10139 1.171973671568e+01
RINT20711 nd10109 nd10140 6.799630807155e+02
RINT20712 nd10110 nd10141 2.412121035800e+01
RINT20713 nd10111 nd10142 2.429181791977e+01
RINT20714 nd10112 nd10143 2.429181791977e+01
RINT20715 nd10113 nd10144 1.271962224384e+03
RINT20716 nd10114 nd10145 1.410120026542e+02
RINT20717 nd10115 nd10146 2.783177502845e+02
RINT20718 nd10116 nd10147 2.783177502845e+02
RINT20719 nd10117 nd10148 2.783177502845e+02
RINT20720 nd10118 nd10149 2.783177502845e+02
RINT20721 nd10119 nd10150 2.783177502845e+02
RINT20722 nd10120 nd10151 2.783177502845e+02
RINT20723 nd10121 nd10152 2.783177502845e+02
RINT20724 nd10122 nd10153 5.371885815399e+01
RINT20725 nd10123 nd10154 5.533517256115e+01
RINT20726 nd10124 nd10155 1.270102159742e+03
RINT20727 nd10125 nd10156 9.135281555084e+01
RINT20728 nd10126 nd10157 2.026342478141e+03
RINT20729 nd10127 nd10158 8.443093658921e+00
RINT20730 nd10128 nd10159 8.443093658921e+00
RINT20731 nd10129 nd10160 8.443093658921e+00
RINT20732 nd10130 nd10161 8.443093658921e+00
RINT20733 nd10131 nd10162 8.443093658921e+00
RINT20734 nd10132 nd10163 8.443093658921e+00
RINT20735 nd10133 nd10164 8.443093658921e+00
RINT20736 nd10134 nd10165 8.443093658921e+00
RINT20737 nd10135 nd10166 8.443093658921e+00
RINT20738 nd10136 nd10167 8.443093658921e+00
RINT20739 nd10137 nd10168 1.357228719451e+01
RINT20740 nd10138 nd10169 1.171973671568e+01
RINT20741 nd10139 nd10170 1.171973671568e+01
RINT20742 nd10140 nd10171 6.799630807155e+02
RINT20743 nd10141 nd10172 2.412121035800e+01
RINT20744 nd10142 nd10173 2.429181791977e+01
RINT20745 nd10143 nd10174 2.429181791977e+01
RINT20746 nd10144 nd10175 1.271962224384e+03
RINT20747 nd10145 nd10176 1.410120026542e+02
RINT20748 nd10146 nd10177 2.783177502845e+02
RINT20749 nd10147 nd10178 2.783177502845e+02
RINT20750 nd10148 nd10179 2.783177502845e+02
RINT20751 nd10149 nd10180 2.783177502845e+02
RINT20752 nd10150 nd10181 2.783177502845e+02
RINT20753 nd10151 nd10182 2.783177502845e+02
RINT20754 nd10152 nd10183 2.783177502845e+02
RINT20755 nd10153 nd10184 5.371885815399e+01
RINT20756 nd10154 nd10185 5.533517256115e+01
RINT20757 nd10155 nd10186 1.270102159742e+03
RINT20758 nd10156 nd10187 9.135281555084e+01
RINT20759 nd10157 nd10188 2.026342478141e+03
RINT20760 nd10158 nd10189 8.443093658921e+00
RINT20761 nd10159 nd10190 8.443093658921e+00
RINT20762 nd10160 nd10191 8.443093658921e+00
RINT20763 nd10161 nd10192 8.443093658921e+00
RINT20764 nd10162 nd10193 8.443093658921e+00
RINT20765 nd10163 nd10194 8.443093658921e+00
RINT20766 nd10164 nd10195 8.443093658921e+00
RINT20767 nd10165 nd10196 8.443093658921e+00
RINT20768 nd10166 nd10197 8.443093658921e+00
RINT20769 nd10167 nd10198 8.443093658921e+00
RINT20770 nd10168 nd10199 1.357228719451e+01
RINT20771 nd10169 nd10200 1.171973671568e+01
RINT20772 nd10170 nd10201 1.171973671568e+01
RINT20773 nd10171 nd10202 6.799630807155e+02
RINT20774 nd10172 nd10203 2.412121035800e+01
RINT20775 nd10173 nd10204 2.429181791977e+01
RINT20776 nd10174 nd10205 2.429181791977e+01
RINT20777 nd10175 nd10206 1.271962224384e+03
RINT20778 nd10176 nd10207 1.410120026542e+02
RINT20779 nd10177 nd10208 2.783177502845e+02
RINT20780 nd10178 nd10209 2.783177502845e+02
RINT20781 nd10179 nd10210 2.783177502845e+02
RINT20782 nd10180 nd10211 2.783177502845e+02
RINT20783 nd10181 nd10212 2.783177502845e+02
RINT20784 nd10182 nd10213 2.783177502845e+02
RINT20785 nd10183 nd10214 2.783177502845e+02
RINT20786 nd10184 nd10215 5.371885815399e+01
RINT20787 nd10185 nd10216 5.533517256115e+01
RINT20788 nd10186 nd10217 1.270102159742e+03
RINT20789 nd10187 nd10218 9.135281555084e+01
RINT20790 nd10188 nd10219 2.026342478141e+03
RINT20791 nd10189 nd10220 8.443093658921e+00
RINT20792 nd10190 nd10221 8.443093658921e+00
RINT20793 nd10191 nd10222 8.443093658921e+00
RINT20794 nd10192 nd10223 8.443093658921e+00
RINT20795 nd10193 nd10224 8.443093658921e+00
RINT20796 nd10194 nd10225 8.443093658921e+00
RINT20797 nd10195 nd10226 8.443093658921e+00
RINT20798 nd10196 nd10227 8.443093658921e+00
RINT20799 nd10197 nd10228 8.443093658921e+00
RINT20800 nd10198 nd10229 8.443093658921e+00
RINT20801 nd10199 nd10230 1.357228719451e+01
RINT20802 nd10200 nd10231 1.171973671568e+01
RINT20803 nd10201 nd10232 1.171973671568e+01
RINT20804 nd10202 nd10233 6.799630807155e+02
RINT20805 nd10203 nd10234 2.412121035800e+01
RINT20806 nd10204 nd10235 2.429181791977e+01
RINT20807 nd10205 nd10236 2.429181791977e+01
RINT20808 nd10206 nd10237 1.271962224384e+03
RINT20809 nd10207 nd10238 1.410120026542e+02
RINT20810 nd10208 nd10239 2.783177502845e+02
RINT20811 nd10209 nd10240 2.783177502845e+02
RINT20812 nd10210 nd10241 2.783177502845e+02
RINT20813 nd10211 nd10242 2.783177502845e+02
RINT20814 nd10212 nd10243 2.783177502845e+02
RINT20815 nd10213 nd10244 2.783177502845e+02
RINT20816 nd10214 nd10245 2.783177502845e+02
RINT20817 nd10215 nd10246 5.371885815399e+01
RINT20818 nd10216 nd10247 5.533517256115e+01
RINT20819 nd10217 nd10248 1.270102159742e+03
RINT20820 nd10218 nd10249 9.135281555084e+01
RINT20821 nd10219 nd10250 2.026342478141e+03
RINT20822 nd10220 nd10251 8.443093658921e+00
RINT20823 nd10221 nd10252 8.443093658921e+00
RINT20824 nd10222 nd10253 8.443093658921e+00
RINT20825 nd10223 nd10254 8.443093658921e+00
RINT20826 nd10224 nd10255 8.443093658921e+00
RINT20827 nd10225 nd10256 8.443093658921e+00
RINT20828 nd10226 nd10257 8.443093658921e+00
RINT20829 nd10227 nd10258 8.443093658921e+00
RINT20830 nd10228 nd10259 8.443093658921e+00
RINT20831 nd10229 nd10260 8.443093658921e+00
RINT20832 nd10230 nd10261 1.357228719451e+01
RINT20833 nd10231 nd10262 1.171973671568e+01
RINT20834 nd10232 nd10263 1.171973671568e+01
RINT20835 nd10233 nd10264 6.799630807155e+02
RINT20836 nd10234 nd10265 2.412121035800e+01
RINT20837 nd10235 nd10266 2.429181791977e+01
RINT20838 nd10236 nd10267 2.429181791977e+01
RINT20839 nd10237 nd10268 1.271962224384e+03
RINT20840 nd10238 nd10269 1.410120026542e+02
RINT20841 nd10239 nd10270 2.783177502845e+02
RINT20842 nd10240 nd10271 2.783177502845e+02
RINT20843 nd10241 nd10272 2.783177502845e+02
RINT20844 nd10242 nd10273 2.783177502845e+02
RINT20845 nd10243 nd10274 2.783177502845e+02
RINT20846 nd10244 nd10275 2.783177502845e+02
RINT20847 nd10245 nd10276 2.783177502845e+02
RINT20848 nd10246 nd10277 5.371885815399e+01
RINT20849 nd10247 nd10278 5.533517256115e+01
RINT20850 nd10248 nd10279 1.270102159742e+03
RINT20851 nd10249 nd10280 9.135281555084e+01
RINT20852 nd10250 nd10281 2.026342478141e+03
RINT20853 nd10251 nd10282 8.443093658921e+00
RINT20854 nd10252 nd10283 8.443093658921e+00
RINT20855 nd10253 nd10284 8.443093658921e+00
RINT20856 nd10254 nd10285 8.443093658921e+00
RINT20857 nd10255 nd10286 8.443093658921e+00
RINT20858 nd10256 nd10287 8.443093658921e+00
RINT20859 nd10257 nd10288 8.443093658921e+00
RINT20860 nd10258 nd10289 8.443093658921e+00
RINT20861 nd10259 nd10290 8.443093658921e+00
RINT20862 nd10260 nd10291 8.443093658921e+00
RINT20863 nd10261 nd10292 7.494898898358e+00
RINT20864 nd10262 nd10293 6.471882044678e+00
RINT20865 nd10263 nd10294 6.471882044678e+00
RINT20866 nd10264 nd10295 3.754897366627e+02
RINT20867 nd10265 nd10296 1.332023338058e+01
RINT20868 nd10266 nd10297 1.341444641988e+01
RINT20869 nd10267 nd10298 1.341444641988e+01
RINT20870 nd10268 nd10299 3.942767563891e+03
RINT20871 nd10269 nd10300 6.216370766103e+02
RINT20872 nd10270 nd10301 1.083955004199e+03
RINT20873 nd10271 nd10302 1.083955004199e+03
RINT20874 nd10272 nd10303 1.083955004199e+03
RINT20875 nd10273 nd10304 1.083955004199e+03
RINT20876 nd10274 nd10305 1.083955004199e+03
RINT20877 nd10275 nd10306 1.083955004199e+03
RINT20878 nd10276 nd10307 1.083955004199e+03
RINT20879 nd10277 nd10308 2.368141244230e+02
RINT20880 nd10278 nd10309 2.376222816266e+02
RINT20881 nd10279 nd10310 7.013767938611e+02
RINT20882 nd10280 nd10311 5.044692223361e+01
RINT20883 nd10281 nd10312 1.118988405525e+03
RINT20884 nd10282 nd10313 4.662451689687e+00
RINT20885 nd10283 nd10314 4.662451689687e+00
RINT20886 nd10284 nd10315 4.662451689687e+00
RINT20887 nd10285 nd10316 4.662451689687e+00
RINT20888 nd10286 nd10317 4.662451689687e+00
RINT20889 nd10287 nd10318 4.662451689687e+00
RINT20890 nd10288 nd10319 4.662451689687e+00
RINT20891 nd10289 nd10320 4.662451689687e+00
RINT20892 nd10290 nd10321 4.662451689687e+00
RINT20893 nd10291 nd10322 4.662451689687e+00
RINT20894 nd10292 nd10323 5.918933645378e+00
RINT20895 nd10293 nd10324 5.111028301069e+00
RINT20896 nd10294 nd10325 5.111028301069e+00
RINT20897 nd10295 nd10326 2.965348653754e+02
RINT20898 nd10296 nd10327 1.051936504946e+01
RINT20899 nd10297 nd10328 1.059376775131e+01
RINT20900 nd10298 nd10329 1.059376775131e+01
RINT20901 nd10299 nd10330 3.677205321604e+03
RINT20902 nd10300 nd10331 6.128675536007e+02
RINT20903 nd10301 nd10332 1.050630091887e+03
RINT20904 nd10302 nd10333 1.050630091887e+03
RINT20905 nd10303 nd10334 1.050630091887e+03
RINT20906 nd10304 nd10335 1.050630091887e+03
RINT20907 nd10305 nd10336 1.050630091887e+03
RINT20908 nd10306 nd10337 1.050630091887e+03
RINT20909 nd10307 nd10338 1.050630091887e+03
RINT20910 nd10308 nd10339 2.334733537526e+02
RINT20911 nd10309 nd10340 2.334733537526e+02
RINT20912 nd10310 nd10341 5.538970918181e+02
RINT20913 nd10311 nd10342 3.983936132610e+01
RINT20914 nd10312 nd10343 8.836967932549e+02
RINT20915 nd10313 nd10344 3.682069971895e+00
RINT20916 nd10314 nd10345 3.682069971895e+00
RINT20917 nd10315 nd10346 3.682069971895e+00
RINT20918 nd10316 nd10347 3.682069971895e+00
RINT20919 nd10317 nd10348 3.682069971895e+00
RINT20920 nd10318 nd10349 3.682069971895e+00
RINT20921 nd10319 nd10350 3.682069971895e+00
RINT20922 nd10320 nd10351 3.682069971895e+00
RINT20923 nd10321 nd10352 3.682069971895e+00
RINT20924 nd10322 nd10353 3.682069971895e+00
RINT20925 nd10323 nd10354 1.042035668855e+01
RINT20926 nd10324 nd10355 8.998029228461e+00
RINT20927 nd10325 nd10356 8.998029228461e+00
RINT20928 nd10326 nd10357 5.220533381408e+02
RINT20929 nd10327 nd10358 1.851947369575e+01
RINT20930 nd10328 nd10359 1.865046058263e+01
RINT20931 nd10329 nd10360 1.865046058263e+01
RINT20932 nd10330 nd10361 7.408377398100e+02
RINT20933 nd10331 nd10362 1.234729566350e+02
RINT20934 nd10332 nd10363 2.116679256600e+02
RINT20935 nd10333 nd10364 2.116679256600e+02
RINT20936 nd10334 nd10365 2.116679256600e+02
RINT20937 nd10335 nd10366 2.116679256600e+02
RINT20938 nd10336 nd10367 2.116679256600e+02
RINT20939 nd10337 nd10368 2.116679256600e+02
RINT20940 nd10338 nd10369 2.116679256600e+02
RINT20941 nd10339 nd10370 4.703731681333e+01
RINT20942 nd10340 nd10371 4.703731681333e+01
RINT20943 nd10341 nd10372 9.751427556557e+02
RINT20944 nd10342 nd10373 7.013769373582e+01
RINT20945 nd10343 nd10374 1.555759253601e+03
RINT20946 nd10344 nd10375 6.482330223337e+00
RINT20947 nd10345 nd10376 6.482330223337e+00
RINT20948 nd10346 nd10377 6.482330223337e+00
RINT20949 nd10347 nd10378 6.482330223337e+00
RINT20950 nd10348 nd10379 6.482330223337e+00
RINT20951 nd10349 nd10380 6.482330223337e+00
RINT20952 nd10350 nd10381 6.482330223337e+00
RINT20953 nd10351 nd10382 6.482330223337e+00
RINT20954 nd10352 nd10383 6.482330223337e+00
RINT20955 nd10353 nd10384 6.482330223337e+00
RINT20956 nd10354 nd10385 1.042035668855e+01
RINT20957 nd10355 nd10386 8.998029228461e+00
RINT20958 nd10356 nd10387 8.998029228461e+00
RINT20959 nd10357 nd10388 5.220533381408e+02
RINT20960 nd10358 nd10389 1.851947369575e+01
RINT20961 nd10359 nd10390 1.865046058263e+01
RINT20962 nd10360 nd10391 1.865046058263e+01
RINT20963 nd10361 nd10392 7.408377398100e+02
RINT20964 nd10362 nd10393 1.234729566350e+02
RINT20965 nd10363 nd10394 2.116679256600e+02
RINT20966 nd10364 nd10395 2.116679256600e+02
RINT20967 nd10365 nd10396 2.116679256600e+02
RINT20968 nd10366 nd10397 2.116679256600e+02
RINT20969 nd10367 nd10398 2.116679256600e+02
RINT20970 nd10368 nd10399 2.116679256600e+02
RINT20971 nd10369 nd10400 2.116679256600e+02
RINT20972 nd10370 nd10401 4.703731681333e+01
RINT20973 nd10371 nd10402 4.703731681333e+01
RINT20974 nd10372 nd10403 9.751427556557e+02
RINT20975 nd10373 nd10404 7.013769373582e+01
RINT20976 nd10374 nd10405 1.555759253601e+03
RINT20977 nd10375 nd10406 6.482330223337e+00
RINT20978 nd10376 nd10407 6.482330223337e+00
RINT20979 nd10377 nd10408 6.482330223337e+00
RINT20980 nd10378 nd10409 6.482330223337e+00
RINT20981 nd10379 nd10410 6.482330223337e+00
RINT20982 nd10380 nd10411 6.482330223337e+00
RINT20983 nd10381 nd10412 6.482330223337e+00
RINT20984 nd10382 nd10413 6.482330223337e+00
RINT20985 nd10383 nd10414 6.482330223337e+00
RINT20986 nd10384 nd10415 6.482330223337e+00
RINT20987 nd10416 nd10447 9.847510605046e+01
RINT20988 nd10417 nd10448 8.503373819163e+01
RINT20989 nd10418 nd10449 8.503373819163e+01
RINT20990 nd10419 nd10450 4.933541084432e+03
RINT20991 nd10420 nd10451 1.750138877867e+02
RINT20992 nd10421 nd10452 1.762517482517e+02
RINT20993 nd10422 nd10453 1.762517482517e+02
RINT20994 nd10423 nd10454 7.001111111111e+03
RINT20995 nd10424 nd10455 1.166851851852e+03
RINT20996 nd10425 nd10456 2.000317460317e+03
RINT20997 nd10426 nd10457 2.000317460317e+03
RINT20998 nd10427 nd10458 2.000317460317e+03
RINT20999 nd10428 nd10459 2.000317460317e+03
RINT21000 nd10429 nd10460 2.000317460317e+03
RINT21001 nd10430 nd10461 2.000317460317e+03
RINT21002 nd10431 nd10462 2.000317460317e+03
RINT21003 nd10432 nd10463 4.445149911817e+02
RINT21004 nd10433 nd10464 4.445149911817e+02
RINT21005 nd10434 nd10465 9.215355015920e+03
RINT21006 nd10435 nd10466 6.628196169481e+02
RINT21007 nd10436 nd10467 1.470233333333e+04
RINT21008 nd10437 nd10468 6.125972222222e+01
RINT21009 nd10438 nd10469 6.125972222222e+01
RINT21010 nd10439 nd10470 6.125972222222e+01
RINT21011 nd10440 nd10471 6.125972222222e+01
RINT21012 nd10441 nd10472 6.125972222222e+01
RINT21013 nd10442 nd10473 6.125972222222e+01
RINT21014 nd10443 nd10474 6.125972222222e+01
RINT21015 nd10444 nd10475 6.125972222222e+01
RINT21016 nd10445 nd10476 6.125972222222e+01
RINT21017 nd10446 nd10477 6.125972222222e+01
RINT21018 nd10447 nd10478 9.847510605046e+01
RINT21019 nd10448 nd10479 8.503373819163e+01
RINT21020 nd10449 nd10480 8.503373819163e+01
RINT21021 nd10450 nd10481 4.933541084432e+03
RINT21022 nd10451 nd10482 1.750138877867e+02
RINT21023 nd10452 nd10483 1.762517482517e+02
RINT21024 nd10453 nd10484 1.762517482517e+02
RINT21025 nd10454 nd10485 7.001111111111e+03
RINT21026 nd10455 nd10486 1.166851851852e+03
RINT21027 nd10456 nd10487 2.000317460317e+03
RINT21028 nd10457 nd10488 2.000317460317e+03
RINT21029 nd10458 nd10489 2.000317460317e+03
RINT21030 nd10459 nd10490 2.000317460317e+03
RINT21031 nd10460 nd10491 2.000317460317e+03
RINT21032 nd10461 nd10492 2.000317460317e+03
RINT21033 nd10462 nd10493 2.000317460317e+03
RINT21034 nd10463 nd10494 4.445149911817e+02
RINT21035 nd10464 nd10495 4.445149911817e+02
RINT21036 nd10465 nd10496 9.215355015920e+03
RINT21037 nd10466 nd10497 6.628196169481e+02
RINT21038 nd10467 nd10498 1.470233333333e+04
RINT21039 nd10468 nd10499 6.125972222222e+01
RINT21040 nd10469 nd10500 6.125972222222e+01
RINT21041 nd10470 nd10501 6.125972222222e+01
RINT21042 nd10471 nd10502 6.125972222222e+01
RINT21043 nd10472 nd10503 6.125972222222e+01
RINT21044 nd10473 nd10504 6.125972222222e+01
RINT21045 nd10474 nd10505 6.125972222222e+01
RINT21046 nd10475 nd10506 6.125972222222e+01
RINT21047 nd10476 nd10507 6.125972222222e+01
RINT21048 nd10477 nd10508 6.125972222222e+01
RINT21049 nd10478 nd10509 5.593547666890e+01
RINT21050 nd10479 nd10510 4.830055909003e+01
RINT21051 nd10480 nd10511 4.830055909003e+01
RINT21052 nd10481 nd10512 2.802332318199e+03
RINT21053 nd10482 nd10513 9.941076105071e+01
RINT21054 nd10483 nd10514 1.001138861139e+02
RINT21055 nd10484 nd10515 1.001138861139e+02
RINT21056 nd10485 nd10516 3.475055555556e+04
RINT21057 nd10486 nd10517 5.791759259259e+03
RINT21058 nd10487 nd10518 9.928730158730e+03
RINT21059 nd10488 nd10519 9.928730158730e+03
RINT21060 nd10489 nd10520 9.928730158730e+03
RINT21061 nd10490 nd10521 9.928730158730e+03
RINT21062 nd10491 nd10522 9.928730158730e+03
RINT21063 nd10492 nd10523 9.928730158730e+03
RINT21064 nd10493 nd10524 9.928730158730e+03
RINT21065 nd10494 nd10525 2.206384479718e+03
RINT21066 nd10495 nd10526 2.206384479718e+03
RINT21067 nd10496 nd10527 5.234472915668e+03
RINT21068 nd10497 nd10528 3.764924223640e+02
RINT21069 nd10498 nd10529 8.351166666667e+03
RINT21070 nd10499 nd10530 3.479652777778e+01
RINT21071 nd10500 nd10531 3.479652777778e+01
RINT21072 nd10501 nd10532 3.479652777778e+01
RINT21073 nd10502 nd10533 3.479652777778e+01
RINT21074 nd10503 nd10534 3.479652777778e+01
RINT21075 nd10504 nd10535 3.479652777778e+01
RINT21076 nd10505 nd10536 3.479652777778e+01
RINT21077 nd10506 nd10537 3.479652777778e+01
RINT21078 nd10507 nd10538 3.479652777778e+01
RINT21079 nd10508 nd10539 3.479652777778e+01
RINT21080 nd10509 nd10540 7.082876200045e+01
RINT21081 nd10510 nd10541 6.116098419125e+01
RINT21082 nd10511 nd10542 6.116098419125e+01
RINT21083 nd10512 nd10543 3.548476577518e+03
RINT21084 nd10513 nd10544 1.258797020078e+02
RINT21085 nd10514 nd10545 1.267700399600e+02
RINT21086 nd10515 nd10546 1.267700399600e+02
RINT21087 nd10516 nd10547 3.304604427083e+05
RINT21088 nd10517 nd10548 5.507674045139e+04
RINT21089 nd10518 nd10549 9.441726934524e+04
RINT21090 nd10519 nd10550 9.441726934524e+04
RINT21091 nd10520 nd10551 9.441726934524e+04
RINT21092 nd10521 nd10552 9.441726934524e+04
RINT21093 nd10522 nd10553 9.441726934524e+04
RINT21094 nd10523 nd10554 9.441726934524e+04
RINT21095 nd10524 nd10555 9.441726934524e+04
RINT21096 nd10525 nd10556 2.098161541005e+04
RINT21097 nd10526 nd10557 2.098161541005e+04
RINT21098 nd10527 nd10558 6.628194813396e+03
RINT21099 nd10528 nd10559 4.767366574247e+02
RINT21100 nd10529 nd10560 1.057473416667e+04
RINT21101 nd10530 nd10561 4.406139236111e+01
RINT21102 nd10531 nd10562 4.406139236111e+01
RINT21103 nd10532 nd10563 4.406139236111e+01
RINT21104 nd10533 nd10564 4.406139236111e+01
RINT21105 nd10534 nd10565 4.406139236111e+01
RINT21106 nd10535 nd10566 4.406139236111e+01
RINT21107 nd10536 nd10567 4.406139236111e+01
RINT21108 nd10537 nd10568 4.406139236111e+01
RINT21109 nd10538 nd10569 4.406139236111e+01
RINT21110 nd10539 nd10570 4.406139236111e+01
RINT21111 nd10540 nd10571 1.282616767136e+02
RINT21112 nd10541 nd10572 1.107545883941e+02
RINT21113 nd10542 nd10573 1.107545883941e+02
RINT21114 nd10543 nd10574 6.425829603070e+03
RINT21115 nd10544 nd10575 2.279517697008e+02
RINT21116 nd10545 nd10576 2.295640559441e+02
RINT21117 nd10546 nd10577 2.295640559441e+02
RINT21118 nd10547 nd10578 5.984208854167e+05
RINT21119 nd10548 nd10579 9.973681423611e+04
RINT21120 nd10549 nd10580 1.709773958333e+05
RINT21121 nd10550 nd10581 1.709773958333e+05
RINT21122 nd10551 nd10582 1.709773958333e+05
RINT21123 nd10552 nd10583 1.709773958333e+05
RINT21124 nd10553 nd10584 1.709773958333e+05
RINT21125 nd10554 nd10585 1.709773958333e+05
RINT21126 nd10555 nd10586 1.709773958333e+05
RINT21127 nd10556 nd10587 3.799497685185e+04
RINT21128 nd10557 nd10588 3.799497685185e+04
RINT21129 nd10558 nd10589 1.200279881138e+04
RINT21130 nd10559 nd10590 8.633080870696e+02
RINT21131 nd10560 nd10591 1.914946833333e+04
RINT21132 nd10561 nd10592 7.978945138889e+01
RINT21133 nd10562 nd10593 7.978945138889e+01
RINT21134 nd10563 nd10594 7.978945138889e+01
RINT21135 nd10564 nd10595 7.978945138889e+01
RINT21136 nd10565 nd10596 7.978945138889e+01
RINT21137 nd10566 nd10597 7.978945138889e+01
RINT21138 nd10567 nd10598 7.978945138889e+01
RINT21139 nd10568 nd10599 7.978945138889e+01
RINT21140 nd10569 nd10600 7.978945138889e+01
RINT21141 nd10570 nd10601 7.978945138889e+01
RINT21142 nd10571 nd10602 1.282616767136e+02
RINT21143 nd10572 nd10603 1.107545883941e+02
RINT21144 nd10573 nd10604 1.107545883941e+02
RINT21145 nd10574 nd10605 6.425829603070e+03
RINT21146 nd10575 nd10606 2.279517697008e+02
RINT21147 nd10576 nd10607 2.295640559441e+02
RINT21148 nd10577 nd10608 2.295640559441e+02
RINT21149 nd10578 nd10609 5.984208854167e+05
RINT21150 nd10579 nd10610 9.973681423611e+04
RINT21151 nd10580 nd10611 1.709773958333e+05
RINT21152 nd10581 nd10612 1.709773958333e+05
RINT21153 nd10582 nd10613 1.709773958333e+05
RINT21154 nd10583 nd10614 1.709773958333e+05
RINT21155 nd10584 nd10615 1.709773958333e+05
RINT21156 nd10585 nd10616 1.709773958333e+05
RINT21157 nd10586 nd10617 1.709773958333e+05
RINT21158 nd10587 nd10618 3.799497685185e+04
RINT21159 nd10588 nd10619 3.799497685185e+04
RINT21160 nd10589 nd10620 1.200279881138e+04
RINT21161 nd10590 nd10621 8.633080870696e+02
RINT21162 nd10591 nd10622 1.914946833333e+04
RINT21163 nd10592 nd10623 7.978945138889e+01
RINT21164 nd10593 nd10624 7.978945138889e+01
RINT21165 nd10594 nd10625 7.978945138889e+01
RINT21166 nd10595 nd10626 7.978945138889e+01
RINT21167 nd10596 nd10627 7.978945138889e+01
RINT21168 nd10597 nd10628 7.978945138889e+01
RINT21169 nd10598 nd10629 7.978945138889e+01
RINT21170 nd10599 nd10630 7.978945138889e+01
RINT21171 nd10600 nd10631 7.978945138889e+01
RINT21172 nd10601 nd10632 7.978945138889e+01
RINT21173 nd10602 nd10633 1.282616767136e+02
RINT21174 nd10603 nd10634 1.107545883941e+02
RINT21175 nd10604 nd10635 1.107545883941e+02
RINT21176 nd10605 nd10636 6.425829603070e+03
RINT21177 nd10606 nd10637 2.279517697008e+02
RINT21178 nd10607 nd10638 2.295640559441e+02
RINT21179 nd10608 nd10639 2.295640559441e+02
RINT21180 nd10609 nd10640 5.984208854167e+05
RINT21181 nd10610 nd10641 9.973681423611e+04
RINT21182 nd10611 nd10642 1.709773958333e+05
RINT21183 nd10612 nd10643 1.709773958333e+05
RINT21184 nd10613 nd10644 1.709773958333e+05
RINT21185 nd10614 nd10645 1.709773958333e+05
RINT21186 nd10615 nd10646 1.709773958333e+05
RINT21187 nd10616 nd10647 1.709773958333e+05
RINT21188 nd10617 nd10648 1.709773958333e+05
RINT21189 nd10618 nd10649 3.799497685185e+04
RINT21190 nd10619 nd10650 3.799497685185e+04
RINT21191 nd10620 nd10651 1.200279881138e+04
RINT21192 nd10621 nd10652 8.633080870696e+02
RINT21193 nd10622 nd10653 1.914946833333e+04
RINT21194 nd10623 nd10654 7.978945138889e+01
RINT21195 nd10624 nd10655 7.978945138889e+01
RINT21196 nd10625 nd10656 7.978945138889e+01
RINT21197 nd10626 nd10657 7.978945138889e+01
RINT21198 nd10627 nd10658 7.978945138889e+01
RINT21199 nd10628 nd10659 7.978945138889e+01
RINT21200 nd10629 nd10660 7.978945138889e+01
RINT21201 nd10630 nd10661 7.978945138889e+01
RINT21202 nd10631 nd10662 7.978945138889e+01
RINT21203 nd10632 nd10663 7.978945138889e+01
RINT21204 nd10633 nd10664 1.282616767136e+02
RINT21205 nd10634 nd10665 1.107545883941e+02
RINT21206 nd10635 nd10666 1.107545883941e+02
RINT21207 nd10636 nd10667 6.425829603070e+03
RINT21208 nd10637 nd10668 2.279517697008e+02
RINT21209 nd10638 nd10669 2.295640559441e+02
RINT21210 nd10639 nd10670 2.295640559441e+02
RINT21211 nd10640 nd10671 5.984208854167e+05
RINT21212 nd10641 nd10672 9.973681423611e+04
RINT21213 nd10642 nd10673 1.709773958333e+05
RINT21214 nd10643 nd10674 1.709773958333e+05
RINT21215 nd10644 nd10675 1.709773958333e+05
RINT21216 nd10645 nd10676 1.709773958333e+05
RINT21217 nd10646 nd10677 1.709773958333e+05
RINT21218 nd10647 nd10678 1.709773958333e+05
RINT21219 nd10648 nd10679 1.709773958333e+05
RINT21220 nd10649 nd10680 3.799497685185e+04
RINT21221 nd10650 nd10681 3.799497685185e+04
RINT21222 nd10651 nd10682 1.200279881138e+04
RINT21223 nd10652 nd10683 8.633080870696e+02
RINT21224 nd10653 nd10684 1.914946833333e+04
RINT21225 nd10654 nd10685 7.978945138889e+01
RINT21226 nd10655 nd10686 7.978945138889e+01
RINT21227 nd10656 nd10687 7.978945138889e+01
RINT21228 nd10657 nd10688 7.978945138889e+01
RINT21229 nd10658 nd10689 7.978945138889e+01
RINT21230 nd10659 nd10690 7.978945138889e+01
RINT21231 nd10660 nd10691 7.978945138889e+01
RINT21232 nd10661 nd10692 7.978945138889e+01
RINT21233 nd10662 nd10693 7.978945138889e+01
RINT21234 nd10663 nd10694 7.978945138889e+01
RINT21235 nd10664 nd10695 1.282616767136e+02
RINT21236 nd10665 nd10696 1.107545883941e+02
RINT21237 nd10666 nd10697 1.107545883941e+02
RINT21238 nd10667 nd10698 6.425829603070e+03
RINT21239 nd10668 nd10699 2.279517697008e+02
RINT21240 nd10669 nd10700 2.295640559441e+02
RINT21241 nd10670 nd10701 2.295640559441e+02
RINT21242 nd10671 nd10702 5.984208854167e+05
RINT21243 nd10672 nd10703 9.973681423611e+04
RINT21244 nd10673 nd10704 1.709773958333e+05
RINT21245 nd10674 nd10705 1.709773958333e+05
RINT21246 nd10675 nd10706 1.709773958333e+05
RINT21247 nd10676 nd10707 1.709773958333e+05
RINT21248 nd10677 nd10708 1.709773958333e+05
RINT21249 nd10678 nd10709 1.709773958333e+05
RINT21250 nd10679 nd10710 1.709773958333e+05
RINT21251 nd10680 nd10711 3.799497685185e+04
RINT21252 nd10681 nd10712 3.799497685185e+04
RINT21253 nd10682 nd10713 1.200279881138e+04
RINT21254 nd10683 nd10714 8.633080870696e+02
RINT21255 nd10684 nd10715 1.914946833333e+04
RINT21256 nd10685 nd10716 7.978945138889e+01
RINT21257 nd10686 nd10717 7.978945138889e+01
RINT21258 nd10687 nd10718 7.978945138889e+01
RINT21259 nd10688 nd10719 7.978945138889e+01
RINT21260 nd10689 nd10720 7.978945138889e+01
RINT21261 nd10690 nd10721 7.978945138889e+01
RINT21262 nd10691 nd10722 7.978945138889e+01
RINT21263 nd10692 nd10723 7.978945138889e+01
RINT21264 nd10693 nd10724 7.978945138889e+01
RINT21265 nd10694 nd10725 7.978945138889e+01
RINT21266 nd10695 nd10726 7.082876200045e+01
RINT21267 nd10696 nd10727 6.116098419125e+01
RINT21268 nd10697 nd10728 6.116098419125e+01
RINT21269 nd10698 nd10729 3.548476577518e+03
RINT21270 nd10699 nd10730 1.258797020078e+02
RINT21271 nd10700 nd10731 1.267700399600e+02
RINT21272 nd10701 nd10732 1.267700399600e+02
RINT21273 nd10702 nd10733 3.304604427083e+05
RINT21274 nd10703 nd10734 5.507674045139e+04
RINT21275 nd10704 nd10735 9.441726934524e+04
RINT21276 nd10705 nd10736 9.441726934524e+04
RINT21277 nd10706 nd10737 9.441726934524e+04
RINT21278 nd10707 nd10738 9.441726934524e+04
RINT21279 nd10708 nd10739 9.441726934524e+04
RINT21280 nd10709 nd10740 9.441726934524e+04
RINT21281 nd10710 nd10741 9.441726934524e+04
RINT21282 nd10711 nd10742 2.098161541005e+04
RINT21283 nd10712 nd10743 2.098161541005e+04
RINT21284 nd10713 nd10744 6.628194813396e+03
RINT21285 nd10714 nd10745 4.767366574247e+02
RINT21286 nd10715 nd10746 1.057473416667e+04
RINT21287 nd10716 nd10747 4.406139236111e+01
RINT21288 nd10717 nd10748 4.406139236111e+01
RINT21289 nd10718 nd10749 4.406139236111e+01
RINT21290 nd10719 nd10750 4.406139236111e+01
RINT21291 nd10720 nd10751 4.406139236111e+01
RINT21292 nd10721 nd10752 4.406139236111e+01
RINT21293 nd10722 nd10753 4.406139236111e+01
RINT21294 nd10723 nd10754 4.406139236111e+01
RINT21295 nd10724 nd10755 4.406139236111e+01
RINT21296 nd10725 nd10756 4.406139236111e+01
RINT21297 nd10726 nd10757 7.082876200045e+01
RINT21298 nd10727 nd10758 6.116098419125e+01
RINT21299 nd10728 nd10759 6.116098419125e+01
RINT21300 nd10729 nd10760 3.548476577518e+03
RINT21301 nd10730 nd10761 1.258797020078e+02
RINT21302 nd10731 nd10762 1.267700399600e+02
RINT21303 nd10732 nd10763 1.267700399600e+02
RINT21304 nd10733 nd10764 3.304604427083e+05
RINT21305 nd10734 nd10765 5.507674045139e+04
RINT21306 nd10735 nd10766 9.441726934524e+04
RINT21307 nd10736 nd10767 9.441726934524e+04
RINT21308 nd10737 nd10768 9.441726934524e+04
RINT21309 nd10738 nd10769 9.441726934524e+04
RINT21310 nd10739 nd10770 9.441726934524e+04
RINT21311 nd10740 nd10771 9.441726934524e+04
RINT21312 nd10741 nd10772 9.441726934524e+04
RINT21313 nd10742 nd10773 2.098161541005e+04
RINT21314 nd10743 nd10774 2.098161541005e+04
RINT21315 nd10744 nd10775 6.628194813396e+03
RINT21316 nd10745 nd10776 4.767366574247e+02
RINT21317 nd10746 nd10777 1.057473416667e+04
RINT21318 nd10747 nd10778 4.406139236111e+01
RINT21319 nd10748 nd10779 4.406139236111e+01
RINT21320 nd10749 nd10780 4.406139236111e+01
RINT21321 nd10750 nd10781 4.406139236111e+01
RINT21322 nd10751 nd10782 4.406139236111e+01
RINT21323 nd10752 nd10783 4.406139236111e+01
RINT21324 nd10753 nd10784 4.406139236111e+01
RINT21325 nd10754 nd10785 4.406139236111e+01
RINT21326 nd10755 nd10786 4.406139236111e+01
RINT21327 nd10756 nd10787 4.406139236111e+01
RINT21328 nd10757 nd10788 1.282616767136e+02
RINT21329 nd10758 nd10789 1.107545883941e+02
RINT21330 nd10759 nd10790 1.107545883941e+02
RINT21331 nd10760 nd10791 6.425829603070e+03
RINT21332 nd10761 nd10792 2.279517697008e+02
RINT21333 nd10762 nd10793 2.295640559441e+02
RINT21334 nd10763 nd10794 2.295640559441e+02
RINT21335 nd10764 nd10795 5.984208854167e+05
RINT21336 nd10765 nd10796 9.973681423611e+04
RINT21337 nd10766 nd10797 1.709773958333e+05
RINT21338 nd10767 nd10798 1.709773958333e+05
RINT21339 nd10768 nd10799 1.709773958333e+05
RINT21340 nd10769 nd10800 1.709773958333e+05
RINT21341 nd10770 nd10801 1.709773958333e+05
RINT21342 nd10771 nd10802 1.709773958333e+05
RINT21343 nd10772 nd10803 1.709773958333e+05
RINT21344 nd10773 nd10804 3.799497685185e+04
RINT21345 nd10774 nd10805 3.799497685185e+04
RINT21346 nd10775 nd10806 1.200279881138e+04
RINT21347 nd10776 nd10807 8.633080870696e+02
RINT21348 nd10777 nd10808 1.914946833333e+04
RINT21349 nd10778 nd10809 7.978945138889e+01
RINT21350 nd10779 nd10810 7.978945138889e+01
RINT21351 nd10780 nd10811 7.978945138889e+01
RINT21352 nd10781 nd10812 7.978945138889e+01
RINT21353 nd10782 nd10813 7.978945138889e+01
RINT21354 nd10783 nd10814 7.978945138889e+01
RINT21355 nd10784 nd10815 7.978945138889e+01
RINT21356 nd10785 nd10816 7.978945138889e+01
RINT21357 nd10786 nd10817 7.978945138889e+01
RINT21358 nd10787 nd10818 7.978945138889e+01
RINT21359 nd10788 nd10819 1.282616767136e+02
RINT21360 nd10789 nd10820 1.107545883941e+02
RINT21361 nd10790 nd10821 1.107545883941e+02
RINT21362 nd10791 nd10822 6.425829603070e+03
RINT21363 nd10792 nd10823 2.279517697008e+02
RINT21364 nd10793 nd10824 2.295640559441e+02
RINT21365 nd10794 nd10825 2.295640559441e+02
RINT21366 nd10795 nd10826 5.984208854167e+05
RINT21367 nd10796 nd10827 9.973681423611e+04
RINT21368 nd10797 nd10828 1.709773958333e+05
RINT21369 nd10798 nd10829 1.709773958333e+05
RINT21370 nd10799 nd10830 1.709773958333e+05
RINT21371 nd10800 nd10831 1.709773958333e+05
RINT21372 nd10801 nd10832 1.709773958333e+05
RINT21373 nd10802 nd10833 1.709773958333e+05
RINT21374 nd10803 nd10834 1.709773958333e+05
RINT21375 nd10804 nd10835 3.799497685185e+04
RINT21376 nd10805 nd10836 3.799497685185e+04
RINT21377 nd10806 nd10837 1.200279881138e+04
RINT21378 nd10807 nd10838 8.633080870696e+02
RINT21379 nd10808 nd10839 1.914946833333e+04
RINT21380 nd10809 nd10840 7.978945138889e+01
RINT21381 nd10810 nd10841 7.978945138889e+01
RINT21382 nd10811 nd10842 7.978945138889e+01
RINT21383 nd10812 nd10843 7.978945138889e+01
RINT21384 nd10813 nd10844 7.978945138889e+01
RINT21385 nd10814 nd10845 7.978945138889e+01
RINT21386 nd10815 nd10846 7.978945138889e+01
RINT21387 nd10816 nd10847 7.978945138889e+01
RINT21388 nd10817 nd10848 7.978945138889e+01
RINT21389 nd10818 nd10849 7.978945138889e+01
RINT21390 nd10819 nd10850 1.282616767136e+02
RINT21391 nd10820 nd10851 1.107545883941e+02
RINT21392 nd10821 nd10852 1.107545883941e+02
RINT21393 nd10822 nd10853 6.425829603070e+03
RINT21394 nd10823 nd10854 2.279517697008e+02
RINT21395 nd10824 nd10855 2.295640559441e+02
RINT21396 nd10825 nd10856 2.295640559441e+02
RINT21397 nd10826 nd10857 5.984208854167e+05
RINT21398 nd10827 nd10858 9.973681423611e+04
RINT21399 nd10828 nd10859 1.709773958333e+05
RINT21400 nd10829 nd10860 1.709773958333e+05
RINT21401 nd10830 nd10861 1.709773958333e+05
RINT21402 nd10831 nd10862 1.709773958333e+05
RINT21403 nd10832 nd10863 1.709773958333e+05
RINT21404 nd10833 nd10864 1.709773958333e+05
RINT21405 nd10834 nd10865 1.709773958333e+05
RINT21406 nd10835 nd10866 3.799497685185e+04
RINT21407 nd10836 nd10867 3.799497685185e+04
RINT21408 nd10837 nd10868 1.200279881138e+04
RINT21409 nd10838 nd10869 8.633080870696e+02
RINT21410 nd10839 nd10870 1.914946833333e+04
RINT21411 nd10840 nd10871 7.978945138889e+01
RINT21412 nd10841 nd10872 7.978945138889e+01
RINT21413 nd10842 nd10873 7.978945138889e+01
RINT21414 nd10843 nd10874 7.978945138889e+01
RINT21415 nd10844 nd10875 7.978945138889e+01
RINT21416 nd10845 nd10876 7.978945138889e+01
RINT21417 nd10846 nd10877 7.978945138889e+01
RINT21418 nd10847 nd10878 7.978945138889e+01
RINT21419 nd10848 nd10879 7.978945138889e+01
RINT21420 nd10849 nd10880 7.978945138889e+01
RINT21421 nd10850 nd10881 1.282616767136e+02
RINT21422 nd10851 nd10882 1.107545883941e+02
RINT21423 nd10852 nd10883 1.107545883941e+02
RINT21424 nd10853 nd10884 6.425829603070e+03
RINT21425 nd10854 nd10885 2.279517697008e+02
RINT21426 nd10855 nd10886 2.295640559441e+02
RINT21427 nd10856 nd10887 2.295640559441e+02
RINT21428 nd10857 nd10888 5.984208854167e+05
RINT21429 nd10858 nd10889 9.973681423611e+04
RINT21430 nd10859 nd10890 1.709773958333e+05
RINT21431 nd10860 nd10891 1.709773958333e+05
RINT21432 nd10861 nd10892 1.709773958333e+05
RINT21433 nd10862 nd10893 1.709773958333e+05
RINT21434 nd10863 nd10894 1.709773958333e+05
RINT21435 nd10864 nd10895 1.709773958333e+05
RINT21436 nd10865 nd10896 1.709773958333e+05
RINT21437 nd10866 nd10897 3.799497685185e+04
RINT21438 nd10867 nd10898 3.799497685185e+04
RINT21439 nd10868 nd10899 1.200279881138e+04
RINT21440 nd10869 nd10900 8.633080870696e+02
RINT21441 nd10870 nd10901 1.914946833333e+04
RINT21442 nd10871 nd10902 7.978945138889e+01
RINT21443 nd10872 nd10903 7.978945138889e+01
RINT21444 nd10873 nd10904 7.978945138889e+01
RINT21445 nd10874 nd10905 7.978945138889e+01
RINT21446 nd10875 nd10906 7.978945138889e+01
RINT21447 nd10876 nd10907 7.978945138889e+01
RINT21448 nd10877 nd10908 7.978945138889e+01
RINT21449 nd10878 nd10909 7.978945138889e+01
RINT21450 nd10879 nd10910 7.978945138889e+01
RINT21451 nd10880 nd10911 7.978945138889e+01
RINT21452 nd10881 nd10912 1.282616767136e+02
RINT21453 nd10882 nd10913 1.107545883941e+02
RINT21454 nd10883 nd10914 1.107545883941e+02
RINT21455 nd10884 nd10915 6.425829603070e+03
RINT21456 nd10885 nd10916 2.279517697008e+02
RINT21457 nd10886 nd10917 2.295640559441e+02
RINT21458 nd10887 nd10918 2.295640559441e+02
RINT21459 nd10888 nd10919 5.984208854167e+05
RINT21460 nd10889 nd10920 9.973681423611e+04
RINT21461 nd10890 nd10921 1.709773958333e+05
RINT21462 nd10891 nd10922 1.709773958333e+05
RINT21463 nd10892 nd10923 1.709773958333e+05
RINT21464 nd10893 nd10924 1.709773958333e+05
RINT21465 nd10894 nd10925 1.709773958333e+05
RINT21466 nd10895 nd10926 1.709773958333e+05
RINT21467 nd10896 nd10927 1.709773958333e+05
RINT21468 nd10897 nd10928 3.799497685185e+04
RINT21469 nd10898 nd10929 3.799497685185e+04
RINT21470 nd10899 nd10930 1.200279881138e+04
RINT21471 nd10900 nd10931 8.633080870696e+02
RINT21472 nd10901 nd10932 1.914946833333e+04
RINT21473 nd10902 nd10933 7.978945138889e+01
RINT21474 nd10903 nd10934 7.978945138889e+01
RINT21475 nd10904 nd10935 7.978945138889e+01
RINT21476 nd10905 nd10936 7.978945138889e+01
RINT21477 nd10906 nd10937 7.978945138889e+01
RINT21478 nd10907 nd10938 7.978945138889e+01
RINT21479 nd10908 nd10939 7.978945138889e+01
RINT21480 nd10909 nd10940 7.978945138889e+01
RINT21481 nd10910 nd10941 7.978945138889e+01
RINT21482 nd10911 nd10942 7.978945138889e+01
RINT21483 nd10912 nd10943 7.082876200045e+01
RINT21484 nd10913 nd10944 6.116098419125e+01
RINT21485 nd10914 nd10945 6.116098419125e+01
RINT21486 nd10915 nd10946 3.548476577518e+03
RINT21487 nd10916 nd10947 1.258797020078e+02
RINT21488 nd10917 nd10948 1.267700399600e+02
RINT21489 nd10918 nd10949 1.267700399600e+02
RINT21490 nd10919 nd10950 3.304604427083e+05
RINT21491 nd10920 nd10951 5.507674045139e+04
RINT21492 nd10921 nd10952 9.441726934524e+04
RINT21493 nd10922 nd10953 9.441726934524e+04
RINT21494 nd10923 nd10954 9.441726934524e+04
RINT21495 nd10924 nd10955 9.441726934524e+04
RINT21496 nd10925 nd10956 9.441726934524e+04
RINT21497 nd10926 nd10957 9.441726934524e+04
RINT21498 nd10927 nd10958 9.441726934524e+04
RINT21499 nd10928 nd10959 2.098161541005e+04
RINT21500 nd10929 nd10960 2.098161541005e+04
RINT21501 nd10930 nd10961 6.628194813396e+03
RINT21502 nd10931 nd10962 4.767366574247e+02
RINT21503 nd10932 nd10963 1.057473416667e+04
RINT21504 nd10933 nd10964 4.406139236111e+01
RINT21505 nd10934 nd10965 4.406139236111e+01
RINT21506 nd10935 nd10966 4.406139236111e+01
RINT21507 nd10936 nd10967 4.406139236111e+01
RINT21508 nd10937 nd10968 4.406139236111e+01
RINT21509 nd10938 nd10969 4.406139236111e+01
RINT21510 nd10939 nd10970 4.406139236111e+01
RINT21511 nd10940 nd10971 4.406139236111e+01
RINT21512 nd10941 nd10972 4.406139236111e+01
RINT21513 nd10942 nd10973 4.406139236111e+01
RINT21514 nd10943 nd10974 5.593547666890e+01
RINT21515 nd10944 nd10975 4.830055909003e+01
RINT21516 nd10945 nd10976 4.830055909003e+01
RINT21517 nd10946 nd10977 2.802332318199e+03
RINT21518 nd10947 nd10978 9.941076105071e+01
RINT21519 nd10948 nd10979 1.001138861139e+02
RINT21520 nd10949 nd10980 1.001138861139e+02
RINT21521 nd10950 nd10981 3.475055555556e+04
RINT21522 nd10951 nd10982 5.791759259259e+03
RINT21523 nd10952 nd10983 9.928730158730e+03
RINT21524 nd10953 nd10984 9.928730158730e+03
RINT21525 nd10954 nd10985 9.928730158730e+03
RINT21526 nd10955 nd10986 9.928730158730e+03
RINT21527 nd10956 nd10987 9.928730158730e+03
RINT21528 nd10957 nd10988 9.928730158730e+03
RINT21529 nd10958 nd10989 9.928730158730e+03
RINT21530 nd10959 nd10990 2.206384479718e+03
RINT21531 nd10960 nd10991 2.206384479718e+03
RINT21532 nd10961 nd10992 5.234472915668e+03
RINT21533 nd10962 nd10993 3.764924223640e+02
RINT21534 nd10963 nd10994 8.351166666667e+03
RINT21535 nd10964 nd10995 3.479652777778e+01
RINT21536 nd10965 nd10996 3.479652777778e+01
RINT21537 nd10966 nd10997 3.479652777778e+01
RINT21538 nd10967 nd10998 3.479652777778e+01
RINT21539 nd10968 nd10999 3.479652777778e+01
RINT21540 nd10969 nd11000 3.479652777778e+01
RINT21541 nd10970 nd11001 3.479652777778e+01
RINT21542 nd10971 nd11002 3.479652777778e+01
RINT21543 nd10972 nd11003 3.479652777778e+01
RINT21544 nd10973 nd11004 3.479652777778e+01
RINT21545 nd10974 nd11005 9.847510605046e+01
RINT21546 nd10975 nd11006 8.503373819163e+01
RINT21547 nd10976 nd11007 8.503373819163e+01
RINT21548 nd10977 nd11008 4.933541084432e+03
RINT21549 nd10978 nd11009 1.750138877867e+02
RINT21550 nd10979 nd11010 1.762517482517e+02
RINT21551 nd10980 nd11011 1.762517482517e+02
RINT21552 nd10981 nd11012 7.001111111111e+03
RINT21553 nd10982 nd11013 1.166851851852e+03
RINT21554 nd10983 nd11014 2.000317460317e+03
RINT21555 nd10984 nd11015 2.000317460317e+03
RINT21556 nd10985 nd11016 2.000317460317e+03
RINT21557 nd10986 nd11017 2.000317460317e+03
RINT21558 nd10987 nd11018 2.000317460317e+03
RINT21559 nd10988 nd11019 2.000317460317e+03
RINT21560 nd10989 nd11020 2.000317460317e+03
RINT21561 nd10990 nd11021 4.445149911817e+02
RINT21562 nd10991 nd11022 4.445149911817e+02
RINT21563 nd10992 nd11023 9.215355015920e+03
RINT21564 nd10993 nd11024 6.628196169481e+02
RINT21565 nd10994 nd11025 1.470233333333e+04
RINT21566 nd10995 nd11026 6.125972222222e+01
RINT21567 nd10996 nd11027 6.125972222222e+01
RINT21568 nd10997 nd11028 6.125972222222e+01
RINT21569 nd10998 nd11029 6.125972222222e+01
RINT21570 nd10999 nd11030 6.125972222222e+01
RINT21571 nd11000 nd11031 6.125972222222e+01
RINT21572 nd11001 nd11032 6.125972222222e+01
RINT21573 nd11002 nd11033 6.125972222222e+01
RINT21574 nd11003 nd11034 6.125972222222e+01
RINT21575 nd11004 nd11035 6.125972222222e+01
RINT21576 nd11005 nd11036 9.847510605046e+01
RINT21577 nd11006 nd11037 8.503373819163e+01
RINT21578 nd11007 nd11038 8.503373819163e+01
RINT21579 nd11008 nd11039 4.933541084432e+03
RINT21580 nd11009 nd11040 1.750138877867e+02
RINT21581 nd11010 nd11041 1.762517482517e+02
RINT21582 nd11011 nd11042 1.762517482517e+02
RINT21583 nd11012 nd11043 7.001111111111e+03
RINT21584 nd11013 nd11044 1.166851851852e+03
RINT21585 nd11014 nd11045 2.000317460317e+03
RINT21586 nd11015 nd11046 2.000317460317e+03
RINT21587 nd11016 nd11047 2.000317460317e+03
RINT21588 nd11017 nd11048 2.000317460317e+03
RINT21589 nd11018 nd11049 2.000317460317e+03
RINT21590 nd11019 nd11050 2.000317460317e+03
RINT21591 nd11020 nd11051 2.000317460317e+03
RINT21592 nd11021 nd11052 4.445149911817e+02
RINT21593 nd11022 nd11053 4.445149911817e+02
RINT21594 nd11023 nd11054 9.215355015920e+03
RINT21595 nd11024 nd11055 6.628196169481e+02
RINT21596 nd11025 nd11056 1.470233333333e+04
RINT21597 nd11026 nd11057 6.125972222222e+01
RINT21598 nd11027 nd11058 6.125972222222e+01
RINT21599 nd11028 nd11059 6.125972222222e+01
RINT21600 nd11029 nd11060 6.125972222222e+01
RINT21601 nd11030 nd11061 6.125972222222e+01
RINT21602 nd11031 nd11062 6.125972222222e+01
RINT21603 nd11032 nd11063 6.125972222222e+01
RINT21604 nd11033 nd11064 6.125972222222e+01
RINT21605 nd11034 nd11065 6.125972222222e+01
RINT21606 nd11035 nd11066 6.125972222222e+01
RINT21607 nd11067 nd11098 1.951190200973e+01
RINT21608 nd11068 nd11099 1.684862330858e+01
RINT21609 nd11069 nd11100 1.684862330858e+01
RINT21610 nd11070 nd11101 9.775340597358e+02
RINT21611 nd11071 nd11102 3.467733080771e+01
RINT21612 nd11072 nd11103 3.492260103959e+01
RINT21613 nd11073 nd11104 3.492260103959e+01
RINT21614 nd11074 nd11105 1.387203319073e+03
RINT21615 nd11075 nd11106 2.312005531788e+02
RINT21616 nd11076 nd11107 3.963438054494e+02
RINT21617 nd11077 nd11108 3.963438054493e+02
RINT21618 nd11078 nd11109 3.963438054494e+02
RINT21619 nd11079 nd11110 3.963438054493e+02
RINT21620 nd11080 nd11111 3.963438054494e+02
RINT21621 nd11081 nd11112 3.963438054494e+02
RINT21622 nd11082 nd11113 3.963438054493e+02
RINT21623 nd11083 nd11114 8.807640121097e+01
RINT21624 nd11084 nd11115 8.807640121097e+01
RINT21625 nd11085 nd11116 1.825934606898e+03
RINT21626 nd11086 nd11117 1.313313784033e+02
RINT21627 nd11087 nd11118 2.913126970053e+03
RINT21628 nd11088 nd11119 1.213802904189e+01
RINT21629 nd11089 nd11120 1.213802904189e+01
RINT21630 nd11090 nd11121 1.213802904189e+01
RINT21631 nd11091 nd11122 1.213802904189e+01
RINT21632 nd11092 nd11123 1.213802904189e+01
RINT21633 nd11093 nd11124 1.213802904189e+01
RINT21634 nd11094 nd11125 1.213802904189e+01
RINT21635 nd11095 nd11126 1.213802904189e+01
RINT21636 nd11096 nd11127 1.213802904189e+01
RINT21637 nd11097 nd11128 1.213802904189e+01
RINT21638 nd11098 nd11129 1.951190200973e+01
RINT21639 nd11099 nd11130 1.684862330858e+01
RINT21640 nd11100 nd11131 1.684862330858e+01
RINT21641 nd11101 nd11132 9.775340597358e+02
RINT21642 nd11102 nd11133 3.467733080771e+01
RINT21643 nd11103 nd11134 3.492260103959e+01
RINT21644 nd11104 nd11135 3.492260103959e+01
RINT21645 nd11105 nd11136 1.387203319073e+03
RINT21646 nd11106 nd11137 2.312005531788e+02
RINT21647 nd11107 nd11138 3.963438054494e+02
RINT21648 nd11108 nd11139 3.963438054493e+02
RINT21649 nd11109 nd11140 3.963438054494e+02
RINT21650 nd11110 nd11141 3.963438054493e+02
RINT21651 nd11111 nd11142 3.963438054494e+02
RINT21652 nd11112 nd11143 3.963438054494e+02
RINT21653 nd11113 nd11144 3.963438054493e+02
RINT21654 nd11114 nd11145 8.807640121097e+01
RINT21655 nd11115 nd11146 8.807640121097e+01
RINT21656 nd11116 nd11147 1.825934606898e+03
RINT21657 nd11117 nd11148 1.313313784033e+02
RINT21658 nd11118 nd11149 2.913126970053e+03
RINT21659 nd11119 nd11150 1.213802904189e+01
RINT21660 nd11120 nd11151 1.213802904189e+01
RINT21661 nd11121 nd11152 1.213802904189e+01
RINT21662 nd11122 nd11153 1.213802904189e+01
RINT21663 nd11123 nd11154 1.213802904189e+01
RINT21664 nd11124 nd11155 1.213802904189e+01
RINT21665 nd11125 nd11156 1.213802904189e+01
RINT21666 nd11126 nd11157 1.213802904189e+01
RINT21667 nd11127 nd11158 1.213802904189e+01
RINT21668 nd11128 nd11159 1.213802904189e+01
RINT21669 nd11129 nd11160 1.108308062214e+01
RINT21670 nd11130 nd11161 9.570294603156e+00
RINT21671 nd11131 nd11162 9.570294603156e+00
RINT21672 nd11132 nd11163 5.552553917880e+02
RINT21673 nd11133 nd11164 1.969729311426e+01
RINT21674 nd11134 nd11165 1.983661063200e+01
RINT21675 nd11135 nd11166 1.983661063200e+01
RINT21676 nd11136 nd11167 7.879542556598e+02
RINT21677 nd11137 nd11168 1.313257092766e+02
RINT21678 nd11138 nd11169 2.251297873314e+02
RINT21679 nd11139 nd11170 2.251297873314e+02
RINT21680 nd11140 nd11171 2.251297873314e+02
RINT21681 nd11141 nd11172 2.251297873314e+02
RINT21682 nd11142 nd11173 2.251297873314e+02
RINT21683 nd11143 nd11174 2.251297873314e+02
RINT21684 nd11144 nd11175 2.251297873314e+02
RINT21685 nd11145 nd11176 5.002884162920e+01
RINT21686 nd11146 nd11177 5.002884162920e+01
RINT21687 nd11147 nd11178 1.037160828756e+03
RINT21688 nd11148 nd11179 7.459837868880e+01
RINT21689 nd11149 nd11180 1.654703936886e+03
RINT21690 nd11150 nd11181 6.894599737024e+00
RINT21691 nd11151 nd11182 6.894599737024e+00
RINT21692 nd11152 nd11183 6.894599737024e+00
RINT21693 nd11153 nd11184 6.894599737024e+00
RINT21694 nd11154 nd11185 6.894599737024e+00
RINT21695 nd11155 nd11186 6.894599737024e+00
RINT21696 nd11156 nd11187 6.894599737024e+00
RINT21697 nd11157 nd11188 6.894599737024e+00
RINT21698 nd11158 nd11189 6.894599737024e+00
RINT21699 nd11159 nd11190 6.894599737024e+00
RINT21700 nd11160 nd11191 1.403404290740e+01
RINT21701 nd11161 nd11192 1.211846504381e+01
RINT21702 nd11162 nd11193 1.211846504381e+01
RINT21703 nd11163 nd11194 7.030967524816e+02
RINT21704 nd11164 nd11195 2.494186103574e+01
RINT21705 nd11165 nd11196 2.511827299990e+01
RINT21706 nd11166 nd11197 2.511827299990e+01
RINT21707 nd11167 nd11198 9.977536219406e+02
RINT21708 nd11168 nd11199 1.662922703234e+02
RINT21709 nd11169 nd11200 2.850724634116e+02
RINT21710 nd11170 nd11201 2.850724634116e+02
RINT21711 nd11171 nd11202 2.850724634116e+02
RINT21712 nd11172 nd11203 2.850724634116e+02
RINT21713 nd11173 nd11204 2.850724634116e+02
RINT21714 nd11174 nd11205 2.850724634116e+02
RINT21715 nd11175 nd11206 2.850724634116e+02
RINT21716 nd11176 nd11207 6.334943631369e+01
RINT21717 nd11177 nd11208 6.334943631369e+01
RINT21718 nd11178 nd11209 1.313313515338e+03
RINT21719 nd11179 nd11210 9.446081672003e+01
RINT21720 nd11180 nd11211 2.095282606075e+03
RINT21721 nd11181 nd11212 8.730344191980e+00
RINT21722 nd11182 nd11213 8.730344191980e+00
RINT21723 nd11183 nd11214 8.730344191980e+00
RINT21724 nd11184 nd11215 8.730344191980e+00
RINT21725 nd11185 nd11216 8.730344191980e+00
RINT21726 nd11186 nd11217 8.730344191980e+00
RINT21727 nd11187 nd11218 8.730344191980e+00
RINT21728 nd11188 nd11219 8.730344191980e+00
RINT21729 nd11189 nd11220 8.730344191980e+00
RINT21730 nd11190 nd11221 8.730344191980e+00
RINT21731 nd11191 nd11222 2.541382658025e+01
RINT21732 nd11192 nd11223 2.194496418989e+01
RINT21733 nd11193 nd11224 2.194496418989e+01
RINT21734 nd11194 nd11225 1.273216781123e+03
RINT21735 nd11195 nd11226 4.516646665065e+01
RINT21736 nd11196 nd11227 4.548592577541e+01
RINT21737 nd11197 nd11228 4.548592577541e+01
RINT21738 nd11198 nd11229 1.806802051634e+03
RINT21739 nd11199 nd11230 3.011336752724e+02
RINT21740 nd11200 nd11231 5.162291576098e+02
RINT21741 nd11201 nd11232 5.162291576098e+02
RINT21742 nd11202 nd11233 5.162291576098e+02
RINT21743 nd11203 nd11234 5.162291576098e+02
RINT21744 nd11204 nd11235 5.162291576098e+02
RINT21745 nd11205 nd11236 5.162291576098e+02
RINT21746 nd11206 nd11237 5.162291576098e+02
RINT21747 nd11207 nd11238 1.147175905800e+02
RINT21748 nd11208 nd11239 1.147175905800e+02
RINT21749 nd11209 nd11240 2.378239980062e+03
RINT21750 nd11210 nd11241 1.710562544657e+02
RINT21751 nd11211 nd11242 3.794284308432e+03
RINT21752 nd11212 nd11243 1.580951795180e+01
RINT21753 nd11213 nd11244 1.580951795180e+01
RINT21754 nd11214 nd11245 1.580951795180e+01
RINT21755 nd11215 nd11246 1.580951795180e+01
RINT21756 nd11216 nd11247 1.580951795180e+01
RINT21757 nd11217 nd11248 1.580951795180e+01
RINT21758 nd11218 nd11249 1.580951795180e+01
RINT21759 nd11219 nd11250 1.580951795180e+01
RINT21760 nd11220 nd11251 1.580951795180e+01
RINT21761 nd11221 nd11252 1.580951795180e+01
RINT21762 nd11222 nd11253 2.541382658025e+01
RINT21763 nd11223 nd11254 2.194496418989e+01
RINT21764 nd11224 nd11255 2.194496418989e+01
RINT21765 nd11225 nd11256 1.273216781123e+03
RINT21766 nd11226 nd11257 4.516646665065e+01
RINT21767 nd11227 nd11258 4.548592577541e+01
RINT21768 nd11228 nd11259 4.548592577541e+01
RINT21769 nd11229 nd11260 1.806802051634e+03
RINT21770 nd11230 nd11261 3.011336752724e+02
RINT21771 nd11231 nd11262 5.162291576098e+02
RINT21772 nd11232 nd11263 5.162291576098e+02
RINT21773 nd11233 nd11264 5.162291576098e+02
RINT21774 nd11234 nd11265 5.162291576098e+02
RINT21775 nd11235 nd11266 5.162291576098e+02
RINT21776 nd11236 nd11267 5.162291576098e+02
RINT21777 nd11237 nd11268 5.162291576098e+02
RINT21778 nd11238 nd11269 1.147175905800e+02
RINT21779 nd11239 nd11270 1.147175905800e+02
RINT21780 nd11240 nd11271 2.378239980062e+03
RINT21781 nd11241 nd11272 1.710562544657e+02
RINT21782 nd11242 nd11273 3.794284308432e+03
RINT21783 nd11243 nd11274 1.580951795180e+01
RINT21784 nd11244 nd11275 1.580951795180e+01
RINT21785 nd11245 nd11276 1.580951795180e+01
RINT21786 nd11246 nd11277 1.580951795180e+01
RINT21787 nd11247 nd11278 1.580951795180e+01
RINT21788 nd11248 nd11279 1.580951795180e+01
RINT21789 nd11249 nd11280 1.580951795180e+01
RINT21790 nd11250 nd11281 1.580951795180e+01
RINT21791 nd11251 nd11282 1.580951795180e+01
RINT21792 nd11252 nd11283 1.580951795180e+01
RINT21793 nd11253 nd11284 2.541382658025e+01
RINT21794 nd11254 nd11285 2.194496418989e+01
RINT21795 nd11255 nd11286 2.194496418989e+01
RINT21796 nd11256 nd11287 1.273216781123e+03
RINT21797 nd11257 nd11288 4.516646665065e+01
RINT21798 nd11258 nd11289 4.548592577541e+01
RINT21799 nd11259 nd11290 4.548592577541e+01
RINT21800 nd11260 nd11291 1.806802051634e+03
RINT21801 nd11261 nd11292 3.011336752724e+02
RINT21802 nd11262 nd11293 5.162291576098e+02
RINT21803 nd11263 nd11294 5.162291576098e+02
RINT21804 nd11264 nd11295 5.162291576098e+02
RINT21805 nd11265 nd11296 5.162291576098e+02
RINT21806 nd11266 nd11297 5.162291576098e+02
RINT21807 nd11267 nd11298 5.162291576098e+02
RINT21808 nd11268 nd11299 5.162291576098e+02
RINT21809 nd11269 nd11300 1.147175905800e+02
RINT21810 nd11270 nd11301 1.147175905800e+02
RINT21811 nd11271 nd11302 2.378239980062e+03
RINT21812 nd11272 nd11303 1.710562544657e+02
RINT21813 nd11273 nd11304 3.794284308432e+03
RINT21814 nd11274 nd11305 1.580951795180e+01
RINT21815 nd11275 nd11306 1.580951795180e+01
RINT21816 nd11276 nd11307 1.580951795180e+01
RINT21817 nd11277 nd11308 1.580951795180e+01
RINT21818 nd11278 nd11309 1.580951795180e+01
RINT21819 nd11279 nd11310 1.580951795180e+01
RINT21820 nd11280 nd11311 1.580951795180e+01
RINT21821 nd11281 nd11312 1.580951795180e+01
RINT21822 nd11282 nd11313 1.580951795180e+01
RINT21823 nd11283 nd11314 1.580951795180e+01
RINT21824 nd11284 nd11315 2.541382658025e+01
RINT21825 nd11285 nd11316 2.194496418989e+01
RINT21826 nd11286 nd11317 2.194496418989e+01
RINT21827 nd11287 nd11318 1.273216781123e+03
RINT21828 nd11288 nd11319 4.516646665065e+01
RINT21829 nd11289 nd11320 4.548592577541e+01
RINT21830 nd11290 nd11321 4.548592577541e+01
RINT21831 nd11291 nd11322 1.806802051634e+03
RINT21832 nd11292 nd11323 3.011336752724e+02
RINT21833 nd11293 nd11324 5.162291576098e+02
RINT21834 nd11294 nd11325 5.162291576098e+02
RINT21835 nd11295 nd11326 5.162291576098e+02
RINT21836 nd11296 nd11327 5.162291576098e+02
RINT21837 nd11297 nd11328 5.162291576098e+02
RINT21838 nd11298 nd11329 5.162291576098e+02
RINT21839 nd11299 nd11330 5.162291576098e+02
RINT21840 nd11300 nd11331 1.147175905800e+02
RINT21841 nd11301 nd11332 1.147175905800e+02
RINT21842 nd11302 nd11333 2.378239980062e+03
RINT21843 nd11303 nd11334 1.710562544657e+02
RINT21844 nd11304 nd11335 3.794284308432e+03
RINT21845 nd11305 nd11336 1.580951795180e+01
RINT21846 nd11306 nd11337 1.580951795180e+01
RINT21847 nd11307 nd11338 1.580951795180e+01
RINT21848 nd11308 nd11339 1.580951795180e+01
RINT21849 nd11309 nd11340 1.580951795180e+01
RINT21850 nd11310 nd11341 1.580951795180e+01
RINT21851 nd11311 nd11342 1.580951795180e+01
RINT21852 nd11312 nd11343 1.580951795180e+01
RINT21853 nd11313 nd11344 1.580951795180e+01
RINT21854 nd11314 nd11345 1.580951795180e+01
RINT21855 nd11315 nd11346 2.541382658025e+01
RINT21856 nd11316 nd11347 2.194496418989e+01
RINT21857 nd11317 nd11348 2.194496418989e+01
RINT21858 nd11318 nd11349 1.273216781123e+03
RINT21859 nd11319 nd11350 4.516646665065e+01
RINT21860 nd11320 nd11351 4.548592577541e+01
RINT21861 nd11321 nd11352 4.548592577541e+01
RINT21862 nd11322 nd11353 1.806802051634e+03
RINT21863 nd11323 nd11354 3.011336752724e+02
RINT21864 nd11324 nd11355 5.162291576098e+02
RINT21865 nd11325 nd11356 5.162291576098e+02
RINT21866 nd11326 nd11357 5.162291576098e+02
RINT21867 nd11327 nd11358 5.162291576098e+02
RINT21868 nd11328 nd11359 5.162291576098e+02
RINT21869 nd11329 nd11360 5.162291576098e+02
RINT21870 nd11330 nd11361 5.162291576098e+02
RINT21871 nd11331 nd11362 1.147175905800e+02
RINT21872 nd11332 nd11363 1.147175905800e+02
RINT21873 nd11333 nd11364 2.378239980062e+03
RINT21874 nd11334 nd11365 1.710562544657e+02
RINT21875 nd11335 nd11366 3.794284308432e+03
RINT21876 nd11336 nd11367 1.580951795180e+01
RINT21877 nd11337 nd11368 1.580951795180e+01
RINT21878 nd11338 nd11369 1.580951795180e+01
RINT21879 nd11339 nd11370 1.580951795180e+01
RINT21880 nd11340 nd11371 1.580951795180e+01
RINT21881 nd11341 nd11372 1.580951795180e+01
RINT21882 nd11342 nd11373 1.580951795180e+01
RINT21883 nd11343 nd11374 1.580951795180e+01
RINT21884 nd11344 nd11375 1.580951795180e+01
RINT21885 nd11345 nd11376 1.580951795180e+01
RINT21886 nd11346 nd11377 1.403404290740e+01
RINT21887 nd11347 nd11378 1.211846504381e+01
RINT21888 nd11348 nd11379 1.211846504381e+01
RINT21889 nd11349 nd11380 7.030967524816e+02
RINT21890 nd11350 nd11381 2.494186103574e+01
RINT21891 nd11351 nd11382 2.511827299990e+01
RINT21892 nd11352 nd11383 2.511827299990e+01
RINT21893 nd11353 nd11384 9.977536219406e+02
RINT21894 nd11354 nd11385 1.662922703234e+02
RINT21895 nd11355 nd11386 2.850724634116e+02
RINT21896 nd11356 nd11387 2.850724634116e+02
RINT21897 nd11357 nd11388 2.850724634116e+02
RINT21898 nd11358 nd11389 2.850724634116e+02
RINT21899 nd11359 nd11390 2.850724634116e+02
RINT21900 nd11360 nd11391 2.850724634116e+02
RINT21901 nd11361 nd11392 2.850724634116e+02
RINT21902 nd11362 nd11393 6.334943631369e+01
RINT21903 nd11363 nd11394 6.334943631369e+01
RINT21904 nd11364 nd11395 1.313313515338e+03
RINT21905 nd11365 nd11396 9.446081672003e+01
RINT21906 nd11366 nd11397 2.095282606075e+03
RINT21907 nd11367 nd11398 8.730344191980e+00
RINT21908 nd11368 nd11399 8.730344191980e+00
RINT21909 nd11369 nd11400 8.730344191980e+00
RINT21910 nd11370 nd11401 8.730344191980e+00
RINT21911 nd11371 nd11402 8.730344191980e+00
RINT21912 nd11372 nd11403 8.730344191980e+00
RINT21913 nd11373 nd11404 8.730344191980e+00
RINT21914 nd11374 nd11405 8.730344191980e+00
RINT21915 nd11375 nd11406 8.730344191980e+00
RINT21916 nd11376 nd11407 8.730344191980e+00
RINT21917 nd11377 nd11408 1.403404290740e+01
RINT21918 nd11378 nd11409 1.211846504381e+01
RINT21919 nd11379 nd11410 1.211846504381e+01
RINT21920 nd11380 nd11411 7.030967524816e+02
RINT21921 nd11381 nd11412 2.494186103574e+01
RINT21922 nd11382 nd11413 2.511827299990e+01
RINT21923 nd11383 nd11414 2.511827299990e+01
RINT21924 nd11384 nd11415 9.977536219406e+02
RINT21925 nd11385 nd11416 1.662922703234e+02
RINT21926 nd11386 nd11417 2.850724634116e+02
RINT21927 nd11387 nd11418 2.850724634116e+02
RINT21928 nd11388 nd11419 2.850724634116e+02
RINT21929 nd11389 nd11420 2.850724634116e+02
RINT21930 nd11390 nd11421 2.850724634116e+02
RINT21931 nd11391 nd11422 2.850724634116e+02
RINT21932 nd11392 nd11423 2.850724634116e+02
RINT21933 nd11393 nd11424 6.334943631369e+01
RINT21934 nd11394 nd11425 6.334943631369e+01
RINT21935 nd11395 nd11426 1.313313515338e+03
RINT21936 nd11396 nd11427 9.446081672003e+01
RINT21937 nd11397 nd11428 2.095282606075e+03
RINT21938 nd11398 nd11429 8.730344191980e+00
RINT21939 nd11399 nd11430 8.730344191980e+00
RINT21940 nd11400 nd11431 8.730344191980e+00
RINT21941 nd11401 nd11432 8.730344191980e+00
RINT21942 nd11402 nd11433 8.730344191980e+00
RINT21943 nd11403 nd11434 8.730344191980e+00
RINT21944 nd11404 nd11435 8.730344191980e+00
RINT21945 nd11405 nd11436 8.730344191980e+00
RINT21946 nd11406 nd11437 8.730344191980e+00
RINT21947 nd11407 nd11438 8.730344191980e+00
RINT21948 nd11408 nd11439 2.541382658025e+01
RINT21949 nd11409 nd11440 2.194496418989e+01
RINT21950 nd11410 nd11441 2.194496418989e+01
RINT21951 nd11411 nd11442 1.273216781123e+03
RINT21952 nd11412 nd11443 4.516646665065e+01
RINT21953 nd11413 nd11444 4.548592577541e+01
RINT21954 nd11414 nd11445 4.548592577541e+01
RINT21955 nd11415 nd11446 1.806802051634e+03
RINT21956 nd11416 nd11447 3.011336752724e+02
RINT21957 nd11417 nd11448 5.162291576098e+02
RINT21958 nd11418 nd11449 5.162291576098e+02
RINT21959 nd11419 nd11450 5.162291576098e+02
RINT21960 nd11420 nd11451 5.162291576098e+02
RINT21961 nd11421 nd11452 5.162291576098e+02
RINT21962 nd11422 nd11453 5.162291576098e+02
RINT21963 nd11423 nd11454 5.162291576098e+02
RINT21964 nd11424 nd11455 1.147175905800e+02
RINT21965 nd11425 nd11456 1.147175905800e+02
RINT21966 nd11426 nd11457 2.378239980062e+03
RINT21967 nd11427 nd11458 1.710562544657e+02
RINT21968 nd11428 nd11459 3.794284308432e+03
RINT21969 nd11429 nd11460 1.580951795180e+01
RINT21970 nd11430 nd11461 1.580951795180e+01
RINT21971 nd11431 nd11462 1.580951795180e+01
RINT21972 nd11432 nd11463 1.580951795180e+01
RINT21973 nd11433 nd11464 1.580951795180e+01
RINT21974 nd11434 nd11465 1.580951795180e+01
RINT21975 nd11435 nd11466 1.580951795180e+01
RINT21976 nd11436 nd11467 1.580951795180e+01
RINT21977 nd11437 nd11468 1.580951795180e+01
RINT21978 nd11438 nd11469 1.580951795180e+01
RINT21979 nd11439 nd11470 2.541382658025e+01
RINT21980 nd11440 nd11471 2.194496418989e+01
RINT21981 nd11441 nd11472 2.194496418989e+01
RINT21982 nd11442 nd11473 1.273216781123e+03
RINT21983 nd11443 nd11474 4.516646665065e+01
RINT21984 nd11444 nd11475 4.548592577541e+01
RINT21985 nd11445 nd11476 4.548592577541e+01
RINT21986 nd11446 nd11477 1.806802051634e+03
RINT21987 nd11447 nd11478 3.011336752724e+02
RINT21988 nd11448 nd11479 5.162291576098e+02
RINT21989 nd11449 nd11480 5.162291576098e+02
RINT21990 nd11450 nd11481 5.162291576098e+02
RINT21991 nd11451 nd11482 5.162291576098e+02
RINT21992 nd11452 nd11483 5.162291576098e+02
RINT21993 nd11453 nd11484 5.162291576098e+02
RINT21994 nd11454 nd11485 5.162291576098e+02
RINT21995 nd11455 nd11486 1.147175905800e+02
RINT21996 nd11456 nd11487 1.147175905800e+02
RINT21997 nd11457 nd11488 2.378239980062e+03
RINT21998 nd11458 nd11489 1.710562544657e+02
RINT21999 nd11459 nd11490 3.794284308432e+03
RINT22000 nd11460 nd11491 1.580951795180e+01
RINT22001 nd11461 nd11492 1.580951795180e+01
RINT22002 nd11462 nd11493 1.580951795180e+01
RINT22003 nd11463 nd11494 1.580951795180e+01
RINT22004 nd11464 nd11495 1.580951795180e+01
RINT22005 nd11465 nd11496 1.580951795180e+01
RINT22006 nd11466 nd11497 1.580951795180e+01
RINT22007 nd11467 nd11498 1.580951795180e+01
RINT22008 nd11468 nd11499 1.580951795180e+01
RINT22009 nd11469 nd11500 1.580951795180e+01
RINT22010 nd11470 nd11501 2.541382658025e+01
RINT22011 nd11471 nd11502 2.194496418989e+01
RINT22012 nd11472 nd11503 2.194496418989e+01
RINT22013 nd11473 nd11504 1.273216781123e+03
RINT22014 nd11474 nd11505 4.516646665065e+01
RINT22015 nd11475 nd11506 4.548592577541e+01
RINT22016 nd11476 nd11507 4.548592577541e+01
RINT22017 nd11477 nd11508 1.806802051634e+03
RINT22018 nd11478 nd11509 3.011336752724e+02
RINT22019 nd11479 nd11510 5.162291576098e+02
RINT22020 nd11480 nd11511 5.162291576098e+02
RINT22021 nd11481 nd11512 5.162291576098e+02
RINT22022 nd11482 nd11513 5.162291576098e+02
RINT22023 nd11483 nd11514 5.162291576098e+02
RINT22024 nd11484 nd11515 5.162291576098e+02
RINT22025 nd11485 nd11516 5.162291576098e+02
RINT22026 nd11486 nd11517 1.147175905800e+02
RINT22027 nd11487 nd11518 1.147175905800e+02
RINT22028 nd11488 nd11519 2.378239980062e+03
RINT22029 nd11489 nd11520 1.710562544657e+02
RINT22030 nd11490 nd11521 3.794284308432e+03
RINT22031 nd11491 nd11522 1.580951795180e+01
RINT22032 nd11492 nd11523 1.580951795180e+01
RINT22033 nd11493 nd11524 1.580951795180e+01
RINT22034 nd11494 nd11525 1.580951795180e+01
RINT22035 nd11495 nd11526 1.580951795180e+01
RINT22036 nd11496 nd11527 1.580951795180e+01
RINT22037 nd11497 nd11528 1.580951795180e+01
RINT22038 nd11498 nd11529 1.580951795180e+01
RINT22039 nd11499 nd11530 1.580951795180e+01
RINT22040 nd11500 nd11531 1.580951795180e+01
RINT22041 nd11501 nd11532 2.541382658025e+01
RINT22042 nd11502 nd11533 2.194496418989e+01
RINT22043 nd11503 nd11534 2.194496418989e+01
RINT22044 nd11504 nd11535 1.273216781123e+03
RINT22045 nd11505 nd11536 4.516646665065e+01
RINT22046 nd11506 nd11537 4.548592577541e+01
RINT22047 nd11507 nd11538 4.548592577541e+01
RINT22048 nd11508 nd11539 1.806802051634e+03
RINT22049 nd11509 nd11540 3.011336752724e+02
RINT22050 nd11510 nd11541 5.162291576098e+02
RINT22051 nd11511 nd11542 5.162291576098e+02
RINT22052 nd11512 nd11543 5.162291576098e+02
RINT22053 nd11513 nd11544 5.162291576098e+02
RINT22054 nd11514 nd11545 5.162291576098e+02
RINT22055 nd11515 nd11546 5.162291576098e+02
RINT22056 nd11516 nd11547 5.162291576098e+02
RINT22057 nd11517 nd11548 1.147175905800e+02
RINT22058 nd11518 nd11549 1.147175905800e+02
RINT22059 nd11519 nd11550 2.378239980062e+03
RINT22060 nd11520 nd11551 1.710562544657e+02
RINT22061 nd11521 nd11552 3.794284308432e+03
RINT22062 nd11522 nd11553 1.580951795180e+01
RINT22063 nd11523 nd11554 1.580951795180e+01
RINT22064 nd11524 nd11555 1.580951795180e+01
RINT22065 nd11525 nd11556 1.580951795180e+01
RINT22066 nd11526 nd11557 1.580951795180e+01
RINT22067 nd11527 nd11558 1.580951795180e+01
RINT22068 nd11528 nd11559 1.580951795180e+01
RINT22069 nd11529 nd11560 1.580951795180e+01
RINT22070 nd11530 nd11561 1.580951795180e+01
RINT22071 nd11531 nd11562 1.580951795180e+01
RINT22072 nd11532 nd11563 2.541382658025e+01
RINT22073 nd11533 nd11564 2.194496418989e+01
RINT22074 nd11534 nd11565 2.194496418989e+01
RINT22075 nd11535 nd11566 1.273216781123e+03
RINT22076 nd11536 nd11567 4.516646665065e+01
RINT22077 nd11537 nd11568 4.548592577541e+01
RINT22078 nd11538 nd11569 4.548592577541e+01
RINT22079 nd11539 nd11570 1.806802051634e+03
RINT22080 nd11540 nd11571 3.011336752724e+02
RINT22081 nd11541 nd11572 5.162291576098e+02
RINT22082 nd11542 nd11573 5.162291576098e+02
RINT22083 nd11543 nd11574 5.162291576098e+02
RINT22084 nd11544 nd11575 5.162291576098e+02
RINT22085 nd11545 nd11576 5.162291576098e+02
RINT22086 nd11546 nd11577 5.162291576098e+02
RINT22087 nd11547 nd11578 5.162291576098e+02
RINT22088 nd11548 nd11579 1.147175905800e+02
RINT22089 nd11549 nd11580 1.147175905800e+02
RINT22090 nd11550 nd11581 2.378239980062e+03
RINT22091 nd11551 nd11582 1.710562544657e+02
RINT22092 nd11552 nd11583 3.794284308432e+03
RINT22093 nd11553 nd11584 1.580951795180e+01
RINT22094 nd11554 nd11585 1.580951795180e+01
RINT22095 nd11555 nd11586 1.580951795180e+01
RINT22096 nd11556 nd11587 1.580951795180e+01
RINT22097 nd11557 nd11588 1.580951795180e+01
RINT22098 nd11558 nd11589 1.580951795180e+01
RINT22099 nd11559 nd11590 1.580951795180e+01
RINT22100 nd11560 nd11591 1.580951795180e+01
RINT22101 nd11561 nd11592 1.580951795180e+01
RINT22102 nd11562 nd11593 1.580951795180e+01
RINT22103 nd11563 nd11594 1.403404290740e+01
RINT22104 nd11564 nd11595 1.211846504381e+01
RINT22105 nd11565 nd11596 1.211846504381e+01
RINT22106 nd11566 nd11597 7.030967524816e+02
RINT22107 nd11567 nd11598 2.494186103574e+01
RINT22108 nd11568 nd11599 2.511827299990e+01
RINT22109 nd11569 nd11600 2.511827299990e+01
RINT22110 nd11570 nd11601 9.977536219406e+02
RINT22111 nd11571 nd11602 1.662922703234e+02
RINT22112 nd11572 nd11603 2.850724634116e+02
RINT22113 nd11573 nd11604 2.850724634116e+02
RINT22114 nd11574 nd11605 2.850724634116e+02
RINT22115 nd11575 nd11606 2.850724634116e+02
RINT22116 nd11576 nd11607 2.850724634116e+02
RINT22117 nd11577 nd11608 2.850724634116e+02
RINT22118 nd11578 nd11609 2.850724634116e+02
RINT22119 nd11579 nd11610 6.334943631369e+01
RINT22120 nd11580 nd11611 6.334943631369e+01
RINT22121 nd11581 nd11612 1.313313515338e+03
RINT22122 nd11582 nd11613 9.446081672003e+01
RINT22123 nd11583 nd11614 2.095282606075e+03
RINT22124 nd11584 nd11615 8.730344191980e+00
RINT22125 nd11585 nd11616 8.730344191980e+00
RINT22126 nd11586 nd11617 8.730344191980e+00
RINT22127 nd11587 nd11618 8.730344191980e+00
RINT22128 nd11588 nd11619 8.730344191980e+00
RINT22129 nd11589 nd11620 8.730344191980e+00
RINT22130 nd11590 nd11621 8.730344191980e+00
RINT22131 nd11591 nd11622 8.730344191980e+00
RINT22132 nd11592 nd11623 8.730344191980e+00
RINT22133 nd11593 nd11624 8.730344191980e+00
RINT22134 nd11594 nd11625 1.108308062214e+01
RINT22135 nd11595 nd11626 9.570294603156e+00
RINT22136 nd11596 nd11627 9.570294603156e+00
RINT22137 nd11597 nd11628 5.552553917880e+02
RINT22138 nd11598 nd11629 1.969729311426e+01
RINT22139 nd11599 nd11630 1.983661063200e+01
RINT22140 nd11600 nd11631 1.983661063200e+01
RINT22141 nd11601 nd11632 7.879542556598e+02
RINT22142 nd11602 nd11633 1.313257092766e+02
RINT22143 nd11603 nd11634 2.251297873314e+02
RINT22144 nd11604 nd11635 2.251297873314e+02
RINT22145 nd11605 nd11636 2.251297873314e+02
RINT22146 nd11606 nd11637 2.251297873314e+02
RINT22147 nd11607 nd11638 2.251297873314e+02
RINT22148 nd11608 nd11639 2.251297873314e+02
RINT22149 nd11609 nd11640 2.251297873314e+02
RINT22150 nd11610 nd11641 5.002884162920e+01
RINT22151 nd11611 nd11642 5.002884162920e+01
RINT22152 nd11612 nd11643 1.037160828756e+03
RINT22153 nd11613 nd11644 7.459837868880e+01
RINT22154 nd11614 nd11645 1.654703936886e+03
RINT22155 nd11615 nd11646 6.894599737024e+00
RINT22156 nd11616 nd11647 6.894599737024e+00
RINT22157 nd11617 nd11648 6.894599737024e+00
RINT22158 nd11618 nd11649 6.894599737024e+00
RINT22159 nd11619 nd11650 6.894599737024e+00
RINT22160 nd11620 nd11651 6.894599737024e+00
RINT22161 nd11621 nd11652 6.894599737024e+00
RINT22162 nd11622 nd11653 6.894599737024e+00
RINT22163 nd11623 nd11654 6.894599737024e+00
RINT22164 nd11624 nd11655 6.894599737024e+00
RINT22165 nd11625 nd11656 1.951190200973e+01
RINT22166 nd11626 nd11657 1.684862330858e+01
RINT22167 nd11627 nd11658 1.684862330858e+01
RINT22168 nd11628 nd11659 9.775340597358e+02
RINT22169 nd11629 nd11660 3.467733080771e+01
RINT22170 nd11630 nd11661 3.492260103959e+01
RINT22171 nd11631 nd11662 3.492260103959e+01
RINT22172 nd11632 nd11663 1.387203319073e+03
RINT22173 nd11633 nd11664 2.312005531788e+02
RINT22174 nd11634 nd11665 3.963438054493e+02
RINT22175 nd11635 nd11666 3.963438054493e+02
RINT22176 nd11636 nd11667 3.963438054493e+02
RINT22177 nd11637 nd11668 3.963438054493e+02
RINT22178 nd11638 nd11669 3.963438054493e+02
RINT22179 nd11639 nd11670 3.963438054493e+02
RINT22180 nd11640 nd11671 3.963438054493e+02
RINT22181 nd11641 nd11672 8.807640121097e+01
RINT22182 nd11642 nd11673 8.807640121097e+01
RINT22183 nd11643 nd11674 1.825934606898e+03
RINT22184 nd11644 nd11675 1.313313784033e+02
RINT22185 nd11645 nd11676 2.913126970053e+03
RINT22186 nd11646 nd11677 1.213802904189e+01
RINT22187 nd11647 nd11678 1.213802904189e+01
RINT22188 nd11648 nd11679 1.213802904189e+01
RINT22189 nd11649 nd11680 1.213802904189e+01
RINT22190 nd11650 nd11681 1.213802904189e+01
RINT22191 nd11651 nd11682 1.213802904189e+01
RINT22192 nd11652 nd11683 1.213802904189e+01
RINT22193 nd11653 nd11684 1.213802904189e+01
RINT22194 nd11654 nd11685 1.213802904189e+01
RINT22195 nd11655 nd11686 1.213802904189e+01
RINT22196 nd11656 nd11687 1.951190200973e+01
RINT22197 nd11657 nd11688 1.684862330858e+01
RINT22198 nd11658 nd11689 1.684862330858e+01
RINT22199 nd11659 nd11690 9.775340597358e+02
RINT22200 nd11660 nd11691 3.467733080771e+01
RINT22201 nd11661 nd11692 3.492260103959e+01
RINT22202 nd11662 nd11693 3.492260103959e+01
RINT22203 nd11663 nd11694 1.387203319073e+03
RINT22204 nd11664 nd11695 2.312005531788e+02
RINT22205 nd11665 nd11696 3.963438054493e+02
RINT22206 nd11666 nd11697 3.963438054493e+02
RINT22207 nd11667 nd11698 3.963438054493e+02
RINT22208 nd11668 nd11699 3.963438054493e+02
RINT22209 nd11669 nd11700 3.963438054493e+02
RINT22210 nd11670 nd11701 3.963438054493e+02
RINT22211 nd11671 nd11702 3.963438054493e+02
RINT22212 nd11672 nd11703 8.807640121097e+01
RINT22213 nd11673 nd11704 8.807640121097e+01
RINT22214 nd11674 nd11705 1.825934606898e+03
RINT22215 nd11675 nd11706 1.313313784033e+02
RINT22216 nd11676 nd11707 2.913126970053e+03
RINT22217 nd11677 nd11708 1.213802904189e+01
RINT22218 nd11678 nd11709 1.213802904189e+01
RINT22219 nd11679 nd11710 1.213802904189e+01
RINT22220 nd11680 nd11711 1.213802904189e+01
RINT22221 nd11681 nd11712 1.213802904189e+01
RINT22222 nd11682 nd11713 1.213802904189e+01
RINT22223 nd11683 nd11714 1.213802904189e+01
RINT22224 nd11684 nd11715 1.213802904189e+01
RINT22225 nd11685 nd11716 1.213802904189e+01
RINT22226 nd11686 nd11717 1.213802904189e+01
RINT22227 nd0 nd1 4.668678698020e-01
RINT22228 nd1 nd2 4.243707687709e-01
RINT22229 nd2 nd3 1.434437286031e+01
RINT22230 nd3 nd4 1.458717554935e+01
RINT22231 nd4 nd5 8.947905065228e-01
RINT22232 nd5 nd6 8.796048661798e-01
RINT22233 nd6 nd7 4.718900595857e-01
RINT22234 nd7 nd8 2.246133854709e-01
RINT22235 nd8 nd9 3.048324517105e-01
RINT22236 nd9 nd10 2.246133854709e-01
RINT22237 nd10 nd11 2.246133854709e-01
RINT22238 nd11 nd12 2.246133854709e-01
RINT22239 nd12 nd13 2.246133854709e-01
RINT22240 nd13 nd14 2.246133854709e-01
RINT22241 nd14 nd15 2.246133854709e-01
RINT22242 nd15 nd16 6.176868100450e-01
RINT22243 nd16 nd17 1.010760234619e+00
RINT22244 nd17 nd18 5.476161088664e-01
RINT22245 nd18 nd19 4.098155462576e-01
RINT22246 nd19 nd20 7.105981118828e+00
RINT22247 nd20 nd21 6.991091622782e+00
RINT22248 nd21 nd22 5.053801173095e-01
RINT22249 nd22 nd23 5.053801173095e-01
RINT22250 nd23 nd24 5.053801173095e-01
RINT22251 nd24 nd25 5.053801173095e-01
RINT22252 nd25 nd26 5.053801173095e-01
RINT22253 nd26 nd27 5.053801173095e-01
RINT22254 nd27 nd28 5.053801173095e-01
RINT22255 nd28 nd29 5.053801173095e-01
RINT22256 nd29 nd30 5.053801173095e-01
RINT22257 nd31 nd32 4.668678698020e-01
RINT22258 nd32 nd33 4.243707687709e-01
RINT22259 nd33 nd34 1.434437286031e+01
RINT22260 nd34 nd35 1.458717554935e+01
RINT22261 nd35 nd36 8.947905065228e-01
RINT22262 nd36 nd37 8.796048661798e-01
RINT22263 nd37 nd38 4.718900595857e-01
RINT22264 nd38 nd39 2.246133854709e-01
RINT22265 nd39 nd40 3.048324517105e-01
RINT22266 nd40 nd41 2.246133854709e-01
RINT22267 nd41 nd42 2.246133854709e-01
RINT22268 nd42 nd43 2.246133854709e-01
RINT22269 nd43 nd44 2.246133854709e-01
RINT22270 nd44 nd45 2.246133854709e-01
RINT22271 nd45 nd46 2.246133854709e-01
RINT22272 nd46 nd47 6.176868100450e-01
RINT22273 nd47 nd48 1.010760234619e+00
RINT22274 nd48 nd49 5.476161088664e-01
RINT22275 nd49 nd50 4.098155462576e-01
RINT22276 nd50 nd51 7.105981118828e+00
RINT22277 nd51 nd52 6.991091622782e+00
RINT22278 nd52 nd53 5.053801173095e-01
RINT22279 nd53 nd54 5.053801173095e-01
RINT22280 nd54 nd55 5.053801173095e-01
RINT22281 nd55 nd56 5.053801173095e-01
RINT22282 nd56 nd57 5.053801173095e-01
RINT22283 nd57 nd58 5.053801173095e-01
RINT22284 nd58 nd59 5.053801173095e-01
RINT22285 nd59 nd60 5.053801173095e-01
RINT22286 nd60 nd61 5.053801173095e-01
RINT22287 nd62 nd63 4.668678698020e-01
RINT22288 nd63 nd64 4.243707687709e-01
RINT22289 nd64 nd65 1.434437286031e+01
RINT22290 nd65 nd66 1.458717554935e+01
RINT22291 nd66 nd67 8.947905065228e-01
RINT22292 nd67 nd68 8.796048661798e-01
RINT22293 nd68 nd69 4.718900595857e-01
RINT22294 nd69 nd70 2.246133854709e-01
RINT22295 nd70 nd71 3.048324517105e-01
RINT22296 nd71 nd72 2.246133854709e-01
RINT22297 nd72 nd73 2.246133854709e-01
RINT22298 nd73 nd74 2.246133854709e-01
RINT22299 nd74 nd75 2.246133854709e-01
RINT22300 nd75 nd76 2.246133854709e-01
RINT22301 nd76 nd77 2.246133854709e-01
RINT22302 nd77 nd78 6.176868100450e-01
RINT22303 nd78 nd79 1.010760234619e+00
RINT22304 nd79 nd80 5.476161088664e-01
RINT22305 nd80 nd81 4.098155462576e-01
RINT22306 nd81 nd82 7.105981118828e+00
RINT22307 nd82 nd83 6.991091622782e+00
RINT22308 nd83 nd84 5.053801173095e-01
RINT22309 nd84 nd85 5.053801173095e-01
RINT22310 nd85 nd86 5.053801173095e-01
RINT22311 nd86 nd87 5.053801173095e-01
RINT22312 nd87 nd88 5.053801173095e-01
RINT22313 nd88 nd89 5.053801173095e-01
RINT22314 nd89 nd90 5.053801173095e-01
RINT22315 nd90 nd91 5.053801173095e-01
RINT22316 nd91 nd92 5.053801173095e-01
RINT22317 nd93 nd94 3.432023522226e+00
RINT22318 nd94 nd95 3.119620249697e+00
RINT22319 nd95 nd96 1.054478756249e+02
RINT22320 nd96 nd97 1.072327586592e+02
RINT22321 nd97 nd98 6.577754145201e+00
RINT22322 nd98 nd99 6.466121972098e+00
RINT22323 nd99 nd100 3.468942476358e+00
RINT22324 nd100 nd101 1.651170432161e+00
RINT22325 nd101 nd102 2.240874157933e+00
RINT22326 nd102 nd103 1.651170432161e+00
RINT22327 nd103 nd104 1.651170432161e+00
RINT22328 nd104 nd105 1.651170432161e+00
RINT22329 nd105 nd106 1.651170432161e+00
RINT22330 nd106 nd107 1.651170432161e+00
RINT22331 nd107 nd108 1.651170432161e+00
RINT22332 nd108 nd109 4.540718688442e+00
RINT22333 nd109 nd110 7.430266944724e+00
RINT22334 nd110 nd111 4.025617285628e+00
RINT22335 nd111 nd112 3.012622383130e+00
RINT22336 nd112 nd113 5.223725153469e+01
RINT22337 nd113 nd114 5.139267970101e+01
RINT22338 nd114 nd115 3.715133472362e+00
RINT22339 nd115 nd116 3.715133472362e+00
RINT22340 nd116 nd117 3.715133472362e+00
RINT22341 nd117 nd118 3.715133472362e+00
RINT22342 nd118 nd119 3.715133472362e+00
RINT22343 nd119 nd120 3.715133472362e+00
RINT22344 nd120 nd121 3.715133472362e+00
RINT22345 nd121 nd122 3.715133472362e+00
RINT22346 nd122 nd123 3.715133472362e+00
RINT22347 nd124 nd125 3.584458286241e-01
RINT22348 nd125 nd126 3.258179491350e-01
RINT22349 nd126 nd127 1.101313872421e+01
RINT22350 nd127 nd128 1.119955466049e+01
RINT22351 nd128 nd129 6.869907854048e-01
RINT22352 nd129 nd130 6.753317491163e-01
RINT22353 nd130 nd131 3.623017011203e-01
RINT22354 nd131 nd132 1.724507859350e-01
RINT22355 nd132 nd133 2.340403523404e-01
RINT22356 nd133 nd134 1.724507859350e-01
RINT22357 nd134 nd135 1.724507859350e-01
RINT22358 nd135 nd136 1.724507859350e-01
RINT22359 nd136 nd137 1.724507859350e-01
RINT22360 nd137 nd138 1.724507859350e-01
RINT22361 nd138 nd139 1.724507859350e-01
RINT22362 nd139 nd140 4.742396613214e-01
RINT22363 nd140 nd141 7.760285367077e-01
RINT22364 nd141 nd142 4.204416765578e-01
RINT22365 nd142 nd143 3.146429269669e-01
RINT22366 nd143 nd144 5.455739096815e+00
RINT22367 nd144 nd145 5.367530712228e+00
RINT22368 nd145 nd146 3.880142683539e-01
RINT22369 nd146 nd147 3.880142683539e-01
RINT22370 nd147 nd148 3.880142683539e-01
RINT22371 nd148 nd149 3.880142683539e-01
RINT22372 nd149 nd150 3.880142683539e-01
RINT22373 nd150 nd151 3.880142683539e-01
RINT22374 nd151 nd152 3.880142683539e-01
RINT22375 nd152 nd153 3.880142683539e-01
RINT22376 nd153 nd154 3.880142683539e-01
RINT22377 nd155 nd156 3.584458286241e-01
RINT22378 nd156 nd157 3.258179491350e-01
RINT22379 nd157 nd158 1.101313872421e+01
RINT22380 nd158 nd159 1.119955466049e+01
RINT22381 nd159 nd160 6.869907854048e-01
RINT22382 nd160 nd161 6.753317491163e-01
RINT22383 nd161 nd162 3.623017011203e-01
RINT22384 nd162 nd163 1.724507859350e-01
RINT22385 nd163 nd164 2.340403523404e-01
RINT22386 nd164 nd165 1.724507859350e-01
RINT22387 nd165 nd166 1.724507859350e-01
RINT22388 nd166 nd167 1.724507859350e-01
RINT22389 nd167 nd168 1.724507859350e-01
RINT22390 nd168 nd169 1.724507859350e-01
RINT22391 nd169 nd170 1.724507859350e-01
RINT22392 nd170 nd171 4.742396613214e-01
RINT22393 nd171 nd172 7.760285367077e-01
RINT22394 nd172 nd173 4.204416765578e-01
RINT22395 nd173 nd174 3.146429269669e-01
RINT22396 nd174 nd175 5.455739096815e+00
RINT22397 nd175 nd176 5.367530712228e+00
RINT22398 nd176 nd177 3.880142683539e-01
RINT22399 nd177 nd178 3.880142683539e-01
RINT22400 nd178 nd179 3.880142683539e-01
RINT22401 nd179 nd180 3.880142683539e-01
RINT22402 nd180 nd181 3.880142683539e-01
RINT22403 nd181 nd182 3.880142683539e-01
RINT22404 nd182 nd183 3.880142683539e-01
RINT22405 nd183 nd184 3.880142683539e-01
RINT22406 nd184 nd185 3.880142683539e-01
RINT22407 nd186 nd187 3.584458286241e-01
RINT22408 nd187 nd188 3.258179491350e-01
RINT22409 nd188 nd189 1.101313872421e+01
RINT22410 nd189 nd190 1.119955466049e+01
RINT22411 nd190 nd191 6.869907854048e-01
RINT22412 nd191 nd192 6.753317491163e-01
RINT22413 nd192 nd193 3.623017011203e-01
RINT22414 nd193 nd194 1.724507859350e-01
RINT22415 nd194 nd195 2.340403523404e-01
RINT22416 nd195 nd196 1.724507859350e-01
RINT22417 nd196 nd197 1.724507859350e-01
RINT22418 nd197 nd198 1.724507859350e-01
RINT22419 nd198 nd199 1.724507859350e-01
RINT22420 nd199 nd200 1.724507859350e-01
RINT22421 nd200 nd201 1.724507859350e-01
RINT22422 nd201 nd202 4.742396613214e-01
RINT22423 nd202 nd203 7.760285367077e-01
RINT22424 nd203 nd204 4.204416765578e-01
RINT22425 nd204 nd205 3.146429269669e-01
RINT22426 nd205 nd206 5.455739096815e+00
RINT22427 nd206 nd207 5.367530712228e+00
RINT22428 nd207 nd208 3.880142683539e-01
RINT22429 nd208 nd209 3.880142683539e-01
RINT22430 nd209 nd210 3.880142683539e-01
RINT22431 nd210 nd211 3.880142683539e-01
RINT22432 nd211 nd212 3.880142683539e-01
RINT22433 nd212 nd213 3.880142683539e-01
RINT22434 nd213 nd214 3.880142683539e-01
RINT22435 nd214 nd215 3.880142683539e-01
RINT22436 nd215 nd216 3.880142683539e-01
RINT22437 nd217 nd218 3.584458286241e-01
RINT22438 nd218 nd219 3.258179491350e-01
RINT22439 nd219 nd220 1.101313872421e+01
RINT22440 nd220 nd221 1.119955466049e+01
RINT22441 nd221 nd222 6.869907854048e-01
RINT22442 nd222 nd223 6.753317491163e-01
RINT22443 nd223 nd224 3.623017011203e-01
RINT22444 nd224 nd225 1.724507859350e-01
RINT22445 nd225 nd226 2.340403523404e-01
RINT22446 nd226 nd227 1.724507859350e-01
RINT22447 nd227 nd228 1.724507859350e-01
RINT22448 nd228 nd229 1.724507859350e-01
RINT22449 nd229 nd230 1.724507859350e-01
RINT22450 nd230 nd231 1.724507859350e-01
RINT22451 nd231 nd232 1.724507859350e-01
RINT22452 nd232 nd233 4.742396613214e-01
RINT22453 nd233 nd234 7.760285367077e-01
RINT22454 nd234 nd235 4.204416765578e-01
RINT22455 nd235 nd236 3.146429269669e-01
RINT22456 nd236 nd237 5.455739096815e+00
RINT22457 nd237 nd238 5.367530712228e+00
RINT22458 nd238 nd239 3.880142683539e-01
RINT22459 nd239 nd240 3.880142683539e-01
RINT22460 nd240 nd241 3.880142683539e-01
RINT22461 nd241 nd242 3.880142683539e-01
RINT22462 nd242 nd243 3.880142683539e-01
RINT22463 nd243 nd244 3.880142683539e-01
RINT22464 nd244 nd245 3.880142683539e-01
RINT22465 nd245 nd246 3.880142683539e-01
RINT22466 nd246 nd247 3.880142683539e-01
RINT22467 nd248 nd249 3.584458286241e-01
RINT22468 nd249 nd250 3.258179491350e-01
RINT22469 nd250 nd251 1.101313872421e+01
RINT22470 nd251 nd252 1.119955466049e+01
RINT22471 nd252 nd253 6.869907854048e-01
RINT22472 nd253 nd254 6.753317491163e-01
RINT22473 nd254 nd255 3.623017011203e-01
RINT22474 nd255 nd256 1.724507859350e-01
RINT22475 nd256 nd257 2.340403523404e-01
RINT22476 nd257 nd258 1.724507859350e-01
RINT22477 nd258 nd259 1.724507859350e-01
RINT22478 nd259 nd260 1.724507859350e-01
RINT22479 nd260 nd261 1.724507859350e-01
RINT22480 nd261 nd262 1.724507859350e-01
RINT22481 nd262 nd263 1.724507859350e-01
RINT22482 nd263 nd264 4.742396613214e-01
RINT22483 nd264 nd265 7.760285367077e-01
RINT22484 nd265 nd266 4.204416765578e-01
RINT22485 nd266 nd267 3.146429269669e-01
RINT22486 nd267 nd268 5.455739096815e+00
RINT22487 nd268 nd269 5.367530712228e+00
RINT22488 nd269 nd270 3.880142683539e-01
RINT22489 nd270 nd271 3.880142683539e-01
RINT22490 nd271 nd272 3.880142683539e-01
RINT22491 nd272 nd273 3.880142683539e-01
RINT22492 nd273 nd274 3.880142683539e-01
RINT22493 nd274 nd275 3.880142683539e-01
RINT22494 nd275 nd276 3.880142683539e-01
RINT22495 nd276 nd277 3.880142683539e-01
RINT22496 nd277 nd278 3.880142683539e-01
RINT22497 nd279 nd280 3.584458286241e-01
RINT22498 nd280 nd281 3.258179491350e-01
RINT22499 nd281 nd282 1.101313872421e+01
RINT22500 nd282 nd283 1.119955466049e+01
RINT22501 nd283 nd284 6.869907854048e-01
RINT22502 nd284 nd285 6.753317491163e-01
RINT22503 nd285 nd286 3.623017011203e-01
RINT22504 nd286 nd287 1.724507859350e-01
RINT22505 nd287 nd288 2.340403523404e-01
RINT22506 nd288 nd289 1.724507859350e-01
RINT22507 nd289 nd290 1.724507859350e-01
RINT22508 nd290 nd291 1.724507859350e-01
RINT22509 nd291 nd292 1.724507859350e-01
RINT22510 nd292 nd293 1.724507859350e-01
RINT22511 nd293 nd294 1.724507859350e-01
RINT22512 nd294 nd295 4.742396613214e-01
RINT22513 nd295 nd296 7.760285367077e-01
RINT22514 nd296 nd297 4.204416765578e-01
RINT22515 nd297 nd298 3.146429269669e-01
RINT22516 nd298 nd299 5.455739096815e+00
RINT22517 nd299 nd300 5.367530712228e+00
RINT22518 nd300 nd301 3.880142683539e-01
RINT22519 nd301 nd302 3.880142683539e-01
RINT22520 nd302 nd303 3.880142683539e-01
RINT22521 nd303 nd304 3.880142683539e-01
RINT22522 nd304 nd305 3.880142683539e-01
RINT22523 nd305 nd306 3.880142683539e-01
RINT22524 nd306 nd307 3.880142683539e-01
RINT22525 nd307 nd308 3.880142683539e-01
RINT22526 nd308 nd309 3.880142683539e-01
RINT22527 nd310 nd311 3.432023522226e+00
RINT22528 nd311 nd312 3.119620249697e+00
RINT22529 nd312 nd313 1.054478756249e+02
RINT22530 nd313 nd314 1.072327586592e+02
RINT22531 nd314 nd315 6.577754145200e+00
RINT22532 nd315 nd316 6.466121972098e+00
RINT22533 nd316 nd317 3.468942476358e+00
RINT22534 nd317 nd318 1.651170432161e+00
RINT22535 nd318 nd319 2.240874157933e+00
RINT22536 nd319 nd320 1.651170432161e+00
RINT22537 nd320 nd321 1.651170432161e+00
RINT22538 nd321 nd322 1.651170432161e+00
RINT22539 nd322 nd323 1.651170432161e+00
RINT22540 nd323 nd324 1.651170432161e+00
RINT22541 nd324 nd325 1.651170432161e+00
RINT22542 nd325 nd326 4.540718688442e+00
RINT22543 nd326 nd327 7.430266944724e+00
RINT22544 nd327 nd328 4.025617285628e+00
RINT22545 nd328 nd329 3.012622383130e+00
RINT22546 nd329 nd330 5.223725153469e+01
RINT22547 nd330 nd331 5.139267970101e+01
RINT22548 nd331 nd332 3.715133472362e+00
RINT22549 nd332 nd333 3.715133472362e+00
RINT22550 nd333 nd334 3.715133472362e+00
RINT22551 nd334 nd335 3.715133472362e+00
RINT22552 nd335 nd336 3.715133472362e+00
RINT22553 nd336 nd337 3.715133472362e+00
RINT22554 nd337 nd338 3.715133472362e+00
RINT22555 nd338 nd339 3.715133472362e+00
RINT22556 nd339 nd340 3.715133472362e+00
RINT22557 nd341 nd342 3.584458286241e-01
RINT22558 nd342 nd343 3.258179491350e-01
RINT22559 nd343 nd344 1.101313872421e+01
RINT22560 nd344 nd345 1.119955466049e+01
RINT22561 nd345 nd346 6.869907854048e-01
RINT22562 nd346 nd347 6.753317491163e-01
RINT22563 nd347 nd348 3.623017011203e-01
RINT22564 nd348 nd349 1.724507859350e-01
RINT22565 nd349 nd350 2.340403523404e-01
RINT22566 nd350 nd351 1.724507859350e-01
RINT22567 nd351 nd352 1.724507859350e-01
RINT22568 nd352 nd353 1.724507859350e-01
RINT22569 nd353 nd354 1.724507859350e-01
RINT22570 nd354 nd355 1.724507859350e-01
RINT22571 nd355 nd356 1.724507859350e-01
RINT22572 nd356 nd357 4.742396613214e-01
RINT22573 nd357 nd358 7.760285367077e-01
RINT22574 nd358 nd359 4.204416765578e-01
RINT22575 nd359 nd360 3.146429269669e-01
RINT22576 nd360 nd361 5.455739096815e+00
RINT22577 nd361 nd362 5.367530712228e+00
RINT22578 nd362 nd363 3.880142683539e-01
RINT22579 nd363 nd364 3.880142683539e-01
RINT22580 nd364 nd365 3.880142683539e-01
RINT22581 nd365 nd366 3.880142683539e-01
RINT22582 nd366 nd367 3.880142683539e-01
RINT22583 nd367 nd368 3.880142683539e-01
RINT22584 nd368 nd369 3.880142683539e-01
RINT22585 nd369 nd370 3.880142683539e-01
RINT22586 nd370 nd371 3.880142683539e-01
RINT22587 nd372 nd373 3.584458286241e-01
RINT22588 nd373 nd374 3.258179491350e-01
RINT22589 nd374 nd375 1.101313872421e+01
RINT22590 nd375 nd376 1.119955466049e+01
RINT22591 nd376 nd377 6.869907854048e-01
RINT22592 nd377 nd378 6.753317491163e-01
RINT22593 nd378 nd379 3.623017011203e-01
RINT22594 nd379 nd380 1.724507859350e-01
RINT22595 nd380 nd381 2.340403523404e-01
RINT22596 nd381 nd382 1.724507859350e-01
RINT22597 nd382 nd383 1.724507859350e-01
RINT22598 nd383 nd384 1.724507859350e-01
RINT22599 nd384 nd385 1.724507859350e-01
RINT22600 nd385 nd386 1.724507859350e-01
RINT22601 nd386 nd387 1.724507859350e-01
RINT22602 nd387 nd388 4.742396613214e-01
RINT22603 nd388 nd389 7.760285367077e-01
RINT22604 nd389 nd390 4.204416765578e-01
RINT22605 nd390 nd391 3.146429269669e-01
RINT22606 nd391 nd392 5.455739096815e+00
RINT22607 nd392 nd393 5.367530712228e+00
RINT22608 nd393 nd394 3.880142683539e-01
RINT22609 nd394 nd395 3.880142683539e-01
RINT22610 nd395 nd396 3.880142683539e-01
RINT22611 nd396 nd397 3.880142683539e-01
RINT22612 nd397 nd398 3.880142683539e-01
RINT22613 nd398 nd399 3.880142683539e-01
RINT22614 nd399 nd400 3.880142683539e-01
RINT22615 nd400 nd401 3.880142683539e-01
RINT22616 nd401 nd402 3.880142683539e-01
RINT22617 nd403 nd404 3.584458286241e-01
RINT22618 nd404 nd405 3.258179491350e-01
RINT22619 nd405 nd406 1.101313872421e+01
RINT22620 nd406 nd407 1.119955466049e+01
RINT22621 nd407 nd408 6.869907854048e-01
RINT22622 nd408 nd409 6.753317491163e-01
RINT22623 nd409 nd410 3.623017011203e-01
RINT22624 nd410 nd411 1.724507859350e-01
RINT22625 nd411 nd412 2.340403523404e-01
RINT22626 nd412 nd413 1.724507859350e-01
RINT22627 nd413 nd414 1.724507859350e-01
RINT22628 nd414 nd415 1.724507859350e-01
RINT22629 nd415 nd416 1.724507859350e-01
RINT22630 nd416 nd417 1.724507859350e-01
RINT22631 nd417 nd418 1.724507859350e-01
RINT22632 nd418 nd419 4.742396613214e-01
RINT22633 nd419 nd420 7.760285367077e-01
RINT22634 nd420 nd421 4.204416765578e-01
RINT22635 nd421 nd422 3.146429269669e-01
RINT22636 nd422 nd423 5.455739096815e+00
RINT22637 nd423 nd424 5.367530712228e+00
RINT22638 nd424 nd425 3.880142683539e-01
RINT22639 nd425 nd426 3.880142683539e-01
RINT22640 nd426 nd427 3.880142683539e-01
RINT22641 nd427 nd428 3.880142683539e-01
RINT22642 nd428 nd429 3.880142683539e-01
RINT22643 nd429 nd430 3.880142683539e-01
RINT22644 nd430 nd431 3.880142683539e-01
RINT22645 nd431 nd432 3.880142683539e-01
RINT22646 nd432 nd433 3.880142683539e-01
RINT22647 nd434 nd435 3.584458286241e-01
RINT22648 nd435 nd436 3.258179491350e-01
RINT22649 nd436 nd437 1.101313872421e+01
RINT22650 nd437 nd438 1.119955466049e+01
RINT22651 nd438 nd439 6.869907854048e-01
RINT22652 nd439 nd440 6.753317491163e-01
RINT22653 nd440 nd441 3.623017011203e-01
RINT22654 nd441 nd442 1.724507859350e-01
RINT22655 nd442 nd443 2.340403523404e-01
RINT22656 nd443 nd444 1.724507859350e-01
RINT22657 nd444 nd445 1.724507859350e-01
RINT22658 nd445 nd446 1.724507859350e-01
RINT22659 nd446 nd447 1.724507859350e-01
RINT22660 nd447 nd448 1.724507859350e-01
RINT22661 nd448 nd449 1.724507859350e-01
RINT22662 nd449 nd450 4.742396613214e-01
RINT22663 nd450 nd451 7.760285367077e-01
RINT22664 nd451 nd452 4.204416765578e-01
RINT22665 nd452 nd453 3.146429269669e-01
RINT22666 nd453 nd454 5.455739096815e+00
RINT22667 nd454 nd455 5.367530712228e+00
RINT22668 nd455 nd456 3.880142683539e-01
RINT22669 nd456 nd457 3.880142683539e-01
RINT22670 nd457 nd458 3.880142683539e-01
RINT22671 nd458 nd459 3.880142683539e-01
RINT22672 nd459 nd460 3.880142683539e-01
RINT22673 nd460 nd461 3.880142683539e-01
RINT22674 nd461 nd462 3.880142683539e-01
RINT22675 nd462 nd463 3.880142683539e-01
RINT22676 nd463 nd464 3.880142683539e-01
RINT22677 nd465 nd466 3.584458286241e-01
RINT22678 nd466 nd467 3.258179491350e-01
RINT22679 nd467 nd468 1.101313872421e+01
RINT22680 nd468 nd469 1.119955466049e+01
RINT22681 nd469 nd470 6.869907854048e-01
RINT22682 nd470 nd471 6.753317491163e-01
RINT22683 nd471 nd472 3.623017011203e-01
RINT22684 nd472 nd473 1.724507859350e-01
RINT22685 nd473 nd474 2.340403523404e-01
RINT22686 nd474 nd475 1.724507859350e-01
RINT22687 nd475 nd476 1.724507859350e-01
RINT22688 nd476 nd477 1.724507859350e-01
RINT22689 nd477 nd478 1.724507859350e-01
RINT22690 nd478 nd479 1.724507859350e-01
RINT22691 nd479 nd480 1.724507859350e-01
RINT22692 nd480 nd481 4.742396613214e-01
RINT22693 nd481 nd482 7.760285367077e-01
RINT22694 nd482 nd483 4.204416765578e-01
RINT22695 nd483 nd484 3.146429269669e-01
RINT22696 nd484 nd485 5.455739096815e+00
RINT22697 nd485 nd486 5.367530712228e+00
RINT22698 nd486 nd487 3.880142683539e-01
RINT22699 nd487 nd488 3.880142683539e-01
RINT22700 nd488 nd489 3.880142683539e-01
RINT22701 nd489 nd490 3.880142683539e-01
RINT22702 nd490 nd491 3.880142683539e-01
RINT22703 nd491 nd492 3.880142683539e-01
RINT22704 nd492 nd493 3.880142683539e-01
RINT22705 nd493 nd494 3.880142683539e-01
RINT22706 nd494 nd495 3.880142683539e-01
RINT22707 nd496 nd497 3.584458286241e-01
RINT22708 nd497 nd498 3.258179491350e-01
RINT22709 nd498 nd499 1.101313872421e+01
RINT22710 nd499 nd500 1.119955466049e+01
RINT22711 nd500 nd501 6.869907854048e-01
RINT22712 nd501 nd502 6.753317491163e-01
RINT22713 nd502 nd503 3.623017011203e-01
RINT22714 nd503 nd504 1.724507859350e-01
RINT22715 nd504 nd505 2.340403523404e-01
RINT22716 nd505 nd506 1.724507859350e-01
RINT22717 nd506 nd507 1.724507859350e-01
RINT22718 nd507 nd508 1.724507859350e-01
RINT22719 nd508 nd509 1.724507859350e-01
RINT22720 nd509 nd510 1.724507859350e-01
RINT22721 nd510 nd511 1.724507859350e-01
RINT22722 nd511 nd512 4.742396613214e-01
RINT22723 nd512 nd513 7.760285367077e-01
RINT22724 nd513 nd514 4.204416765578e-01
RINT22725 nd514 nd515 3.146429269669e-01
RINT22726 nd515 nd516 5.455739096815e+00
RINT22727 nd516 nd517 5.367530712228e+00
RINT22728 nd517 nd518 3.880142683539e-01
RINT22729 nd518 nd519 3.880142683539e-01
RINT22730 nd519 nd520 3.880142683539e-01
RINT22731 nd520 nd521 3.880142683539e-01
RINT22732 nd521 nd522 3.880142683539e-01
RINT22733 nd522 nd523 3.880142683539e-01
RINT22734 nd523 nd524 3.880142683539e-01
RINT22735 nd524 nd525 3.880142683539e-01
RINT22736 nd525 nd526 3.880142683539e-01
RINT22737 nd527 nd528 3.432023522226e+00
RINT22738 nd528 nd529 3.119620249697e+00
RINT22739 nd529 nd530 1.054478756249e+02
RINT22740 nd530 nd531 1.072327586592e+02
RINT22741 nd531 nd532 6.577754145200e+00
RINT22742 nd532 nd533 6.466121972098e+00
RINT22743 nd533 nd534 3.468942476358e+00
RINT22744 nd534 nd535 1.651170432161e+00
RINT22745 nd535 nd536 2.240874157933e+00
RINT22746 nd536 nd537 1.651170432161e+00
RINT22747 nd537 nd538 1.651170432161e+00
RINT22748 nd538 nd539 1.651170432161e+00
RINT22749 nd539 nd540 1.651170432161e+00
RINT22750 nd540 nd541 1.651170432161e+00
RINT22751 nd541 nd542 1.651170432161e+00
RINT22752 nd542 nd543 4.540718688442e+00
RINT22753 nd543 nd544 7.430266944724e+00
RINT22754 nd544 nd545 4.025617285628e+00
RINT22755 nd545 nd546 3.012622383130e+00
RINT22756 nd546 nd547 5.223725153469e+01
RINT22757 nd547 nd548 5.139267970101e+01
RINT22758 nd548 nd549 3.715133472362e+00
RINT22759 nd549 nd550 3.715133472362e+00
RINT22760 nd550 nd551 3.715133472362e+00
RINT22761 nd551 nd552 3.715133472362e+00
RINT22762 nd552 nd553 3.715133472362e+00
RINT22763 nd553 nd554 3.715133472362e+00
RINT22764 nd554 nd555 3.715133472362e+00
RINT22765 nd555 nd556 3.715133472362e+00
RINT22766 nd556 nd557 3.715133472362e+00
RINT22767 nd558 nd559 4.668678698020e-01
RINT22768 nd559 nd560 4.243707687709e-01
RINT22769 nd560 nd561 1.434437286031e+01
RINT22770 nd561 nd562 1.458717554935e+01
RINT22771 nd562 nd563 8.947905065228e-01
RINT22772 nd563 nd564 8.796048661798e-01
RINT22773 nd564 nd565 4.718900595857e-01
RINT22774 nd565 nd566 2.246133854709e-01
RINT22775 nd566 nd567 3.048324517105e-01
RINT22776 nd567 nd568 2.246133854709e-01
RINT22777 nd568 nd569 2.246133854709e-01
RINT22778 nd569 nd570 2.246133854709e-01
RINT22779 nd570 nd571 2.246133854709e-01
RINT22780 nd571 nd572 2.246133854709e-01
RINT22781 nd572 nd573 2.246133854709e-01
RINT22782 nd573 nd574 6.176868100450e-01
RINT22783 nd574 nd575 1.010760234619e+00
RINT22784 nd575 nd576 5.476161088664e-01
RINT22785 nd576 nd577 4.098155462576e-01
RINT22786 nd577 nd578 7.105981118828e+00
RINT22787 nd578 nd579 6.991091622782e+00
RINT22788 nd579 nd580 5.053801173095e-01
RINT22789 nd580 nd581 5.053801173095e-01
RINT22790 nd581 nd582 5.053801173095e-01
RINT22791 nd582 nd583 5.053801173095e-01
RINT22792 nd583 nd584 5.053801173095e-01
RINT22793 nd584 nd585 5.053801173095e-01
RINT22794 nd585 nd586 5.053801173095e-01
RINT22795 nd586 nd587 5.053801173095e-01
RINT22796 nd587 nd588 5.053801173095e-01
RINT22797 nd589 nd590 4.668678698020e-01
RINT22798 nd590 nd591 4.243707687709e-01
RINT22799 nd591 nd592 1.434437286031e+01
RINT22800 nd592 nd593 1.458717554935e+01
RINT22801 nd593 nd594 8.947905065228e-01
RINT22802 nd594 nd595 8.796048661798e-01
RINT22803 nd595 nd596 4.718900595857e-01
RINT22804 nd596 nd597 2.246133854709e-01
RINT22805 nd597 nd598 3.048324517105e-01
RINT22806 nd598 nd599 2.246133854709e-01
RINT22807 nd599 nd600 2.246133854709e-01
RINT22808 nd600 nd601 2.246133854709e-01
RINT22809 nd601 nd602 2.246133854709e-01
RINT22810 nd602 nd603 2.246133854709e-01
RINT22811 nd603 nd604 2.246133854709e-01
RINT22812 nd604 nd605 6.176868100450e-01
RINT22813 nd605 nd606 1.010760234619e+00
RINT22814 nd606 nd607 5.476161088664e-01
RINT22815 nd607 nd608 4.098155462576e-01
RINT22816 nd608 nd609 7.105981118828e+00
RINT22817 nd609 nd610 6.991091622782e+00
RINT22818 nd610 nd611 5.053801173095e-01
RINT22819 nd611 nd612 5.053801173095e-01
RINT22820 nd612 nd613 5.053801173095e-01
RINT22821 nd613 nd614 5.053801173095e-01
RINT22822 nd614 nd615 5.053801173095e-01
RINT22823 nd615 nd616 5.053801173095e-01
RINT22824 nd616 nd617 5.053801173095e-01
RINT22825 nd617 nd618 5.053801173095e-01
RINT22826 nd618 nd619 5.053801173095e-01
RINT22827 nd620 nd621 4.668678698020e-01
RINT22828 nd621 nd622 4.243707687709e-01
RINT22829 nd622 nd623 1.434437286031e+01
RINT22830 nd623 nd624 1.458717554935e+01
RINT22831 nd624 nd625 8.947905065228e-01
RINT22832 nd625 nd626 8.796048661798e-01
RINT22833 nd626 nd627 4.718900595857e-01
RINT22834 nd627 nd628 2.246133854709e-01
RINT22835 nd628 nd629 3.048324517105e-01
RINT22836 nd629 nd630 2.246133854709e-01
RINT22837 nd630 nd631 2.246133854709e-01
RINT22838 nd631 nd632 2.246133854709e-01
RINT22839 nd632 nd633 2.246133854709e-01
RINT22840 nd633 nd634 2.246133854709e-01
RINT22841 nd634 nd635 2.246133854709e-01
RINT22842 nd635 nd636 6.176868100450e-01
RINT22843 nd636 nd637 1.010760234619e+00
RINT22844 nd637 nd638 5.476161088664e-01
RINT22845 nd638 nd639 4.098155462576e-01
RINT22846 nd639 nd640 7.105981118828e+00
RINT22847 nd640 nd641 6.991091622782e+00
RINT22848 nd641 nd642 5.053801173095e-01
RINT22849 nd642 nd643 5.053801173095e-01
RINT22850 nd643 nd644 5.053801173095e-01
RINT22851 nd644 nd645 5.053801173095e-01
RINT22852 nd645 nd646 5.053801173095e-01
RINT22853 nd646 nd647 5.053801173095e-01
RINT22854 nd647 nd648 5.053801173095e-01
RINT22855 nd648 nd649 5.053801173095e-01
RINT22856 nd649 nd650 5.053801173095e-01
RINT22857 nd651 nd652 2.356247123801e+00
RINT22858 nd652 nd653 2.141767442179e+00
RINT22859 nd653 nd654 7.239497399800e+01
RINT22860 nd654 nd655 7.362038095942e+01
RINT22861 nd655 nd656 4.515940577133e+00
RINT22862 nd656 nd657 4.439299789244e+00
RINT22863 nd657 nd658 2.381593738975e+00
RINT22864 nd658 nd659 1.133606910468e+00
RINT22865 nd659 nd660 1.538466521349e+00
RINT22866 nd660 nd661 1.133606910468e+00
RINT22867 nd661 nd662 1.133606910468e+00
RINT22868 nd662 nd663 1.133606910468e+00
RINT22869 nd663 nd664 1.133606910468e+00
RINT22870 nd664 nd665 1.133606910468e+00
RINT22871 nd665 nd666 1.133606910468e+00
RINT22872 nd666 nd667 3.117419003786e+00
RINT22873 nd667 nd668 5.101231097105e+00
RINT22874 nd668 nd669 2.763777430240e+00
RINT22875 nd669 nd670 2.068308325796e+00
RINT22876 nd670 nd671 3.586335375814e+01
RINT22877 nd671 nd672 3.528351508831e+01
RINT22878 nd672 nd673 2.550615548552e+00
RINT22879 nd673 nd674 2.550615548552e+00
RINT22880 nd674 nd675 2.550615548552e+00
RINT22881 nd675 nd676 2.550615548552e+00
RINT22882 nd676 nd677 2.550615548552e+00
RINT22883 nd677 nd678 2.550615548552e+00
RINT22884 nd678 nd679 2.550615548552e+00
RINT22885 nd679 nd680 2.550615548552e+00
RINT22886 nd680 nd681 2.550615548552e+00
RINT22887 nd682 nd683 2.356247123801e+00
RINT22888 nd683 nd684 2.141767442179e+00
RINT22889 nd684 nd685 7.239497399800e+01
RINT22890 nd685 nd686 7.362038095942e+01
RINT22891 nd686 nd687 4.515940577133e+00
RINT22892 nd687 nd688 4.439299789244e+00
RINT22893 nd688 nd689 2.381593738975e+00
RINT22894 nd689 nd690 1.133606910468e+00
RINT22895 nd690 nd691 1.538466521349e+00
RINT22896 nd691 nd692 1.133606910468e+00
RINT22897 nd692 nd693 1.133606910468e+00
RINT22898 nd693 nd694 1.133606910468e+00
RINT22899 nd694 nd695 1.133606910468e+00
RINT22900 nd695 nd696 1.133606910468e+00
RINT22901 nd696 nd697 1.133606910468e+00
RINT22902 nd697 nd698 3.117419003786e+00
RINT22903 nd698 nd699 5.101231097105e+00
RINT22904 nd699 nd700 2.763777430240e+00
RINT22905 nd700 nd701 2.068308325796e+00
RINT22906 nd701 nd702 3.586335375814e+01
RINT22907 nd702 nd703 3.528351508831e+01
RINT22908 nd703 nd704 2.550615548552e+00
RINT22909 nd704 nd705 2.550615548552e+00
RINT22910 nd705 nd706 2.550615548552e+00
RINT22911 nd706 nd707 2.550615548552e+00
RINT22912 nd707 nd708 2.550615548552e+00
RINT22913 nd708 nd709 2.550615548552e+00
RINT22914 nd709 nd710 2.550615548552e+00
RINT22915 nd710 nd711 2.550615548552e+00
RINT22916 nd711 nd712 2.550615548552e+00
RINT22917 nd713 nd714 2.356247123801e+00
RINT22918 nd714 nd715 2.141767442179e+00
RINT22919 nd715 nd716 7.239497399800e+01
RINT22920 nd716 nd717 7.362038095942e+01
RINT22921 nd717 nd718 4.515940577133e+00
RINT22922 nd718 nd719 4.439299789244e+00
RINT22923 nd719 nd720 2.381593738975e+00
RINT22924 nd720 nd721 1.133606910468e+00
RINT22925 nd721 nd722 1.538466521349e+00
RINT22926 nd722 nd723 1.133606910468e+00
RINT22927 nd723 nd724 1.133606910468e+00
RINT22928 nd724 nd725 1.133606910468e+00
RINT22929 nd725 nd726 1.133606910468e+00
RINT22930 nd726 nd727 1.133606910468e+00
RINT22931 nd727 nd728 1.133606910468e+00
RINT22932 nd728 nd729 3.117419003786e+00
RINT22933 nd729 nd730 5.101231097105e+00
RINT22934 nd730 nd731 2.763777430240e+00
RINT22935 nd731 nd732 2.068308325796e+00
RINT22936 nd732 nd733 3.586335375814e+01
RINT22937 nd733 nd734 3.528351508831e+01
RINT22938 nd734 nd735 2.550615548552e+00
RINT22939 nd735 nd736 2.550615548552e+00
RINT22940 nd736 nd737 2.550615548552e+00
RINT22941 nd737 nd738 2.550615548552e+00
RINT22942 nd738 nd739 2.550615548552e+00
RINT22943 nd739 nd740 2.550615548552e+00
RINT22944 nd740 nd741 2.550615548552e+00
RINT22945 nd741 nd742 2.550615548552e+00
RINT22946 nd742 nd743 2.550615548552e+00
RINT22947 nd744 nd745 1.732116531491e+01
RINT22948 nd745 nd746 1.574448942870e+01
RINT22949 nd746 nd747 5.321875196883e+02
RINT22950 nd747 nd748 5.411956904962e+02
RINT22951 nd748 nd749 3.319743183927e+01
RINT22952 nd749 nd750 3.263403263403e+01
RINT22953 nd750 nd751 9.444201631702e+01
RINT22954 nd751 nd752 5.468750000000e+02
RINT22955 nd752 nd753 7.421875000000e+02
RINT22956 nd753 nd754 5.468750000000e+02
RINT22957 nd754 nd755 5.468750000000e+02
RINT22958 nd755 nd756 5.468750000000e+02
RINT22959 nd756 nd757 5.468750000000e+02
RINT22960 nd757 nd758 5.468750000000e+02
RINT22961 nd758 nd759 5.468750000000e+02
RINT22962 nd759 nd760 1.503906250000e+03
RINT22963 nd760 nd761 2.460937500000e+03
RINT22964 nd761 nd762 1.232035738519e+03
RINT22965 nd762 nd763 1.520447922098e+01
RINT22966 nd763 nd764 2.636374907017e+02
RINT22967 nd764 nd765 2.593750000000e+02
RINT22968 nd765 nd766 1.875000000000e+01
RINT22969 nd766 nd767 1.875000000000e+01
RINT22970 nd767 nd768 1.875000000000e+01
RINT22971 nd768 nd769 1.875000000000e+01
RINT22972 nd769 nd770 1.875000000000e+01
RINT22973 nd770 nd771 1.875000000000e+01
RINT22974 nd771 nd772 1.875000000000e+01
RINT22975 nd772 nd773 1.875000000000e+01
RINT22976 nd773 nd774 1.875000000000e+01
RINT22977 nd775 nd776 1.809049213629e+00
RINT22978 nd776 nd777 1.644378752938e+00
RINT22979 nd777 nd778 5.558248515568e+01
RINT22980 nd778 nd779 5.652331240488e+01
RINT22981 nd779 nd780 3.467190969629e+00
RINT22982 nd780 nd781 3.408348687909e+00
RINT22983 nd781 nd782 9.863669807754e+00
RINT22984 nd782 nd783 5.711646824659e+01
RINT22985 nd783 nd784 7.751520690609e+01
RINT22986 nd784 nd785 5.711646824659e+01
RINT22987 nd785 nd786 5.711646824659e+01
RINT22988 nd786 nd787 5.711646824659e+01
RINT22989 nd787 nd788 5.711646824659e+01
RINT22990 nd788 nd789 5.711646824659e+01
RINT22991 nd789 nd790 5.711646824659e+01
RINT22992 nd790 nd791 1.570702876781e+02
RINT22993 nd791 nd792 2.570241071097e+02
RINT22994 nd792 nd793 1.286757122520e+02
RINT22995 nd793 nd794 1.587979254183e+00
RINT22996 nd794 nd795 2.753470604119e+01
RINT22997 nd795 nd796 2.708952493981e+01
RINT22998 nd796 nd797 1.958278911312e+00
RINT22999 nd797 nd798 1.958278911312e+00
RINT23000 nd798 nd799 1.958278911312e+00
RINT23001 nd799 nd800 1.958278911312e+00
RINT23002 nd800 nd801 1.958278911312e+00
RINT23003 nd801 nd802 1.958278911312e+00
RINT23004 nd802 nd803 1.958278911312e+00
RINT23005 nd803 nd804 1.958278911312e+00
RINT23006 nd804 nd805 1.958278911312e+00
RINT23007 nd806 nd807 1.809049213629e+00
RINT23008 nd807 nd808 1.644378752938e+00
RINT23009 nd808 nd809 5.558248515568e+01
RINT23010 nd809 nd810 5.652331240488e+01
RINT23011 nd810 nd811 3.467190969629e+00
RINT23012 nd811 nd812 3.408348687909e+00
RINT23013 nd812 nd813 9.863669807754e+00
RINT23014 nd813 nd814 5.711646824659e+01
RINT23015 nd814 nd815 7.751520690609e+01
RINT23016 nd815 nd816 5.711646824659e+01
RINT23017 nd816 nd817 5.711646824659e+01
RINT23018 nd817 nd818 5.711646824659e+01
RINT23019 nd818 nd819 5.711646824659e+01
RINT23020 nd819 nd820 5.711646824659e+01
RINT23021 nd820 nd821 5.711646824659e+01
RINT23022 nd821 nd822 1.570702876781e+02
RINT23023 nd822 nd823 2.570241071097e+02
RINT23024 nd823 nd824 1.286757122520e+02
RINT23025 nd824 nd825 1.587979254183e+00
RINT23026 nd825 nd826 2.753470604119e+01
RINT23027 nd826 nd827 2.708952493981e+01
RINT23028 nd827 nd828 1.958278911312e+00
RINT23029 nd828 nd829 1.958278911312e+00
RINT23030 nd829 nd830 1.958278911312e+00
RINT23031 nd830 nd831 1.958278911312e+00
RINT23032 nd831 nd832 1.958278911312e+00
RINT23033 nd832 nd833 1.958278911312e+00
RINT23034 nd833 nd834 1.958278911312e+00
RINT23035 nd834 nd835 1.958278911312e+00
RINT23036 nd835 nd836 1.958278911312e+00
RINT23037 nd837 nd838 1.809049213629e+00
RINT23038 nd838 nd839 1.644378752938e+00
RINT23039 nd839 nd840 5.558248515568e+01
RINT23040 nd840 nd841 5.652331240488e+01
RINT23041 nd841 nd842 3.467190969629e+00
RINT23042 nd842 nd843 3.408348687909e+00
RINT23043 nd843 nd844 9.863669807754e+00
RINT23044 nd844 nd845 5.711646824659e+01
RINT23045 nd845 nd846 7.751520690609e+01
RINT23046 nd846 nd847 5.711646824659e+01
RINT23047 nd847 nd848 5.711646824659e+01
RINT23048 nd848 nd849 5.711646824659e+01
RINT23049 nd849 nd850 5.711646824659e+01
RINT23050 nd850 nd851 5.711646824659e+01
RINT23051 nd851 nd852 5.711646824659e+01
RINT23052 nd852 nd853 1.570702876781e+02
RINT23053 nd853 nd854 2.570241071097e+02
RINT23054 nd854 nd855 1.286757122520e+02
RINT23055 nd855 nd856 1.587979254183e+00
RINT23056 nd856 nd857 2.753470604119e+01
RINT23057 nd857 nd858 2.708952493981e+01
RINT23058 nd858 nd859 1.958278911312e+00
RINT23059 nd859 nd860 1.958278911312e+00
RINT23060 nd860 nd861 1.958278911312e+00
RINT23061 nd861 nd862 1.958278911312e+00
RINT23062 nd862 nd863 1.958278911312e+00
RINT23063 nd863 nd864 1.958278911312e+00
RINT23064 nd864 nd865 1.958278911312e+00
RINT23065 nd865 nd866 1.958278911312e+00
RINT23066 nd866 nd867 1.958278911312e+00
RINT23067 nd868 nd869 1.809049213629e+00
RINT23068 nd869 nd870 1.644378752938e+00
RINT23069 nd870 nd871 5.558248515568e+01
RINT23070 nd871 nd872 5.652331240488e+01
RINT23071 nd872 nd873 3.467190969629e+00
RINT23072 nd873 nd874 3.408348687909e+00
RINT23073 nd874 nd875 9.863669807754e+00
RINT23074 nd875 nd876 5.711646824659e+01
RINT23075 nd876 nd877 7.751520690609e+01
RINT23076 nd877 nd878 5.711646824659e+01
RINT23077 nd878 nd879 5.711646824659e+01
RINT23078 nd879 nd880 5.711646824659e+01
RINT23079 nd880 nd881 5.711646824659e+01
RINT23080 nd881 nd882 5.711646824659e+01
RINT23081 nd882 nd883 5.711646824659e+01
RINT23082 nd883 nd884 1.570702876781e+02
RINT23083 nd884 nd885 2.570241071097e+02
RINT23084 nd885 nd886 1.286757122520e+02
RINT23085 nd886 nd887 1.587979254183e+00
RINT23086 nd887 nd888 2.753470604119e+01
RINT23087 nd888 nd889 2.708952493981e+01
RINT23088 nd889 nd890 1.958278911312e+00
RINT23089 nd890 nd891 1.958278911312e+00
RINT23090 nd891 nd892 1.958278911312e+00
RINT23091 nd892 nd893 1.958278911312e+00
RINT23092 nd893 nd894 1.958278911312e+00
RINT23093 nd894 nd895 1.958278911312e+00
RINT23094 nd895 nd896 1.958278911312e+00
RINT23095 nd896 nd897 1.958278911312e+00
RINT23096 nd897 nd898 1.958278911312e+00
RINT23097 nd899 nd900 1.809049213629e+00
RINT23098 nd900 nd901 1.644378752938e+00
RINT23099 nd901 nd902 5.558248515568e+01
RINT23100 nd902 nd903 5.652331240488e+01
RINT23101 nd903 nd904 3.467190969629e+00
RINT23102 nd904 nd905 3.408348687909e+00
RINT23103 nd905 nd906 9.863669807754e+00
RINT23104 nd906 nd907 5.711646824659e+01
RINT23105 nd907 nd908 7.751520690609e+01
RINT23106 nd908 nd909 5.711646824659e+01
RINT23107 nd909 nd910 5.711646824659e+01
RINT23108 nd910 nd911 5.711646824659e+01
RINT23109 nd911 nd912 5.711646824659e+01
RINT23110 nd912 nd913 5.711646824659e+01
RINT23111 nd913 nd914 5.711646824659e+01
RINT23112 nd914 nd915 1.570702876781e+02
RINT23113 nd915 nd916 2.570241071097e+02
RINT23114 nd916 nd917 1.286757122520e+02
RINT23115 nd917 nd918 1.587979254183e+00
RINT23116 nd918 nd919 2.753470604119e+01
RINT23117 nd919 nd920 2.708952493981e+01
RINT23118 nd920 nd921 1.958278911312e+00
RINT23119 nd921 nd922 1.958278911312e+00
RINT23120 nd922 nd923 1.958278911312e+00
RINT23121 nd923 nd924 1.958278911312e+00
RINT23122 nd924 nd925 1.958278911312e+00
RINT23123 nd925 nd926 1.958278911312e+00
RINT23124 nd926 nd927 1.958278911312e+00
RINT23125 nd927 nd928 1.958278911312e+00
RINT23126 nd928 nd929 1.958278911312e+00
RINT23127 nd930 nd931 1.809049213629e+00
RINT23128 nd931 nd932 1.644378752938e+00
RINT23129 nd932 nd933 5.558248515568e+01
RINT23130 nd933 nd934 5.652331240488e+01
RINT23131 nd934 nd935 3.467190969629e+00
RINT23132 nd935 nd936 3.408348687909e+00
RINT23133 nd936 nd937 9.863669807754e+00
RINT23134 nd937 nd938 5.711646824659e+01
RINT23135 nd938 nd939 7.751520690609e+01
RINT23136 nd939 nd940 5.711646824659e+01
RINT23137 nd940 nd941 5.711646824659e+01
RINT23138 nd941 nd942 5.711646824659e+01
RINT23139 nd942 nd943 5.711646824659e+01
RINT23140 nd943 nd944 5.711646824659e+01
RINT23141 nd944 nd945 5.711646824659e+01
RINT23142 nd945 nd946 1.570702876781e+02
RINT23143 nd946 nd947 2.570241071097e+02
RINT23144 nd947 nd948 1.286757122520e+02
RINT23145 nd948 nd949 1.587979254183e+00
RINT23146 nd949 nd950 2.753470604119e+01
RINT23147 nd950 nd951 2.708952493981e+01
RINT23148 nd951 nd952 1.958278911312e+00
RINT23149 nd952 nd953 1.958278911312e+00
RINT23150 nd953 nd954 1.958278911312e+00
RINT23151 nd954 nd955 1.958278911312e+00
RINT23152 nd955 nd956 1.958278911312e+00
RINT23153 nd956 nd957 1.958278911312e+00
RINT23154 nd957 nd958 1.958278911312e+00
RINT23155 nd958 nd959 1.958278911312e+00
RINT23156 nd959 nd960 1.958278911312e+00
RINT23157 nd961 nd962 1.732116531491e+01
RINT23158 nd962 nd963 1.574448942870e+01
RINT23159 nd963 nd964 5.321875196883e+02
RINT23160 nd964 nd965 5.411956904962e+02
RINT23161 nd965 nd966 3.319743183927e+01
RINT23162 nd966 nd967 3.263403263403e+01
RINT23163 nd967 nd968 9.444201631702e+01
RINT23164 nd968 nd969 5.468750000000e+02
RINT23165 nd969 nd970 7.421875000000e+02
RINT23166 nd970 nd971 5.468750000000e+02
RINT23167 nd971 nd972 5.468750000000e+02
RINT23168 nd972 nd973 5.468750000000e+02
RINT23169 nd973 nd974 5.468750000000e+02
RINT23170 nd974 nd975 5.468750000000e+02
RINT23171 nd975 nd976 5.468750000000e+02
RINT23172 nd976 nd977 1.503906250000e+03
RINT23173 nd977 nd978 2.460937500000e+03
RINT23174 nd978 nd979 1.232035738519e+03
RINT23175 nd979 nd980 1.520447922098e+01
RINT23176 nd980 nd981 2.636374907017e+02
RINT23177 nd981 nd982 2.593750000000e+02
RINT23178 nd982 nd983 1.875000000000e+01
RINT23179 nd983 nd984 1.875000000000e+01
RINT23180 nd984 nd985 1.875000000000e+01
RINT23181 nd985 nd986 1.875000000000e+01
RINT23182 nd986 nd987 1.875000000000e+01
RINT23183 nd987 nd988 1.875000000000e+01
RINT23184 nd988 nd989 1.875000000000e+01
RINT23185 nd989 nd990 1.875000000000e+01
RINT23186 nd990 nd991 1.875000000000e+01
RINT23187 nd992 nd993 1.809049213629e+00
RINT23188 nd993 nd994 1.644378752938e+00
RINT23189 nd994 nd995 5.558248515568e+01
RINT23190 nd995 nd996 5.652331240488e+01
RINT23191 nd996 nd997 3.467190969629e+00
RINT23192 nd997 nd998 3.408348687909e+00
RINT23193 nd998 nd999 9.863669807754e+00
RINT23194 nd999 nd1000 5.711646824659e+01
RINT23195 nd1000 nd1001 7.751520690609e+01
RINT23196 nd1001 nd1002 5.711646824659e+01
RINT23197 nd1002 nd1003 5.711646824659e+01
RINT23198 nd1003 nd1004 5.711646824659e+01
RINT23199 nd1004 nd1005 5.711646824659e+01
RINT23200 nd1005 nd1006 5.711646824659e+01
RINT23201 nd1006 nd1007 5.711646824659e+01
RINT23202 nd1007 nd1008 1.570702876781e+02
RINT23203 nd1008 nd1009 2.570241071097e+02
RINT23204 nd1009 nd1010 1.286757122520e+02
RINT23205 nd1010 nd1011 1.587979254183e+00
RINT23206 nd1011 nd1012 2.753470604119e+01
RINT23207 nd1012 nd1013 2.708952493981e+01
RINT23208 nd1013 nd1014 1.958278911312e+00
RINT23209 nd1014 nd1015 1.958278911312e+00
RINT23210 nd1015 nd1016 1.958278911312e+00
RINT23211 nd1016 nd1017 1.958278911312e+00
RINT23212 nd1017 nd1018 1.958278911312e+00
RINT23213 nd1018 nd1019 1.958278911312e+00
RINT23214 nd1019 nd1020 1.958278911312e+00
RINT23215 nd1020 nd1021 1.958278911312e+00
RINT23216 nd1021 nd1022 1.958278911312e+00
RINT23217 nd1023 nd1024 1.809049213629e+00
RINT23218 nd1024 nd1025 1.644378752938e+00
RINT23219 nd1025 nd1026 5.558248515568e+01
RINT23220 nd1026 nd1027 5.652331240488e+01
RINT23221 nd1027 nd1028 3.467190969629e+00
RINT23222 nd1028 nd1029 3.408348687909e+00
RINT23223 nd1029 nd1030 9.863669807754e+00
RINT23224 nd1030 nd1031 5.711646824659e+01
RINT23225 nd1031 nd1032 7.751520690609e+01
RINT23226 nd1032 nd1033 5.711646824659e+01
RINT23227 nd1033 nd1034 5.711646824659e+01
RINT23228 nd1034 nd1035 5.711646824659e+01
RINT23229 nd1035 nd1036 5.711646824659e+01
RINT23230 nd1036 nd1037 5.711646824659e+01
RINT23231 nd1037 nd1038 5.711646824659e+01
RINT23232 nd1038 nd1039 1.570702876781e+02
RINT23233 nd1039 nd1040 2.570241071097e+02
RINT23234 nd1040 nd1041 1.286757122520e+02
RINT23235 nd1041 nd1042 1.587979254183e+00
RINT23236 nd1042 nd1043 2.753470604119e+01
RINT23237 nd1043 nd1044 2.708952493981e+01
RINT23238 nd1044 nd1045 1.958278911312e+00
RINT23239 nd1045 nd1046 1.958278911312e+00
RINT23240 nd1046 nd1047 1.958278911312e+00
RINT23241 nd1047 nd1048 1.958278911312e+00
RINT23242 nd1048 nd1049 1.958278911312e+00
RINT23243 nd1049 nd1050 1.958278911312e+00
RINT23244 nd1050 nd1051 1.958278911312e+00
RINT23245 nd1051 nd1052 1.958278911312e+00
RINT23246 nd1052 nd1053 1.958278911312e+00
RINT23247 nd1054 nd1055 1.809049213629e+00
RINT23248 nd1055 nd1056 1.644378752938e+00
RINT23249 nd1056 nd1057 5.558248515568e+01
RINT23250 nd1057 nd1058 5.652331240488e+01
RINT23251 nd1058 nd1059 3.467190969629e+00
RINT23252 nd1059 nd1060 3.408348687909e+00
RINT23253 nd1060 nd1061 9.863669807754e+00
RINT23254 nd1061 nd1062 5.711646824659e+01
RINT23255 nd1062 nd1063 7.751520690609e+01
RINT23256 nd1063 nd1064 5.711646824659e+01
RINT23257 nd1064 nd1065 5.711646824659e+01
RINT23258 nd1065 nd1066 5.711646824659e+01
RINT23259 nd1066 nd1067 5.711646824659e+01
RINT23260 nd1067 nd1068 5.711646824659e+01
RINT23261 nd1068 nd1069 5.711646824659e+01
RINT23262 nd1069 nd1070 1.570702876781e+02
RINT23263 nd1070 nd1071 2.570241071097e+02
RINT23264 nd1071 nd1072 1.286757122520e+02
RINT23265 nd1072 nd1073 1.587979254183e+00
RINT23266 nd1073 nd1074 2.753470604119e+01
RINT23267 nd1074 nd1075 2.708952493981e+01
RINT23268 nd1075 nd1076 1.958278911312e+00
RINT23269 nd1076 nd1077 1.958278911312e+00
RINT23270 nd1077 nd1078 1.958278911312e+00
RINT23271 nd1078 nd1079 1.958278911312e+00
RINT23272 nd1079 nd1080 1.958278911312e+00
RINT23273 nd1080 nd1081 1.958278911312e+00
RINT23274 nd1081 nd1082 1.958278911312e+00
RINT23275 nd1082 nd1083 1.958278911312e+00
RINT23276 nd1083 nd1084 1.958278911312e+00
RINT23277 nd1085 nd1086 1.809049213629e+00
RINT23278 nd1086 nd1087 1.644378752938e+00
RINT23279 nd1087 nd1088 5.558248515568e+01
RINT23280 nd1088 nd1089 5.652331240488e+01
RINT23281 nd1089 nd1090 3.467190969629e+00
RINT23282 nd1090 nd1091 3.408348687909e+00
RINT23283 nd1091 nd1092 9.863669807754e+00
RINT23284 nd1092 nd1093 5.711646824659e+01
RINT23285 nd1093 nd1094 7.751520690609e+01
RINT23286 nd1094 nd1095 5.711646824659e+01
RINT23287 nd1095 nd1096 5.711646824659e+01
RINT23288 nd1096 nd1097 5.711646824659e+01
RINT23289 nd1097 nd1098 5.711646824659e+01
RINT23290 nd1098 nd1099 5.711646824659e+01
RINT23291 nd1099 nd1100 5.711646824659e+01
RINT23292 nd1100 nd1101 1.570702876781e+02
RINT23293 nd1101 nd1102 2.570241071097e+02
RINT23294 nd1102 nd1103 1.286757122520e+02
RINT23295 nd1103 nd1104 1.587979254183e+00
RINT23296 nd1104 nd1105 2.753470604119e+01
RINT23297 nd1105 nd1106 2.708952493981e+01
RINT23298 nd1106 nd1107 1.958278911312e+00
RINT23299 nd1107 nd1108 1.958278911312e+00
RINT23300 nd1108 nd1109 1.958278911312e+00
RINT23301 nd1109 nd1110 1.958278911312e+00
RINT23302 nd1110 nd1111 1.958278911312e+00
RINT23303 nd1111 nd1112 1.958278911312e+00
RINT23304 nd1112 nd1113 1.958278911312e+00
RINT23305 nd1113 nd1114 1.958278911312e+00
RINT23306 nd1114 nd1115 1.958278911312e+00
RINT23307 nd1116 nd1117 1.809049213629e+00
RINT23308 nd1117 nd1118 1.644378752938e+00
RINT23309 nd1118 nd1119 5.558248515568e+01
RINT23310 nd1119 nd1120 5.652331240488e+01
RINT23311 nd1120 nd1121 3.467190969629e+00
RINT23312 nd1121 nd1122 3.408348687909e+00
RINT23313 nd1122 nd1123 9.863669807754e+00
RINT23314 nd1123 nd1124 5.711646824659e+01
RINT23315 nd1124 nd1125 7.751520690609e+01
RINT23316 nd1125 nd1126 5.711646824659e+01
RINT23317 nd1126 nd1127 5.711646824659e+01
RINT23318 nd1127 nd1128 5.711646824659e+01
RINT23319 nd1128 nd1129 5.711646824659e+01
RINT23320 nd1129 nd1130 5.711646824659e+01
RINT23321 nd1130 nd1131 5.711646824659e+01
RINT23322 nd1131 nd1132 1.570702876781e+02
RINT23323 nd1132 nd1133 2.570241071097e+02
RINT23324 nd1133 nd1134 1.286757122520e+02
RINT23325 nd1134 nd1135 1.587979254183e+00
RINT23326 nd1135 nd1136 2.753470604119e+01
RINT23327 nd1136 nd1137 2.708952493981e+01
RINT23328 nd1137 nd1138 1.958278911312e+00
RINT23329 nd1138 nd1139 1.958278911312e+00
RINT23330 nd1139 nd1140 1.958278911312e+00
RINT23331 nd1140 nd1141 1.958278911312e+00
RINT23332 nd1141 nd1142 1.958278911312e+00
RINT23333 nd1142 nd1143 1.958278911312e+00
RINT23334 nd1143 nd1144 1.958278911312e+00
RINT23335 nd1144 nd1145 1.958278911312e+00
RINT23336 nd1145 nd1146 1.958278911312e+00
RINT23337 nd1147 nd1148 1.809049213629e+00
RINT23338 nd1148 nd1149 1.644378752938e+00
RINT23339 nd1149 nd1150 5.558248515568e+01
RINT23340 nd1150 nd1151 5.652331240488e+01
RINT23341 nd1151 nd1152 3.467190969629e+00
RINT23342 nd1152 nd1153 3.408348687909e+00
RINT23343 nd1153 nd1154 9.863669807754e+00
RINT23344 nd1154 nd1155 5.711646824659e+01
RINT23345 nd1155 nd1156 7.751520690609e+01
RINT23346 nd1156 nd1157 5.711646824659e+01
RINT23347 nd1157 nd1158 5.711646824659e+01
RINT23348 nd1158 nd1159 5.711646824659e+01
RINT23349 nd1159 nd1160 5.711646824659e+01
RINT23350 nd1160 nd1161 5.711646824659e+01
RINT23351 nd1161 nd1162 5.711646824659e+01
RINT23352 nd1162 nd1163 1.570702876781e+02
RINT23353 nd1163 nd1164 2.570241071097e+02
RINT23354 nd1164 nd1165 1.286757122520e+02
RINT23355 nd1165 nd1166 1.587979254183e+00
RINT23356 nd1166 nd1167 2.753470604119e+01
RINT23357 nd1167 nd1168 2.708952493981e+01
RINT23358 nd1168 nd1169 1.958278911312e+00
RINT23359 nd1169 nd1170 1.958278911312e+00
RINT23360 nd1170 nd1171 1.958278911312e+00
RINT23361 nd1171 nd1172 1.958278911312e+00
RINT23362 nd1172 nd1173 1.958278911312e+00
RINT23363 nd1173 nd1174 1.958278911312e+00
RINT23364 nd1174 nd1175 1.958278911312e+00
RINT23365 nd1175 nd1176 1.958278911312e+00
RINT23366 nd1176 nd1177 1.958278911312e+00
RINT23367 nd1178 nd1179 1.732116531491e+01
RINT23368 nd1179 nd1180 1.574448942870e+01
RINT23369 nd1180 nd1181 5.321875196883e+02
RINT23370 nd1181 nd1182 5.411956904962e+02
RINT23371 nd1182 nd1183 3.319743183927e+01
RINT23372 nd1183 nd1184 3.263403263403e+01
RINT23373 nd1184 nd1185 9.444201631702e+01
RINT23374 nd1185 nd1186 5.468750000000e+02
RINT23375 nd1186 nd1187 7.421875000000e+02
RINT23376 nd1187 nd1188 5.468750000000e+02
RINT23377 nd1188 nd1189 5.468750000000e+02
RINT23378 nd1189 nd1190 5.468750000000e+02
RINT23379 nd1190 nd1191 5.468750000000e+02
RINT23380 nd1191 nd1192 5.468750000000e+02
RINT23381 nd1192 nd1193 5.468750000000e+02
RINT23382 nd1193 nd1194 1.503906250000e+03
RINT23383 nd1194 nd1195 2.460937500000e+03
RINT23384 nd1195 nd1196 1.232035738519e+03
RINT23385 nd1196 nd1197 1.520447922098e+01
RINT23386 nd1197 nd1198 2.636374907017e+02
RINT23387 nd1198 nd1199 2.593750000000e+02
RINT23388 nd1199 nd1200 1.875000000000e+01
RINT23389 nd1200 nd1201 1.875000000000e+01
RINT23390 nd1201 nd1202 1.875000000000e+01
RINT23391 nd1202 nd1203 1.875000000000e+01
RINT23392 nd1203 nd1204 1.875000000000e+01
RINT23393 nd1204 nd1205 1.875000000000e+01
RINT23394 nd1205 nd1206 1.875000000000e+01
RINT23395 nd1206 nd1207 1.875000000000e+01
RINT23396 nd1207 nd1208 1.875000000000e+01
RINT23397 nd1209 nd1210 2.356247123801e+00
RINT23398 nd1210 nd1211 2.141767442179e+00
RINT23399 nd1211 nd1212 7.239497399800e+01
RINT23400 nd1212 nd1213 7.362038095942e+01
RINT23401 nd1213 nd1214 4.515940577133e+00
RINT23402 nd1214 nd1215 4.439299789244e+00
RINT23403 nd1215 nd1216 2.381593738975e+00
RINT23404 nd1216 nd1217 1.133606910468e+00
RINT23405 nd1217 nd1218 1.538466521349e+00
RINT23406 nd1218 nd1219 1.133606910468e+00
RINT23407 nd1219 nd1220 1.133606910468e+00
RINT23408 nd1220 nd1221 1.133606910468e+00
RINT23409 nd1221 nd1222 1.133606910468e+00
RINT23410 nd1222 nd1223 1.133606910468e+00
RINT23411 nd1223 nd1224 1.133606910468e+00
RINT23412 nd1224 nd1225 3.117419003786e+00
RINT23413 nd1225 nd1226 5.101231097105e+00
RINT23414 nd1226 nd1227 2.763777430240e+00
RINT23415 nd1227 nd1228 2.068308325796e+00
RINT23416 nd1228 nd1229 3.586335375814e+01
RINT23417 nd1229 nd1230 3.528351508831e+01
RINT23418 nd1230 nd1231 2.550615548552e+00
RINT23419 nd1231 nd1232 2.550615548552e+00
RINT23420 nd1232 nd1233 2.550615548552e+00
RINT23421 nd1233 nd1234 2.550615548552e+00
RINT23422 nd1234 nd1235 2.550615548552e+00
RINT23423 nd1235 nd1236 2.550615548552e+00
RINT23424 nd1236 nd1237 2.550615548552e+00
RINT23425 nd1237 nd1238 2.550615548552e+00
RINT23426 nd1238 nd1239 2.550615548552e+00
RINT23427 nd1240 nd1241 2.356247123801e+00
RINT23428 nd1241 nd1242 2.141767442179e+00
RINT23429 nd1242 nd1243 7.239497399800e+01
RINT23430 nd1243 nd1244 7.362038095942e+01
RINT23431 nd1244 nd1245 4.515940577133e+00
RINT23432 nd1245 nd1246 4.439299789244e+00
RINT23433 nd1246 nd1247 2.381593738975e+00
RINT23434 nd1247 nd1248 1.133606910468e+00
RINT23435 nd1248 nd1249 1.538466521349e+00
RINT23436 nd1249 nd1250 1.133606910468e+00
RINT23437 nd1250 nd1251 1.133606910468e+00
RINT23438 nd1251 nd1252 1.133606910468e+00
RINT23439 nd1252 nd1253 1.133606910468e+00
RINT23440 nd1253 nd1254 1.133606910468e+00
RINT23441 nd1254 nd1255 1.133606910468e+00
RINT23442 nd1255 nd1256 3.117419003786e+00
RINT23443 nd1256 nd1257 5.101231097105e+00
RINT23444 nd1257 nd1258 2.763777430240e+00
RINT23445 nd1258 nd1259 2.068308325796e+00
RINT23446 nd1259 nd1260 3.586335375814e+01
RINT23447 nd1260 nd1261 3.528351508831e+01
RINT23448 nd1261 nd1262 2.550615548552e+00
RINT23449 nd1262 nd1263 2.550615548552e+00
RINT23450 nd1263 nd1264 2.550615548552e+00
RINT23451 nd1264 nd1265 2.550615548552e+00
RINT23452 nd1265 nd1266 2.550615548552e+00
RINT23453 nd1266 nd1267 2.550615548552e+00
RINT23454 nd1267 nd1268 2.550615548552e+00
RINT23455 nd1268 nd1269 2.550615548552e+00
RINT23456 nd1269 nd1270 2.550615548552e+00
RINT23457 nd1271 nd1272 2.356247123801e+00
RINT23458 nd1272 nd1273 2.141767442179e+00
RINT23459 nd1273 nd1274 7.239497399800e+01
RINT23460 nd1274 nd1275 7.362038095942e+01
RINT23461 nd1275 nd1276 4.515940577133e+00
RINT23462 nd1276 nd1277 4.439299789244e+00
RINT23463 nd1277 nd1278 2.381593738975e+00
RINT23464 nd1278 nd1279 1.133606910468e+00
RINT23465 nd1279 nd1280 1.538466521349e+00
RINT23466 nd1280 nd1281 1.133606910468e+00
RINT23467 nd1281 nd1282 1.133606910468e+00
RINT23468 nd1282 nd1283 1.133606910468e+00
RINT23469 nd1283 nd1284 1.133606910468e+00
RINT23470 nd1284 nd1285 1.133606910468e+00
RINT23471 nd1285 nd1286 1.133606910468e+00
RINT23472 nd1286 nd1287 3.117419003786e+00
RINT23473 nd1287 nd1288 5.101231097105e+00
RINT23474 nd1288 nd1289 2.763777430240e+00
RINT23475 nd1289 nd1290 2.068308325796e+00
RINT23476 nd1290 nd1291 3.586335375814e+01
RINT23477 nd1291 nd1292 3.528351508831e+01
RINT23478 nd1292 nd1293 2.550615548552e+00
RINT23479 nd1293 nd1294 2.550615548552e+00
RINT23480 nd1294 nd1295 2.550615548552e+00
RINT23481 nd1295 nd1296 2.550615548552e+00
RINT23482 nd1296 nd1297 2.550615548552e+00
RINT23483 nd1297 nd1298 2.550615548552e+00
RINT23484 nd1298 nd1299 2.550615548552e+00
RINT23485 nd1299 nd1300 2.550615548552e+00
RINT23486 nd1300 nd1301 2.550615548552e+00
RINT23487 nd1302 nd1303 2.493313941068e-01
RINT23488 nd1303 nd1304 2.266357619356e-01
RINT23489 nd1304 nd1305 7.660631014006e+00
RINT23490 nd1305 nd1306 7.790300106417e+00
RINT23491 nd1306 nd1307 4.778640357485e-01
RINT23492 nd1307 nd1308 4.697541247393e-01
RINT23493 nd1308 nd1309 2.520135011038e-01
RINT23494 nd1309 nd1310 1.199550711388e-01
RINT23495 nd1310 nd1311 1.627961679741e-01
RINT23496 nd1311 nd1312 1.199550711388e-01
RINT23497 nd1312 nd1313 1.199550711388e-01
RINT23498 nd1313 nd1314 1.199550711388e-01
RINT23499 nd1314 nd1315 1.199550711388e-01
RINT23500 nd1315 nd1316 1.199550711388e-01
RINT23501 nd1316 nd1317 1.199550711388e-01
RINT23502 nd1317 nd1318 3.298764456317e-01
RINT23503 nd1318 nd1319 5.397978201245e-01
RINT23504 nd1319 nd1320 2.924550963786e-01
RINT23505 nd1320 nd1321 2.188625263897e-01
RINT23506 nd1321 nd1322 3.794958474237e+00
RINT23507 nd1322 nd1323 3.733601589195e+00
RINT23508 nd1323 nd1324 2.698989100623e-01
RINT23509 nd1324 nd1325 2.698989100623e-01
RINT23510 nd1325 nd1326 2.698989100623e-01
RINT23511 nd1326 nd1327 2.698989100623e-01
RINT23512 nd1327 nd1328 2.698989100623e-01
RINT23513 nd1328 nd1329 2.698989100623e-01
RINT23514 nd1329 nd1330 2.698989100623e-01
RINT23515 nd1330 nd1331 2.698989100623e-01
RINT23516 nd1331 nd1332 2.698989100623e-01
RINT23517 nd1333 nd1334 2.493313941068e-01
RINT23518 nd1334 nd1335 2.266357619356e-01
RINT23519 nd1335 nd1336 7.660631014006e+00
RINT23520 nd1336 nd1337 7.790300106417e+00
RINT23521 nd1337 nd1338 4.778640357485e-01
RINT23522 nd1338 nd1339 4.697541247393e-01
RINT23523 nd1339 nd1340 2.520135011038e-01
RINT23524 nd1340 nd1341 1.199550711388e-01
RINT23525 nd1341 nd1342 1.627961679741e-01
RINT23526 nd1342 nd1343 1.199550711388e-01
RINT23527 nd1343 nd1344 1.199550711388e-01
RINT23528 nd1344 nd1345 1.199550711388e-01
RINT23529 nd1345 nd1346 1.199550711388e-01
RINT23530 nd1346 nd1347 1.199550711388e-01
RINT23531 nd1347 nd1348 1.199550711388e-01
RINT23532 nd1348 nd1349 3.298764456317e-01
RINT23533 nd1349 nd1350 5.397978201245e-01
RINT23534 nd1350 nd1351 2.924550963786e-01
RINT23535 nd1351 nd1352 2.188625263897e-01
RINT23536 nd1352 nd1353 3.794958474237e+00
RINT23537 nd1353 nd1354 3.733601589195e+00
RINT23538 nd1354 nd1355 2.698989100623e-01
RINT23539 nd1355 nd1356 2.698989100623e-01
RINT23540 nd1356 nd1357 2.698989100623e-01
RINT23541 nd1357 nd1358 2.698989100623e-01
RINT23542 nd1358 nd1359 2.698989100623e-01
RINT23543 nd1359 nd1360 2.698989100623e-01
RINT23544 nd1360 nd1361 2.698989100623e-01
RINT23545 nd1361 nd1362 2.698989100623e-01
RINT23546 nd1362 nd1363 2.698989100623e-01
RINT23547 nd1364 nd1365 2.493313941068e-01
RINT23548 nd1365 nd1366 2.266357619356e-01
RINT23549 nd1366 nd1367 7.660631014006e+00
RINT23550 nd1367 nd1368 7.790300106417e+00
RINT23551 nd1368 nd1369 4.778640357485e-01
RINT23552 nd1369 nd1370 4.697541247393e-01
RINT23553 nd1370 nd1371 2.520135011038e-01
RINT23554 nd1371 nd1372 1.199550711388e-01
RINT23555 nd1372 nd1373 1.627961679741e-01
RINT23556 nd1373 nd1374 1.199550711388e-01
RINT23557 nd1374 nd1375 1.199550711388e-01
RINT23558 nd1375 nd1376 1.199550711388e-01
RINT23559 nd1376 nd1377 1.199550711388e-01
RINT23560 nd1377 nd1378 1.199550711388e-01
RINT23561 nd1378 nd1379 1.199550711388e-01
RINT23562 nd1379 nd1380 3.298764456317e-01
RINT23563 nd1380 nd1381 5.397978201245e-01
RINT23564 nd1381 nd1382 2.924550963786e-01
RINT23565 nd1382 nd1383 2.188625263897e-01
RINT23566 nd1383 nd1384 3.794958474237e+00
RINT23567 nd1384 nd1385 3.733601589195e+00
RINT23568 nd1385 nd1386 2.698989100623e-01
RINT23569 nd1386 nd1387 2.698989100623e-01
RINT23570 nd1387 nd1388 2.698989100623e-01
RINT23571 nd1388 nd1389 2.698989100623e-01
RINT23572 nd1389 nd1390 2.698989100623e-01
RINT23573 nd1390 nd1391 2.698989100623e-01
RINT23574 nd1391 nd1392 2.698989100623e-01
RINT23575 nd1392 nd1393 2.698989100623e-01
RINT23576 nd1393 nd1394 2.698989100623e-01
RINT23577 nd1395 nd1396 1.832876633312e+00
RINT23578 nd1396 nd1397 1.666037258616e+00
RINT23579 nd1397 nd1398 5.631457535580e+01
RINT23580 nd1398 nd1399 5.726779446562e+01
RINT23581 nd1399 nd1400 3.512858170793e+00
RINT23582 nd1400 nd1401 3.453240863313e+00
RINT23583 nd1401 nd1402 9.993586560904e+00
RINT23584 nd1402 nd1403 5.786876290473e+01
RINT23585 nd1403 nd1404 7.853617822785e+01
RINT23586 nd1404 nd1405 5.786876290473e+01
RINT23587 nd1405 nd1406 5.786876290473e+01
RINT23588 nd1406 nd1407 5.786876290473e+01
RINT23589 nd1407 nd1408 5.786876290473e+01
RINT23590 nd1408 nd1409 5.786876290473e+01
RINT23591 nd1409 nd1410 5.786876290473e+01
RINT23592 nd1410 nd1411 1.591390979880e+02
RINT23593 nd1411 nd1412 2.604094330713e+02
RINT23594 nd1412 nd1413 1.303705308206e+02
RINT23595 nd1413 nd1414 1.608894908578e+00
RINT23596 nd1414 nd1415 2.789737223720e+01
RINT23597 nd1415 nd1416 2.744632754910e+01
RINT23598 nd1416 nd1417 1.984071871019e+00
RINT23599 nd1417 nd1418 1.984071871019e+00
RINT23600 nd1418 nd1419 1.984071871019e+00
RINT23601 nd1419 nd1420 1.984071871019e+00
RINT23602 nd1420 nd1421 1.984071871019e+00
RINT23603 nd1421 nd1422 1.984071871019e+00
RINT23604 nd1422 nd1423 1.984071871019e+00
RINT23605 nd1423 nd1424 1.984071871019e+00
RINT23606 nd1424 nd1425 1.984071871019e+00
RINT23607 nd1426 nd1427 1.914284617627e-01
RINT23608 nd1427 nd1428 1.740035002137e-01
RINT23609 nd1428 nd1429 5.881581083666e+00
RINT23610 nd1429 nd1430 5.981136757300e+00
RINT23611 nd1430 nd1431 3.668883239623e-01
RINT23612 nd1431 nd1432 3.606618004430e-01
RINT23613 nd1432 nd1433 1.976741618838e-01
RINT23614 nd1433 nd1434 8.656063970738e-02
RINT23615 nd1434 nd1435 1.760179307529e-01
RINT23616 nd1435 nd1436 2.136011054157e-01
RINT23617 nd1436 nd1437 2.136011054157e-01
RINT23618 nd1437 nd1438 2.136011054157e-01
RINT23619 nd1438 nd1439 2.136011054157e-01
RINT23620 nd1439 nd1440 2.136011054157e-01
RINT23621 nd1440 nd1441 2.136011054157e-01
RINT23622 nd1441 nd1442 2.884961700761e-01
RINT23623 nd1442 nd1443 4.298149835847e-01
RINT23624 nd1443 nd1444 2.654372658145e-01
RINT23625 nd1444 nd1445 1.680354650659e-01
RINT23626 nd1445 nd1446 2.913644572433e+00
RINT23627 nd1446 nd1447 2.866536769726e+00
RINT23628 nd1447 nd1448 2.072195255224e-01
RINT23629 nd1448 nd1449 2.072195255224e-01
RINT23630 nd1449 nd1450 2.072195255224e-01
RINT23631 nd1450 nd1451 2.072195255224e-01
RINT23632 nd1451 nd1452 2.072195255224e-01
RINT23633 nd1452 nd1453 2.072195255224e-01
RINT23634 nd1453 nd1454 2.072195255224e-01
RINT23635 nd1454 nd1455 2.072195255224e-01
RINT23636 nd1455 nd1456 2.072195255224e-01
RINT23637 nd1457 nd1458 1.914284617627e-01
RINT23638 nd1458 nd1459 1.740035002137e-01
RINT23639 nd1459 nd1460 5.881581083666e+00
RINT23640 nd1460 nd1461 5.981136757300e+00
RINT23641 nd1461 nd1462 3.668883239623e-01
RINT23642 nd1462 nd1463 3.606618004430e-01
RINT23643 nd1463 nd1464 1.976741618838e-01
RINT23644 nd1464 nd1465 8.656063970738e-02
RINT23645 nd1465 nd1466 1.760179307529e-01
RINT23646 nd1466 nd1467 2.136011054157e-01
RINT23647 nd1467 nd1468 2.136011054157e-01
RINT23648 nd1468 nd1469 2.136011054157e-01
RINT23649 nd1469 nd1470 2.136011054157e-01
RINT23650 nd1470 nd1471 2.136011054157e-01
RINT23651 nd1471 nd1472 2.136011054157e-01
RINT23652 nd1472 nd1473 2.884961700761e-01
RINT23653 nd1473 nd1474 4.298149835847e-01
RINT23654 nd1474 nd1475 2.654372658145e-01
RINT23655 nd1475 nd1476 1.680354650659e-01
RINT23656 nd1476 nd1477 2.913644572433e+00
RINT23657 nd1477 nd1478 2.866536769726e+00
RINT23658 nd1478 nd1479 2.072195255224e-01
RINT23659 nd1479 nd1480 2.072195255224e-01
RINT23660 nd1480 nd1481 2.072195255224e-01
RINT23661 nd1481 nd1482 2.072195255224e-01
RINT23662 nd1482 nd1483 2.072195255224e-01
RINT23663 nd1483 nd1484 2.072195255224e-01
RINT23664 nd1484 nd1485 2.072195255224e-01
RINT23665 nd1485 nd1486 2.072195255224e-01
RINT23666 nd1486 nd1487 2.072195255224e-01
RINT23667 nd1488 nd1489 1.914284617627e-01
RINT23668 nd1489 nd1490 1.740035002137e-01
RINT23669 nd1490 nd1491 5.881581083666e+00
RINT23670 nd1491 nd1492 5.981136757300e+00
RINT23671 nd1492 nd1493 3.668883239623e-01
RINT23672 nd1493 nd1494 3.606618004430e-01
RINT23673 nd1494 nd1495 1.976741618838e-01
RINT23674 nd1495 nd1496 8.656063970738e-02
RINT23675 nd1496 nd1497 1.760179307529e-01
RINT23676 nd1497 nd1498 2.136011054157e-01
RINT23677 nd1498 nd1499 2.136011054157e-01
RINT23678 nd1499 nd1500 2.136011054157e-01
RINT23679 nd1500 nd1501 2.136011054157e-01
RINT23680 nd1501 nd1502 2.136011054157e-01
RINT23681 nd1502 nd1503 2.136011054157e-01
RINT23682 nd1503 nd1504 2.884961700761e-01
RINT23683 nd1504 nd1505 4.298149835847e-01
RINT23684 nd1505 nd1506 2.654372658145e-01
RINT23685 nd1506 nd1507 1.680354650659e-01
RINT23686 nd1507 nd1508 2.913644572433e+00
RINT23687 nd1508 nd1509 2.866536769726e+00
RINT23688 nd1509 nd1510 2.072195255224e-01
RINT23689 nd1510 nd1511 2.072195255224e-01
RINT23690 nd1511 nd1512 2.072195255224e-01
RINT23691 nd1512 nd1513 2.072195255224e-01
RINT23692 nd1513 nd1514 2.072195255224e-01
RINT23693 nd1514 nd1515 2.072195255224e-01
RINT23694 nd1515 nd1516 2.072195255224e-01
RINT23695 nd1516 nd1517 2.072195255224e-01
RINT23696 nd1517 nd1518 2.072195255224e-01
RINT23697 nd1519 nd1520 1.914284617627e-01
RINT23698 nd1520 nd1521 1.740035002137e-01
RINT23699 nd1521 nd1522 5.881581083666e+00
RINT23700 nd1522 nd1523 5.981136757300e+00
RINT23701 nd1523 nd1524 3.668883239623e-01
RINT23702 nd1524 nd1525 3.606618004430e-01
RINT23703 nd1525 nd1526 1.976741618838e-01
RINT23704 nd1526 nd1527 8.656063970739e-02
RINT23705 nd1527 nd1528 1.760179307529e-01
RINT23706 nd1528 nd1529 2.136011054157e-01
RINT23707 nd1529 nd1530 2.136011054157e-01
RINT23708 nd1530 nd1531 2.136011054157e-01
RINT23709 nd1531 nd1532 2.136011054157e-01
RINT23710 nd1532 nd1533 2.136011054157e-01
RINT23711 nd1533 nd1534 2.136011054157e-01
RINT23712 nd1534 nd1535 2.884961700761e-01
RINT23713 nd1535 nd1536 4.298149835847e-01
RINT23714 nd1536 nd1537 2.654372658145e-01
RINT23715 nd1537 nd1538 1.680354650659e-01
RINT23716 nd1538 nd1539 2.913644572433e+00
RINT23717 nd1539 nd1540 2.866536769726e+00
RINT23718 nd1540 nd1541 2.072195255224e-01
RINT23719 nd1541 nd1542 2.072195255224e-01
RINT23720 nd1542 nd1543 2.072195255224e-01
RINT23721 nd1543 nd1544 2.072195255224e-01
RINT23722 nd1544 nd1545 2.072195255224e-01
RINT23723 nd1545 nd1546 2.072195255224e-01
RINT23724 nd1546 nd1547 2.072195255224e-01
RINT23725 nd1547 nd1548 2.072195255224e-01
RINT23726 nd1548 nd1549 2.072195255224e-01
RINT23727 nd1550 nd1551 1.914284617627e-01
RINT23728 nd1551 nd1552 1.740035002137e-01
RINT23729 nd1552 nd1553 5.881581083666e+00
RINT23730 nd1553 nd1554 5.981136757300e+00
RINT23731 nd1554 nd1555 3.668883239623e-01
RINT23732 nd1555 nd1556 3.606618004430e-01
RINT23733 nd1556 nd1557 1.976741618838e-01
RINT23734 nd1557 nd1558 8.656063970738e-02
RINT23735 nd1558 nd1559 1.760179307529e-01
RINT23736 nd1559 nd1560 2.136011054157e-01
RINT23737 nd1560 nd1561 2.136011054157e-01
RINT23738 nd1561 nd1562 2.136011054157e-01
RINT23739 nd1562 nd1563 2.136011054157e-01
RINT23740 nd1563 nd1564 2.136011054157e-01
RINT23741 nd1564 nd1565 2.136011054157e-01
RINT23742 nd1565 nd1566 2.884961700761e-01
RINT23743 nd1566 nd1567 4.298149835847e-01
RINT23744 nd1567 nd1568 2.654372658145e-01
RINT23745 nd1568 nd1569 1.680354650659e-01
RINT23746 nd1569 nd1570 2.913644572433e+00
RINT23747 nd1570 nd1571 2.866536769726e+00
RINT23748 nd1571 nd1572 2.072195255224e-01
RINT23749 nd1572 nd1573 2.072195255224e-01
RINT23750 nd1573 nd1574 2.072195255224e-01
RINT23751 nd1574 nd1575 2.072195255224e-01
RINT23752 nd1575 nd1576 2.072195255224e-01
RINT23753 nd1576 nd1577 2.072195255224e-01
RINT23754 nd1577 nd1578 2.072195255224e-01
RINT23755 nd1578 nd1579 2.072195255224e-01
RINT23756 nd1579 nd1580 2.072195255224e-01
RINT23757 nd1581 nd1582 1.914284617627e-01
RINT23758 nd1582 nd1583 1.740035002137e-01
RINT23759 nd1583 nd1584 5.881581083666e+00
RINT23760 nd1584 nd1585 5.981136757300e+00
RINT23761 nd1585 nd1586 3.668883239623e-01
RINT23762 nd1586 nd1587 3.606618004430e-01
RINT23763 nd1587 nd1588 1.976741618838e-01
RINT23764 nd1588 nd1589 8.656063970738e-02
RINT23765 nd1589 nd1590 1.760179307529e-01
RINT23766 nd1590 nd1591 2.136011054157e-01
RINT23767 nd1591 nd1592 2.136011054157e-01
RINT23768 nd1592 nd1593 2.136011054157e-01
RINT23769 nd1593 nd1594 2.136011054157e-01
RINT23770 nd1594 nd1595 2.136011054157e-01
RINT23771 nd1595 nd1596 2.136011054157e-01
RINT23772 nd1596 nd1597 2.884961700761e-01
RINT23773 nd1597 nd1598 4.298149835847e-01
RINT23774 nd1598 nd1599 2.654372658145e-01
RINT23775 nd1599 nd1600 1.680354650659e-01
RINT23776 nd1600 nd1601 2.913644572433e+00
RINT23777 nd1601 nd1602 2.866536769726e+00
RINT23778 nd1602 nd1603 2.072195255224e-01
RINT23779 nd1603 nd1604 2.072195255224e-01
RINT23780 nd1604 nd1605 2.072195255224e-01
RINT23781 nd1605 nd1606 2.072195255224e-01
RINT23782 nd1606 nd1607 2.072195255224e-01
RINT23783 nd1607 nd1608 2.072195255224e-01
RINT23784 nd1608 nd1609 2.072195255224e-01
RINT23785 nd1609 nd1610 2.072195255224e-01
RINT23786 nd1610 nd1611 2.072195255224e-01
RINT23787 nd1612 nd1613 1.832876633312e+00
RINT23788 nd1613 nd1614 1.666037258616e+00
RINT23789 nd1614 nd1615 5.631457535579e+01
RINT23790 nd1615 nd1616 5.726779446562e+01
RINT23791 nd1616 nd1617 3.512858170793e+00
RINT23792 nd1617 nd1618 3.453240863313e+00
RINT23793 nd1618 nd1619 9.993586560904e+00
RINT23794 nd1619 nd1620 5.786876290473e+01
RINT23795 nd1620 nd1621 7.853617822785e+01
RINT23796 nd1621 nd1622 5.786876290473e+01
RINT23797 nd1622 nd1623 5.786876290473e+01
RINT23798 nd1623 nd1624 5.786876290473e+01
RINT23799 nd1624 nd1625 5.786876290473e+01
RINT23800 nd1625 nd1626 5.786876290473e+01
RINT23801 nd1626 nd1627 5.786876290473e+01
RINT23802 nd1627 nd1628 1.591390979880e+02
RINT23803 nd1628 nd1629 2.604094330713e+02
RINT23804 nd1629 nd1630 1.303705308206e+02
RINT23805 nd1630 nd1631 1.608894908578e+00
RINT23806 nd1631 nd1632 2.789737223720e+01
RINT23807 nd1632 nd1633 2.744632754910e+01
RINT23808 nd1633 nd1634 1.984071871019e+00
RINT23809 nd1634 nd1635 1.984071871019e+00
RINT23810 nd1635 nd1636 1.984071871019e+00
RINT23811 nd1636 nd1637 1.984071871019e+00
RINT23812 nd1637 nd1638 1.984071871019e+00
RINT23813 nd1638 nd1639 1.984071871019e+00
RINT23814 nd1639 nd1640 1.984071871019e+00
RINT23815 nd1640 nd1641 1.984071871019e+00
RINT23816 nd1641 nd1642 1.984071871019e+00
RINT23817 nd1643 nd1644 1.914284617627e-01
RINT23818 nd1644 nd1645 1.740035002137e-01
RINT23819 nd1645 nd1646 5.881581083666e+00
RINT23820 nd1646 nd1647 5.981136757300e+00
RINT23821 nd1647 nd1648 3.668883239623e-01
RINT23822 nd1648 nd1649 3.606618004430e-01
RINT23823 nd1649 nd1650 1.976741618838e-01
RINT23824 nd1650 nd1651 8.656063970739e-02
RINT23825 nd1651 nd1652 1.760179307529e-01
RINT23826 nd1652 nd1653 2.136011054157e-01
RINT23827 nd1653 nd1654 2.136011054157e-01
RINT23828 nd1654 nd1655 2.136011054157e-01
RINT23829 nd1655 nd1656 2.136011054157e-01
RINT23830 nd1656 nd1657 2.136011054157e-01
RINT23831 nd1657 nd1658 2.136011054157e-01
RINT23832 nd1658 nd1659 2.884961700761e-01
RINT23833 nd1659 nd1660 4.298149835847e-01
RINT23834 nd1660 nd1661 2.654372658145e-01
RINT23835 nd1661 nd1662 1.680354650659e-01
RINT23836 nd1662 nd1663 2.913644572433e+00
RINT23837 nd1663 nd1664 2.866536769726e+00
RINT23838 nd1664 nd1665 2.072195255224e-01
RINT23839 nd1665 nd1666 2.072195255224e-01
RINT23840 nd1666 nd1667 2.072195255224e-01
RINT23841 nd1667 nd1668 2.072195255224e-01
RINT23842 nd1668 nd1669 2.072195255224e-01
RINT23843 nd1669 nd1670 2.072195255224e-01
RINT23844 nd1670 nd1671 2.072195255224e-01
RINT23845 nd1671 nd1672 2.072195255224e-01
RINT23846 nd1672 nd1673 2.072195255224e-01
RINT23847 nd1674 nd1675 1.914284617627e-01
RINT23848 nd1675 nd1676 1.740035002137e-01
RINT23849 nd1676 nd1677 5.881581083666e+00
RINT23850 nd1677 nd1678 5.981136757300e+00
RINT23851 nd1678 nd1679 3.668883239623e-01
RINT23852 nd1679 nd1680 3.606618004430e-01
RINT23853 nd1680 nd1681 1.976741618838e-01
RINT23854 nd1681 nd1682 8.656063970738e-02
RINT23855 nd1682 nd1683 1.760179307529e-01
RINT23856 nd1683 nd1684 2.136011054157e-01
RINT23857 nd1684 nd1685 2.136011054157e-01
RINT23858 nd1685 nd1686 2.136011054157e-01
RINT23859 nd1686 nd1687 2.136011054157e-01
RINT23860 nd1687 nd1688 2.136011054157e-01
RINT23861 nd1688 nd1689 2.136011054157e-01
RINT23862 nd1689 nd1690 2.884961700761e-01
RINT23863 nd1690 nd1691 4.298149835847e-01
RINT23864 nd1691 nd1692 2.654372658145e-01
RINT23865 nd1692 nd1693 1.680354650659e-01
RINT23866 nd1693 nd1694 2.913644572433e+00
RINT23867 nd1694 nd1695 2.866536769726e+00
RINT23868 nd1695 nd1696 2.072195255224e-01
RINT23869 nd1696 nd1697 2.072195255224e-01
RINT23870 nd1697 nd1698 2.072195255224e-01
RINT23871 nd1698 nd1699 2.072195255224e-01
RINT23872 nd1699 nd1700 2.072195255224e-01
RINT23873 nd1700 nd1701 2.072195255224e-01
RINT23874 nd1701 nd1702 2.072195255224e-01
RINT23875 nd1702 nd1703 2.072195255224e-01
RINT23876 nd1703 nd1704 2.072195255224e-01
RINT23877 nd1705 nd1706 1.914284617627e-01
RINT23878 nd1706 nd1707 1.740035002137e-01
RINT23879 nd1707 nd1708 5.881581083666e+00
RINT23880 nd1708 nd1709 5.981136757300e+00
RINT23881 nd1709 nd1710 3.668883239623e-01
RINT23882 nd1710 nd1711 3.606618004430e-01
RINT23883 nd1711 nd1712 1.976741618838e-01
RINT23884 nd1712 nd1713 8.656063970739e-02
RINT23885 nd1713 nd1714 1.760179307529e-01
RINT23886 nd1714 nd1715 2.136011054157e-01
RINT23887 nd1715 nd1716 2.136011054157e-01
RINT23888 nd1716 nd1717 2.136011054157e-01
RINT23889 nd1717 nd1718 2.136011054157e-01
RINT23890 nd1718 nd1719 2.136011054157e-01
RINT23891 nd1719 nd1720 2.136011054157e-01
RINT23892 nd1720 nd1721 2.884961700761e-01
RINT23893 nd1721 nd1722 4.298149835847e-01
RINT23894 nd1722 nd1723 2.654372658145e-01
RINT23895 nd1723 nd1724 1.680354650659e-01
RINT23896 nd1724 nd1725 2.913644572433e+00
RINT23897 nd1725 nd1726 2.866536769726e+00
RINT23898 nd1726 nd1727 2.072195255224e-01
RINT23899 nd1727 nd1728 2.072195255224e-01
RINT23900 nd1728 nd1729 2.072195255224e-01
RINT23901 nd1729 nd1730 2.072195255224e-01
RINT23902 nd1730 nd1731 2.072195255224e-01
RINT23903 nd1731 nd1732 2.072195255224e-01
RINT23904 nd1732 nd1733 2.072195255224e-01
RINT23905 nd1733 nd1734 2.072195255224e-01
RINT23906 nd1734 nd1735 2.072195255224e-01
RINT23907 nd1736 nd1737 1.914284617627e-01
RINT23908 nd1737 nd1738 1.740035002137e-01
RINT23909 nd1738 nd1739 5.881581083666e+00
RINT23910 nd1739 nd1740 5.981136757300e+00
RINT23911 nd1740 nd1741 3.668883239623e-01
RINT23912 nd1741 nd1742 3.606618004430e-01
RINT23913 nd1742 nd1743 1.976741618838e-01
RINT23914 nd1743 nd1744 8.656063970739e-02
RINT23915 nd1744 nd1745 1.760179307529e-01
RINT23916 nd1745 nd1746 2.136011054157e-01
RINT23917 nd1746 nd1747 2.136011054157e-01
RINT23918 nd1747 nd1748 2.136011054157e-01
RINT23919 nd1748 nd1749 2.136011054157e-01
RINT23920 nd1749 nd1750 2.136011054157e-01
RINT23921 nd1750 nd1751 2.136011054157e-01
RINT23922 nd1751 nd1752 2.884961700761e-01
RINT23923 nd1752 nd1753 4.298149835847e-01
RINT23924 nd1753 nd1754 2.654372658145e-01
RINT23925 nd1754 nd1755 1.680354650659e-01
RINT23926 nd1755 nd1756 2.913644572433e+00
RINT23927 nd1756 nd1757 2.866536769726e+00
RINT23928 nd1757 nd1758 2.072195255224e-01
RINT23929 nd1758 nd1759 2.072195255224e-01
RINT23930 nd1759 nd1760 2.072195255224e-01
RINT23931 nd1760 nd1761 2.072195255224e-01
RINT23932 nd1761 nd1762 2.072195255224e-01
RINT23933 nd1762 nd1763 2.072195255224e-01
RINT23934 nd1763 nd1764 2.072195255224e-01
RINT23935 nd1764 nd1765 2.072195255224e-01
RINT23936 nd1765 nd1766 2.072195255224e-01
RINT23937 nd1767 nd1768 1.914284617627e-01
RINT23938 nd1768 nd1769 1.740035002137e-01
RINT23939 nd1769 nd1770 5.881581083666e+00
RINT23940 nd1770 nd1771 5.981136757300e+00
RINT23941 nd1771 nd1772 3.668883239623e-01
RINT23942 nd1772 nd1773 3.606618004430e-01
RINT23943 nd1773 nd1774 1.976741618838e-01
RINT23944 nd1774 nd1775 8.656063970738e-02
RINT23945 nd1775 nd1776 1.760179307529e-01
RINT23946 nd1776 nd1777 2.136011054157e-01
RINT23947 nd1777 nd1778 2.136011054157e-01
RINT23948 nd1778 nd1779 2.136011054157e-01
RINT23949 nd1779 nd1780 2.136011054157e-01
RINT23950 nd1780 nd1781 2.136011054157e-01
RINT23951 nd1781 nd1782 2.136011054157e-01
RINT23952 nd1782 nd1783 2.884961700761e-01
RINT23953 nd1783 nd1784 4.298149835847e-01
RINT23954 nd1784 nd1785 2.654372658145e-01
RINT23955 nd1785 nd1786 1.680354650659e-01
RINT23956 nd1786 nd1787 2.913644572433e+00
RINT23957 nd1787 nd1788 2.866536769726e+00
RINT23958 nd1788 nd1789 2.072195255224e-01
RINT23959 nd1789 nd1790 2.072195255224e-01
RINT23960 nd1790 nd1791 2.072195255224e-01
RINT23961 nd1791 nd1792 2.072195255224e-01
RINT23962 nd1792 nd1793 2.072195255224e-01
RINT23963 nd1793 nd1794 2.072195255224e-01
RINT23964 nd1794 nd1795 2.072195255224e-01
RINT23965 nd1795 nd1796 2.072195255224e-01
RINT23966 nd1796 nd1797 2.072195255224e-01
RINT23967 nd1798 nd1799 1.914284617627e-01
RINT23968 nd1799 nd1800 1.740035002137e-01
RINT23969 nd1800 nd1801 5.881581083666e+00
RINT23970 nd1801 nd1802 5.981136757300e+00
RINT23971 nd1802 nd1803 3.668883239623e-01
RINT23972 nd1803 nd1804 3.606618004430e-01
RINT23973 nd1804 nd1805 1.976741618838e-01
RINT23974 nd1805 nd1806 8.656063970739e-02
RINT23975 nd1806 nd1807 1.760179307529e-01
RINT23976 nd1807 nd1808 2.136011054157e-01
RINT23977 nd1808 nd1809 2.136011054157e-01
RINT23978 nd1809 nd1810 2.136011054157e-01
RINT23979 nd1810 nd1811 2.136011054157e-01
RINT23980 nd1811 nd1812 2.136011054157e-01
RINT23981 nd1812 nd1813 2.136011054157e-01
RINT23982 nd1813 nd1814 2.884961700761e-01
RINT23983 nd1814 nd1815 4.298149835847e-01
RINT23984 nd1815 nd1816 2.654372658145e-01
RINT23985 nd1816 nd1817 1.680354650659e-01
RINT23986 nd1817 nd1818 2.913644572433e+00
RINT23987 nd1818 nd1819 2.866536769726e+00
RINT23988 nd1819 nd1820 2.072195255224e-01
RINT23989 nd1820 nd1821 2.072195255224e-01
RINT23990 nd1821 nd1822 2.072195255224e-01
RINT23991 nd1822 nd1823 2.072195255224e-01
RINT23992 nd1823 nd1824 2.072195255224e-01
RINT23993 nd1824 nd1825 2.072195255224e-01
RINT23994 nd1825 nd1826 2.072195255224e-01
RINT23995 nd1826 nd1827 2.072195255224e-01
RINT23996 nd1827 nd1828 2.072195255224e-01
RINT23997 nd1829 nd1830 1.832876633312e+00
RINT23998 nd1830 nd1831 1.666037258616e+00
RINT23999 nd1831 nd1832 5.631457535579e+01
RINT24000 nd1832 nd1833 5.726779446562e+01
RINT24001 nd1833 nd1834 3.512858170793e+00
RINT24002 nd1834 nd1835 3.453240863313e+00
RINT24003 nd1835 nd1836 9.993586560904e+00
RINT24004 nd1836 nd1837 5.786876290473e+01
RINT24005 nd1837 nd1838 7.853617822785e+01
RINT24006 nd1838 nd1839 5.786876290473e+01
RINT24007 nd1839 nd1840 5.786876290473e+01
RINT24008 nd1840 nd1841 5.786876290473e+01
RINT24009 nd1841 nd1842 5.786876290473e+01
RINT24010 nd1842 nd1843 5.786876290473e+01
RINT24011 nd1843 nd1844 5.786876290473e+01
RINT24012 nd1844 nd1845 1.591390979880e+02
RINT24013 nd1845 nd1846 2.604094330713e+02
RINT24014 nd1846 nd1847 1.303705308206e+02
RINT24015 nd1847 nd1848 1.608894908578e+00
RINT24016 nd1848 nd1849 2.789737223720e+01
RINT24017 nd1849 nd1850 2.744632754910e+01
RINT24018 nd1850 nd1851 1.984071871019e+00
RINT24019 nd1851 nd1852 1.984071871019e+00
RINT24020 nd1852 nd1853 1.984071871019e+00
RINT24021 nd1853 nd1854 1.984071871019e+00
RINT24022 nd1854 nd1855 1.984071871019e+00
RINT24023 nd1855 nd1856 1.984071871019e+00
RINT24024 nd1856 nd1857 1.984071871019e+00
RINT24025 nd1857 nd1858 1.984071871019e+00
RINT24026 nd1858 nd1859 1.984071871019e+00
RINT24027 nd1860 nd1861 2.493313941068e-01
RINT24028 nd1861 nd1862 2.266357619356e-01
RINT24029 nd1862 nd1863 7.660631014006e+00
RINT24030 nd1863 nd1864 7.790300106417e+00
RINT24031 nd1864 nd1865 4.778640357485e-01
RINT24032 nd1865 nd1866 4.697541247393e-01
RINT24033 nd1866 nd1867 2.520135011038e-01
RINT24034 nd1867 nd1868 1.199550711388e-01
RINT24035 nd1868 nd1869 1.627961679741e-01
RINT24036 nd1869 nd1870 1.199550711388e-01
RINT24037 nd1870 nd1871 1.199550711388e-01
RINT24038 nd1871 nd1872 1.199550711388e-01
RINT24039 nd1872 nd1873 1.199550711388e-01
RINT24040 nd1873 nd1874 1.199550711388e-01
RINT24041 nd1874 nd1875 1.199550711388e-01
RINT24042 nd1875 nd1876 3.298764456317e-01
RINT24043 nd1876 nd1877 5.397978201245e-01
RINT24044 nd1877 nd1878 2.924550963786e-01
RINT24045 nd1878 nd1879 2.188625263897e-01
RINT24046 nd1879 nd1880 3.794958474237e+00
RINT24047 nd1880 nd1881 3.733601589195e+00
RINT24048 nd1881 nd1882 2.698989100623e-01
RINT24049 nd1882 nd1883 2.698989100623e-01
RINT24050 nd1883 nd1884 2.698989100623e-01
RINT24051 nd1884 nd1885 2.698989100623e-01
RINT24052 nd1885 nd1886 2.698989100623e-01
RINT24053 nd1886 nd1887 2.698989100623e-01
RINT24054 nd1887 nd1888 2.698989100623e-01
RINT24055 nd1888 nd1889 2.698989100623e-01
RINT24056 nd1889 nd1890 2.698989100623e-01
RINT24057 nd1891 nd1892 2.493313941068e-01
RINT24058 nd1892 nd1893 2.266357619356e-01
RINT24059 nd1893 nd1894 7.660631014006e+00
RINT24060 nd1894 nd1895 7.790300106417e+00
RINT24061 nd1895 nd1896 4.778640357485e-01
RINT24062 nd1896 nd1897 4.697541247393e-01
RINT24063 nd1897 nd1898 2.520135011038e-01
RINT24064 nd1898 nd1899 1.199550711388e-01
RINT24065 nd1899 nd1900 1.627961679741e-01
RINT24066 nd1900 nd1901 1.199550711388e-01
RINT24067 nd1901 nd1902 1.199550711388e-01
RINT24068 nd1902 nd1903 1.199550711388e-01
RINT24069 nd1903 nd1904 1.199550711388e-01
RINT24070 nd1904 nd1905 1.199550711388e-01
RINT24071 nd1905 nd1906 1.199550711388e-01
RINT24072 nd1906 nd1907 3.298764456317e-01
RINT24073 nd1907 nd1908 5.397978201245e-01
RINT24074 nd1908 nd1909 2.924550963786e-01
RINT24075 nd1909 nd1910 2.188625263897e-01
RINT24076 nd1910 nd1911 3.794958474237e+00
RINT24077 nd1911 nd1912 3.733601589195e+00
RINT24078 nd1912 nd1913 2.698989100623e-01
RINT24079 nd1913 nd1914 2.698989100623e-01
RINT24080 nd1914 nd1915 2.698989100623e-01
RINT24081 nd1915 nd1916 2.698989100623e-01
RINT24082 nd1916 nd1917 2.698989100623e-01
RINT24083 nd1917 nd1918 2.698989100623e-01
RINT24084 nd1918 nd1919 2.698989100623e-01
RINT24085 nd1919 nd1920 2.698989100623e-01
RINT24086 nd1920 nd1921 2.698989100623e-01
RINT24087 nd1922 nd1923 2.493313941068e-01
RINT24088 nd1923 nd1924 2.266357619356e-01
RINT24089 nd1924 nd1925 7.660631014006e+00
RINT24090 nd1925 nd1926 7.790300106417e+00
RINT24091 nd1926 nd1927 4.778640357485e-01
RINT24092 nd1927 nd1928 4.697541247393e-01
RINT24093 nd1928 nd1929 2.520135011038e-01
RINT24094 nd1929 nd1930 1.199550711388e-01
RINT24095 nd1930 nd1931 1.627961679741e-01
RINT24096 nd1931 nd1932 1.199550711388e-01
RINT24097 nd1932 nd1933 1.199550711388e-01
RINT24098 nd1933 nd1934 1.199550711388e-01
RINT24099 nd1934 nd1935 1.199550711388e-01
RINT24100 nd1935 nd1936 1.199550711388e-01
RINT24101 nd1936 nd1937 1.199550711388e-01
RINT24102 nd1937 nd1938 3.298764456317e-01
RINT24103 nd1938 nd1939 5.397978201245e-01
RINT24104 nd1939 nd1940 2.924550963786e-01
RINT24105 nd1940 nd1941 2.188625263897e-01
RINT24106 nd1941 nd1942 3.794958474237e+00
RINT24107 nd1942 nd1943 3.733601589195e+00
RINT24108 nd1943 nd1944 2.698989100623e-01
RINT24109 nd1944 nd1945 2.698989100623e-01
RINT24110 nd1945 nd1946 2.698989100623e-01
RINT24111 nd1946 nd1947 2.698989100623e-01
RINT24112 nd1947 nd1948 2.698989100623e-01
RINT24113 nd1948 nd1949 2.698989100623e-01
RINT24114 nd1949 nd1950 2.698989100623e-01
RINT24115 nd1950 nd1951 2.698989100623e-01
RINT24116 nd1951 nd1952 2.698989100623e-01
RINT24117 nd1953 nd1954 2.493313941068e-01
RINT24118 nd1954 nd1955 2.266357619356e-01
RINT24119 nd1955 nd1956 7.660631014006e+00
RINT24120 nd1956 nd1957 7.790300106417e+00
RINT24121 nd1957 nd1958 4.778640357485e-01
RINT24122 nd1958 nd1959 4.697541247393e-01
RINT24123 nd1959 nd1960 2.520135011038e-01
RINT24124 nd1960 nd1961 1.199550711388e-01
RINT24125 nd1961 nd1962 1.627961679741e-01
RINT24126 nd1962 nd1963 1.199550711388e-01
RINT24127 nd1963 nd1964 1.199550711388e-01
RINT24128 nd1964 nd1965 1.199550711388e-01
RINT24129 nd1965 nd1966 1.199550711388e-01
RINT24130 nd1966 nd1967 1.199550711388e-01
RINT24131 nd1967 nd1968 1.199550711388e-01
RINT24132 nd1968 nd1969 3.298764456317e-01
RINT24133 nd1969 nd1970 5.397978201245e-01
RINT24134 nd1970 nd1971 2.924550963786e-01
RINT24135 nd1971 nd1972 2.188625263897e-01
RINT24136 nd1972 nd1973 3.794958474237e+00
RINT24137 nd1973 nd1974 3.733601589195e+00
RINT24138 nd1974 nd1975 2.698989100623e-01
RINT24139 nd1975 nd1976 2.698989100623e-01
RINT24140 nd1976 nd1977 2.698989100623e-01
RINT24141 nd1977 nd1978 2.698989100623e-01
RINT24142 nd1978 nd1979 2.698989100623e-01
RINT24143 nd1979 nd1980 2.698989100623e-01
RINT24144 nd1980 nd1981 2.698989100623e-01
RINT24145 nd1981 nd1982 2.698989100623e-01
RINT24146 nd1982 nd1983 2.698989100623e-01
RINT24147 nd1984 nd1985 2.493313941068e-01
RINT24148 nd1985 nd1986 2.266357619356e-01
RINT24149 nd1986 nd1987 7.660631014006e+00
RINT24150 nd1987 nd1988 7.790300106417e+00
RINT24151 nd1988 nd1989 4.778640357485e-01
RINT24152 nd1989 nd1990 4.697541247393e-01
RINT24153 nd1990 nd1991 2.520135011038e-01
RINT24154 nd1991 nd1992 1.199550711388e-01
RINT24155 nd1992 nd1993 1.627961679741e-01
RINT24156 nd1993 nd1994 1.199550711388e-01
RINT24157 nd1994 nd1995 1.199550711388e-01
RINT24158 nd1995 nd1996 1.199550711388e-01
RINT24159 nd1996 nd1997 1.199550711388e-01
RINT24160 nd1997 nd1998 1.199550711388e-01
RINT24161 nd1998 nd1999 1.199550711388e-01
RINT24162 nd1999 nd2000 3.298764456317e-01
RINT24163 nd2000 nd2001 5.397978201245e-01
RINT24164 nd2001 nd2002 2.924550963786e-01
RINT24165 nd2002 nd2003 2.188625263897e-01
RINT24166 nd2003 nd2004 3.794958474237e+00
RINT24167 nd2004 nd2005 3.733601589195e+00
RINT24168 nd2005 nd2006 2.698989100623e-01
RINT24169 nd2006 nd2007 2.698989100623e-01
RINT24170 nd2007 nd2008 2.698989100623e-01
RINT24171 nd2008 nd2009 2.698989100623e-01
RINT24172 nd2009 nd2010 2.698989100623e-01
RINT24173 nd2010 nd2011 2.698989100623e-01
RINT24174 nd2011 nd2012 2.698989100623e-01
RINT24175 nd2012 nd2013 2.698989100623e-01
RINT24176 nd2013 nd2014 2.698989100623e-01
RINT24177 nd2015 nd2016 2.493313941068e-01
RINT24178 nd2016 nd2017 2.266357619356e-01
RINT24179 nd2017 nd2018 7.660631014006e+00
RINT24180 nd2018 nd2019 7.790300106417e+00
RINT24181 nd2019 nd2020 4.778640357485e-01
RINT24182 nd2020 nd2021 4.697541247393e-01
RINT24183 nd2021 nd2022 2.520135011038e-01
RINT24184 nd2022 nd2023 1.199550711388e-01
RINT24185 nd2023 nd2024 1.627961679741e-01
RINT24186 nd2024 nd2025 1.199550711388e-01
RINT24187 nd2025 nd2026 1.199550711388e-01
RINT24188 nd2026 nd2027 1.199550711388e-01
RINT24189 nd2027 nd2028 1.199550711388e-01
RINT24190 nd2028 nd2029 1.199550711388e-01
RINT24191 nd2029 nd2030 1.199550711388e-01
RINT24192 nd2030 nd2031 3.298764456317e-01
RINT24193 nd2031 nd2032 5.397978201245e-01
RINT24194 nd2032 nd2033 2.924550963786e-01
RINT24195 nd2033 nd2034 2.188625263897e-01
RINT24196 nd2034 nd2035 3.794958474237e+00
RINT24197 nd2035 nd2036 3.733601589195e+00
RINT24198 nd2036 nd2037 2.698989100623e-01
RINT24199 nd2037 nd2038 2.698989100623e-01
RINT24200 nd2038 nd2039 2.698989100623e-01
RINT24201 nd2039 nd2040 2.698989100623e-01
RINT24202 nd2040 nd2041 2.698989100623e-01
RINT24203 nd2041 nd2042 2.698989100623e-01
RINT24204 nd2042 nd2043 2.698989100623e-01
RINT24205 nd2043 nd2044 2.698989100623e-01
RINT24206 nd2044 nd2045 2.698989100623e-01
RINT24207 nd2046 nd2047 1.832876633312e+00
RINT24208 nd2047 nd2048 1.666037258616e+00
RINT24209 nd2048 nd2049 5.631457535580e+01
RINT24210 nd2049 nd2050 5.726779446562e+01
RINT24211 nd2050 nd2051 3.512858170793e+00
RINT24212 nd2051 nd2052 3.453240863313e+00
RINT24213 nd2052 nd2053 9.993586560904e+00
RINT24214 nd2053 nd2054 5.786876290473e+01
RINT24215 nd2054 nd2055 7.853617822785e+01
RINT24216 nd2055 nd2056 5.786876290473e+01
RINT24217 nd2056 nd2057 5.786876290473e+01
RINT24218 nd2057 nd2058 5.786876290473e+01
RINT24219 nd2058 nd2059 5.786876290473e+01
RINT24220 nd2059 nd2060 5.786876290473e+01
RINT24221 nd2060 nd2061 5.786876290473e+01
RINT24222 nd2061 nd2062 1.591390979880e+02
RINT24223 nd2062 nd2063 2.604094330713e+02
RINT24224 nd2063 nd2064 1.303705308206e+02
RINT24225 nd2064 nd2065 1.608894908578e+00
RINT24226 nd2065 nd2066 2.789737223720e+01
RINT24227 nd2066 nd2067 2.744632754910e+01
RINT24228 nd2067 nd2068 1.984071871019e+00
RINT24229 nd2068 nd2069 1.984071871019e+00
RINT24230 nd2069 nd2070 1.984071871019e+00
RINT24231 nd2070 nd2071 1.984071871019e+00
RINT24232 nd2071 nd2072 1.984071871019e+00
RINT24233 nd2072 nd2073 1.984071871019e+00
RINT24234 nd2073 nd2074 1.984071871019e+00
RINT24235 nd2074 nd2075 1.984071871019e+00
RINT24236 nd2075 nd2076 1.984071871019e+00
RINT24237 nd2077 nd2078 1.914284617627e-01
RINT24238 nd2078 nd2079 1.740035002137e-01
RINT24239 nd2079 nd2080 5.881581083666e+00
RINT24240 nd2080 nd2081 5.981136757300e+00
RINT24241 nd2081 nd2082 3.668883239623e-01
RINT24242 nd2082 nd2083 3.606618004430e-01
RINT24243 nd2083 nd2084 1.976741618838e-01
RINT24244 nd2084 nd2085 8.656063970738e-02
RINT24245 nd2085 nd2086 1.760179307529e-01
RINT24246 nd2086 nd2087 2.136011054157e-01
RINT24247 nd2087 nd2088 2.136011054157e-01
RINT24248 nd2088 nd2089 2.136011054157e-01
RINT24249 nd2089 nd2090 2.136011054157e-01
RINT24250 nd2090 nd2091 2.136011054157e-01
RINT24251 nd2091 nd2092 2.136011054157e-01
RINT24252 nd2092 nd2093 2.884961700761e-01
RINT24253 nd2093 nd2094 4.298149835847e-01
RINT24254 nd2094 nd2095 2.654372658145e-01
RINT24255 nd2095 nd2096 1.680354650659e-01
RINT24256 nd2096 nd2097 2.913644572433e+00
RINT24257 nd2097 nd2098 2.866536769726e+00
RINT24258 nd2098 nd2099 2.072195255224e-01
RINT24259 nd2099 nd2100 2.072195255224e-01
RINT24260 nd2100 nd2101 2.072195255224e-01
RINT24261 nd2101 nd2102 2.072195255224e-01
RINT24262 nd2102 nd2103 2.072195255224e-01
RINT24263 nd2103 nd2104 2.072195255224e-01
RINT24264 nd2104 nd2105 2.072195255224e-01
RINT24265 nd2105 nd2106 2.072195255224e-01
RINT24266 nd2106 nd2107 2.072195255224e-01
RINT24267 nd2108 nd2109 1.914284617627e-01
RINT24268 nd2109 nd2110 1.740035002137e-01
RINT24269 nd2110 nd2111 5.881581083666e+00
RINT24270 nd2111 nd2112 5.981136757300e+00
RINT24271 nd2112 nd2113 3.668883239623e-01
RINT24272 nd2113 nd2114 3.606618004430e-01
RINT24273 nd2114 nd2115 1.976741618838e-01
RINT24274 nd2115 nd2116 8.656063970738e-02
RINT24275 nd2116 nd2117 1.760179307529e-01
RINT24276 nd2117 nd2118 2.136011054157e-01
RINT24277 nd2118 nd2119 2.136011054157e-01
RINT24278 nd2119 nd2120 2.136011054157e-01
RINT24279 nd2120 nd2121 2.136011054157e-01
RINT24280 nd2121 nd2122 2.136011054157e-01
RINT24281 nd2122 nd2123 2.136011054157e-01
RINT24282 nd2123 nd2124 2.884961700761e-01
RINT24283 nd2124 nd2125 4.298149835847e-01
RINT24284 nd2125 nd2126 2.654372658145e-01
RINT24285 nd2126 nd2127 1.680354650659e-01
RINT24286 nd2127 nd2128 2.913644572433e+00
RINT24287 nd2128 nd2129 2.866536769726e+00
RINT24288 nd2129 nd2130 2.072195255224e-01
RINT24289 nd2130 nd2131 2.072195255224e-01
RINT24290 nd2131 nd2132 2.072195255224e-01
RINT24291 nd2132 nd2133 2.072195255224e-01
RINT24292 nd2133 nd2134 2.072195255224e-01
RINT24293 nd2134 nd2135 2.072195255224e-01
RINT24294 nd2135 nd2136 2.072195255224e-01
RINT24295 nd2136 nd2137 2.072195255224e-01
RINT24296 nd2137 nd2138 2.072195255224e-01
RINT24297 nd2139 nd2140 1.914284617627e-01
RINT24298 nd2140 nd2141 1.740035002137e-01
RINT24299 nd2141 nd2142 5.881581083666e+00
RINT24300 nd2142 nd2143 5.981136757300e+00
RINT24301 nd2143 nd2144 3.668883239623e-01
RINT24302 nd2144 nd2145 3.606618004430e-01
RINT24303 nd2145 nd2146 1.976741618838e-01
RINT24304 nd2146 nd2147 8.656063970738e-02
RINT24305 nd2147 nd2148 1.760179307529e-01
RINT24306 nd2148 nd2149 2.136011054157e-01
RINT24307 nd2149 nd2150 2.136011054157e-01
RINT24308 nd2150 nd2151 2.136011054157e-01
RINT24309 nd2151 nd2152 2.136011054157e-01
RINT24310 nd2152 nd2153 2.136011054157e-01
RINT24311 nd2153 nd2154 2.136011054157e-01
RINT24312 nd2154 nd2155 2.884961700761e-01
RINT24313 nd2155 nd2156 4.298149835847e-01
RINT24314 nd2156 nd2157 2.654372658145e-01
RINT24315 nd2157 nd2158 1.680354650659e-01
RINT24316 nd2158 nd2159 2.913644572433e+00
RINT24317 nd2159 nd2160 2.866536769726e+00
RINT24318 nd2160 nd2161 2.072195255224e-01
RINT24319 nd2161 nd2162 2.072195255224e-01
RINT24320 nd2162 nd2163 2.072195255224e-01
RINT24321 nd2163 nd2164 2.072195255224e-01
RINT24322 nd2164 nd2165 2.072195255224e-01
RINT24323 nd2165 nd2166 2.072195255224e-01
RINT24324 nd2166 nd2167 2.072195255224e-01
RINT24325 nd2167 nd2168 2.072195255224e-01
RINT24326 nd2168 nd2169 2.072195255224e-01
RINT24327 nd2170 nd2171 1.914284617627e-01
RINT24328 nd2171 nd2172 1.740035002137e-01
RINT24329 nd2172 nd2173 5.881581083666e+00
RINT24330 nd2173 nd2174 5.981136757300e+00
RINT24331 nd2174 nd2175 3.668883239623e-01
RINT24332 nd2175 nd2176 3.606618004430e-01
RINT24333 nd2176 nd2177 1.976741618838e-01
RINT24334 nd2177 nd2178 8.656063970739e-02
RINT24335 nd2178 nd2179 1.760179307529e-01
RINT24336 nd2179 nd2180 2.136011054157e-01
RINT24337 nd2180 nd2181 2.136011054157e-01
RINT24338 nd2181 nd2182 2.136011054157e-01
RINT24339 nd2182 nd2183 2.136011054157e-01
RINT24340 nd2183 nd2184 2.136011054157e-01
RINT24341 nd2184 nd2185 2.136011054157e-01
RINT24342 nd2185 nd2186 2.884961700761e-01
RINT24343 nd2186 nd2187 4.298149835847e-01
RINT24344 nd2187 nd2188 2.654372658145e-01
RINT24345 nd2188 nd2189 1.680354650659e-01
RINT24346 nd2189 nd2190 2.913644572433e+00
RINT24347 nd2190 nd2191 2.866536769726e+00
RINT24348 nd2191 nd2192 2.072195255224e-01
RINT24349 nd2192 nd2193 2.072195255224e-01
RINT24350 nd2193 nd2194 2.072195255224e-01
RINT24351 nd2194 nd2195 2.072195255224e-01
RINT24352 nd2195 nd2196 2.072195255224e-01
RINT24353 nd2196 nd2197 2.072195255224e-01
RINT24354 nd2197 nd2198 2.072195255224e-01
RINT24355 nd2198 nd2199 2.072195255224e-01
RINT24356 nd2199 nd2200 2.072195255224e-01
RINT24357 nd2201 nd2202 1.914284617627e-01
RINT24358 nd2202 nd2203 1.740035002137e-01
RINT24359 nd2203 nd2204 5.881581083666e+00
RINT24360 nd2204 nd2205 5.981136757300e+00
RINT24361 nd2205 nd2206 3.668883239623e-01
RINT24362 nd2206 nd2207 3.606618004430e-01
RINT24363 nd2207 nd2208 1.976741618838e-01
RINT24364 nd2208 nd2209 8.656063970738e-02
RINT24365 nd2209 nd2210 1.760179307529e-01
RINT24366 nd2210 nd2211 2.136011054157e-01
RINT24367 nd2211 nd2212 2.136011054157e-01
RINT24368 nd2212 nd2213 2.136011054157e-01
RINT24369 nd2213 nd2214 2.136011054157e-01
RINT24370 nd2214 nd2215 2.136011054157e-01
RINT24371 nd2215 nd2216 2.136011054157e-01
RINT24372 nd2216 nd2217 2.884961700761e-01
RINT24373 nd2217 nd2218 4.298149835847e-01
RINT24374 nd2218 nd2219 2.654372658145e-01
RINT24375 nd2219 nd2220 1.680354650659e-01
RINT24376 nd2220 nd2221 2.913644572433e+00
RINT24377 nd2221 nd2222 2.866536769726e+00
RINT24378 nd2222 nd2223 2.072195255224e-01
RINT24379 nd2223 nd2224 2.072195255224e-01
RINT24380 nd2224 nd2225 2.072195255224e-01
RINT24381 nd2225 nd2226 2.072195255224e-01
RINT24382 nd2226 nd2227 2.072195255224e-01
RINT24383 nd2227 nd2228 2.072195255224e-01
RINT24384 nd2228 nd2229 2.072195255224e-01
RINT24385 nd2229 nd2230 2.072195255224e-01
RINT24386 nd2230 nd2231 2.072195255224e-01
RINT24387 nd2232 nd2233 1.914284617627e-01
RINT24388 nd2233 nd2234 1.740035002137e-01
RINT24389 nd2234 nd2235 5.881581083666e+00
RINT24390 nd2235 nd2236 5.981136757300e+00
RINT24391 nd2236 nd2237 3.668883239623e-01
RINT24392 nd2237 nd2238 3.606618004430e-01
RINT24393 nd2238 nd2239 1.976741618838e-01
RINT24394 nd2239 nd2240 8.656063970738e-02
RINT24395 nd2240 nd2241 1.760179307529e-01
RINT24396 nd2241 nd2242 2.136011054157e-01
RINT24397 nd2242 nd2243 2.136011054157e-01
RINT24398 nd2243 nd2244 2.136011054157e-01
RINT24399 nd2244 nd2245 2.136011054157e-01
RINT24400 nd2245 nd2246 2.136011054157e-01
RINT24401 nd2246 nd2247 2.136011054157e-01
RINT24402 nd2247 nd2248 2.884961700761e-01
RINT24403 nd2248 nd2249 4.298149835847e-01
RINT24404 nd2249 nd2250 2.654372658145e-01
RINT24405 nd2250 nd2251 1.680354650659e-01
RINT24406 nd2251 nd2252 2.913644572433e+00
RINT24407 nd2252 nd2253 2.866536769726e+00
RINT24408 nd2253 nd2254 2.072195255224e-01
RINT24409 nd2254 nd2255 2.072195255224e-01
RINT24410 nd2255 nd2256 2.072195255224e-01
RINT24411 nd2256 nd2257 2.072195255224e-01
RINT24412 nd2257 nd2258 2.072195255224e-01
RINT24413 nd2258 nd2259 2.072195255224e-01
RINT24414 nd2259 nd2260 2.072195255224e-01
RINT24415 nd2260 nd2261 2.072195255224e-01
RINT24416 nd2261 nd2262 2.072195255224e-01
RINT24417 nd2263 nd2264 1.832876633312e+00
RINT24418 nd2264 nd2265 1.666037258616e+00
RINT24419 nd2265 nd2266 5.631457535579e+01
RINT24420 nd2266 nd2267 5.726779446562e+01
RINT24421 nd2267 nd2268 3.512858170793e+00
RINT24422 nd2268 nd2269 3.453240863313e+00
RINT24423 nd2269 nd2270 9.993586560904e+00
RINT24424 nd2270 nd2271 5.786876290473e+01
RINT24425 nd2271 nd2272 7.853617822785e+01
RINT24426 nd2272 nd2273 5.786876290473e+01
RINT24427 nd2273 nd2274 5.786876290473e+01
RINT24428 nd2274 nd2275 5.786876290473e+01
RINT24429 nd2275 nd2276 5.786876290473e+01
RINT24430 nd2276 nd2277 5.786876290473e+01
RINT24431 nd2277 nd2278 5.786876290473e+01
RINT24432 nd2278 nd2279 1.591390979880e+02
RINT24433 nd2279 nd2280 2.604094330713e+02
RINT24434 nd2280 nd2281 1.303705308206e+02
RINT24435 nd2281 nd2282 1.608894908578e+00
RINT24436 nd2282 nd2283 2.789737223720e+01
RINT24437 nd2283 nd2284 2.744632754910e+01
RINT24438 nd2284 nd2285 1.984071871019e+00
RINT24439 nd2285 nd2286 1.984071871019e+00
RINT24440 nd2286 nd2287 1.984071871019e+00
RINT24441 nd2287 nd2288 1.984071871019e+00
RINT24442 nd2288 nd2289 1.984071871019e+00
RINT24443 nd2289 nd2290 1.984071871019e+00
RINT24444 nd2290 nd2291 1.984071871019e+00
RINT24445 nd2291 nd2292 1.984071871019e+00
RINT24446 nd2292 nd2293 1.984071871019e+00
RINT24447 nd2294 nd2295 1.914284617627e-01
RINT24448 nd2295 nd2296 1.740035002137e-01
RINT24449 nd2296 nd2297 5.881581083666e+00
RINT24450 nd2297 nd2298 5.981136757300e+00
RINT24451 nd2298 nd2299 3.668883239623e-01
RINT24452 nd2299 nd2300 3.606618004430e-01
RINT24453 nd2300 nd2301 1.976741618838e-01
RINT24454 nd2301 nd2302 8.656063970739e-02
RINT24455 nd2302 nd2303 1.760179307529e-01
RINT24456 nd2303 nd2304 2.136011054157e-01
RINT24457 nd2304 nd2305 2.136011054157e-01
RINT24458 nd2305 nd2306 2.136011054157e-01
RINT24459 nd2306 nd2307 2.136011054157e-01
RINT24460 nd2307 nd2308 2.136011054157e-01
RINT24461 nd2308 nd2309 2.136011054157e-01
RINT24462 nd2309 nd2310 2.884961700761e-01
RINT24463 nd2310 nd2311 4.298149835847e-01
RINT24464 nd2311 nd2312 2.654372658145e-01
RINT24465 nd2312 nd2313 1.680354650659e-01
RINT24466 nd2313 nd2314 2.913644572433e+00
RINT24467 nd2314 nd2315 2.866536769726e+00
RINT24468 nd2315 nd2316 2.072195255224e-01
RINT24469 nd2316 nd2317 2.072195255224e-01
RINT24470 nd2317 nd2318 2.072195255224e-01
RINT24471 nd2318 nd2319 2.072195255224e-01
RINT24472 nd2319 nd2320 2.072195255224e-01
RINT24473 nd2320 nd2321 2.072195255224e-01
RINT24474 nd2321 nd2322 2.072195255224e-01
RINT24475 nd2322 nd2323 2.072195255224e-01
RINT24476 nd2323 nd2324 2.072195255224e-01
RINT24477 nd2325 nd2326 1.914284617627e-01
RINT24478 nd2326 nd2327 1.740035002137e-01
RINT24479 nd2327 nd2328 5.881581083666e+00
RINT24480 nd2328 nd2329 5.981136757300e+00
RINT24481 nd2329 nd2330 3.668883239623e-01
RINT24482 nd2330 nd2331 3.606618004430e-01
RINT24483 nd2331 nd2332 1.976741618838e-01
RINT24484 nd2332 nd2333 8.656063970738e-02
RINT24485 nd2333 nd2334 1.760179307529e-01
RINT24486 nd2334 nd2335 2.136011054157e-01
RINT24487 nd2335 nd2336 2.136011054157e-01
RINT24488 nd2336 nd2337 2.136011054157e-01
RINT24489 nd2337 nd2338 2.136011054157e-01
RINT24490 nd2338 nd2339 2.136011054157e-01
RINT24491 nd2339 nd2340 2.136011054157e-01
RINT24492 nd2340 nd2341 2.884961700761e-01
RINT24493 nd2341 nd2342 4.298149835847e-01
RINT24494 nd2342 nd2343 2.654372658145e-01
RINT24495 nd2343 nd2344 1.680354650659e-01
RINT24496 nd2344 nd2345 2.913644572433e+00
RINT24497 nd2345 nd2346 2.866536769726e+00
RINT24498 nd2346 nd2347 2.072195255224e-01
RINT24499 nd2347 nd2348 2.072195255224e-01
RINT24500 nd2348 nd2349 2.072195255224e-01
RINT24501 nd2349 nd2350 2.072195255224e-01
RINT24502 nd2350 nd2351 2.072195255224e-01
RINT24503 nd2351 nd2352 2.072195255224e-01
RINT24504 nd2352 nd2353 2.072195255224e-01
RINT24505 nd2353 nd2354 2.072195255224e-01
RINT24506 nd2354 nd2355 2.072195255224e-01
RINT24507 nd2356 nd2357 1.914284617627e-01
RINT24508 nd2357 nd2358 1.740035002137e-01
RINT24509 nd2358 nd2359 5.881581083666e+00
RINT24510 nd2359 nd2360 5.981136757300e+00
RINT24511 nd2360 nd2361 3.668883239623e-01
RINT24512 nd2361 nd2362 3.606618004430e-01
RINT24513 nd2362 nd2363 1.976741618838e-01
RINT24514 nd2363 nd2364 8.656063970739e-02
RINT24515 nd2364 nd2365 1.760179307529e-01
RINT24516 nd2365 nd2366 2.136011054157e-01
RINT24517 nd2366 nd2367 2.136011054157e-01
RINT24518 nd2367 nd2368 2.136011054157e-01
RINT24519 nd2368 nd2369 2.136011054157e-01
RINT24520 nd2369 nd2370 2.136011054157e-01
RINT24521 nd2370 nd2371 2.136011054157e-01
RINT24522 nd2371 nd2372 2.884961700761e-01
RINT24523 nd2372 nd2373 4.298149835847e-01
RINT24524 nd2373 nd2374 2.654372658145e-01
RINT24525 nd2374 nd2375 1.680354650659e-01
RINT24526 nd2375 nd2376 2.913644572433e+00
RINT24527 nd2376 nd2377 2.866536769726e+00
RINT24528 nd2377 nd2378 2.072195255224e-01
RINT24529 nd2378 nd2379 2.072195255224e-01
RINT24530 nd2379 nd2380 2.072195255224e-01
RINT24531 nd2380 nd2381 2.072195255224e-01
RINT24532 nd2381 nd2382 2.072195255224e-01
RINT24533 nd2382 nd2383 2.072195255224e-01
RINT24534 nd2383 nd2384 2.072195255224e-01
RINT24535 nd2384 nd2385 2.072195255224e-01
RINT24536 nd2385 nd2386 2.072195255224e-01
RINT24537 nd2387 nd2388 1.914284617627e-01
RINT24538 nd2388 nd2389 1.740035002137e-01
RINT24539 nd2389 nd2390 5.881581083666e+00
RINT24540 nd2390 nd2391 5.981136757300e+00
RINT24541 nd2391 nd2392 3.668883239623e-01
RINT24542 nd2392 nd2393 3.606618004430e-01
RINT24543 nd2393 nd2394 1.976741618838e-01
RINT24544 nd2394 nd2395 8.656063970739e-02
RINT24545 nd2395 nd2396 1.760179307529e-01
RINT24546 nd2396 nd2397 2.136011054157e-01
RINT24547 nd2397 nd2398 2.136011054157e-01
RINT24548 nd2398 nd2399 2.136011054157e-01
RINT24549 nd2399 nd2400 2.136011054157e-01
RINT24550 nd2400 nd2401 2.136011054157e-01
RINT24551 nd2401 nd2402 2.136011054157e-01
RINT24552 nd2402 nd2403 2.884961700761e-01
RINT24553 nd2403 nd2404 4.298149835847e-01
RINT24554 nd2404 nd2405 2.654372658145e-01
RINT24555 nd2405 nd2406 1.680354650659e-01
RINT24556 nd2406 nd2407 2.913644572433e+00
RINT24557 nd2407 nd2408 2.866536769726e+00
RINT24558 nd2408 nd2409 2.072195255224e-01
RINT24559 nd2409 nd2410 2.072195255224e-01
RINT24560 nd2410 nd2411 2.072195255224e-01
RINT24561 nd2411 nd2412 2.072195255224e-01
RINT24562 nd2412 nd2413 2.072195255224e-01
RINT24563 nd2413 nd2414 2.072195255224e-01
RINT24564 nd2414 nd2415 2.072195255224e-01
RINT24565 nd2415 nd2416 2.072195255224e-01
RINT24566 nd2416 nd2417 2.072195255224e-01
RINT24567 nd2418 nd2419 1.914284617627e-01
RINT24568 nd2419 nd2420 1.740035002137e-01
RINT24569 nd2420 nd2421 5.881581083666e+00
RINT24570 nd2421 nd2422 5.981136757300e+00
RINT24571 nd2422 nd2423 3.668883239623e-01
RINT24572 nd2423 nd2424 3.606618004430e-01
RINT24573 nd2424 nd2425 1.976741618838e-01
RINT24574 nd2425 nd2426 8.656063970738e-02
RINT24575 nd2426 nd2427 1.760179307529e-01
RINT24576 nd2427 nd2428 2.136011054157e-01
RINT24577 nd2428 nd2429 2.136011054157e-01
RINT24578 nd2429 nd2430 2.136011054157e-01
RINT24579 nd2430 nd2431 2.136011054157e-01
RINT24580 nd2431 nd2432 2.136011054157e-01
RINT24581 nd2432 nd2433 2.136011054157e-01
RINT24582 nd2433 nd2434 2.884961700761e-01
RINT24583 nd2434 nd2435 4.298149835847e-01
RINT24584 nd2435 nd2436 2.654372658145e-01
RINT24585 nd2436 nd2437 1.680354650659e-01
RINT24586 nd2437 nd2438 2.913644572433e+00
RINT24587 nd2438 nd2439 2.866536769726e+00
RINT24588 nd2439 nd2440 2.072195255224e-01
RINT24589 nd2440 nd2441 2.072195255224e-01
RINT24590 nd2441 nd2442 2.072195255224e-01
RINT24591 nd2442 nd2443 2.072195255224e-01
RINT24592 nd2443 nd2444 2.072195255224e-01
RINT24593 nd2444 nd2445 2.072195255224e-01
RINT24594 nd2445 nd2446 2.072195255224e-01
RINT24595 nd2446 nd2447 2.072195255224e-01
RINT24596 nd2447 nd2448 2.072195255224e-01
RINT24597 nd2449 nd2450 1.914284617627e-01
RINT24598 nd2450 nd2451 1.740035002137e-01
RINT24599 nd2451 nd2452 5.881581083666e+00
RINT24600 nd2452 nd2453 5.981136757300e+00
RINT24601 nd2453 nd2454 3.668883239623e-01
RINT24602 nd2454 nd2455 3.606618004430e-01
RINT24603 nd2455 nd2456 1.976741618838e-01
RINT24604 nd2456 nd2457 8.656063970739e-02
RINT24605 nd2457 nd2458 1.760179307529e-01
RINT24606 nd2458 nd2459 2.136011054157e-01
RINT24607 nd2459 nd2460 2.136011054157e-01
RINT24608 nd2460 nd2461 2.136011054157e-01
RINT24609 nd2461 nd2462 2.136011054157e-01
RINT24610 nd2462 nd2463 2.136011054157e-01
RINT24611 nd2463 nd2464 2.136011054157e-01
RINT24612 nd2464 nd2465 2.884961700761e-01
RINT24613 nd2465 nd2466 4.298149835847e-01
RINT24614 nd2466 nd2467 2.654372658145e-01
RINT24615 nd2467 nd2468 1.680354650659e-01
RINT24616 nd2468 nd2469 2.913644572433e+00
RINT24617 nd2469 nd2470 2.866536769726e+00
RINT24618 nd2470 nd2471 2.072195255224e-01
RINT24619 nd2471 nd2472 2.072195255224e-01
RINT24620 nd2472 nd2473 2.072195255224e-01
RINT24621 nd2473 nd2474 2.072195255224e-01
RINT24622 nd2474 nd2475 2.072195255224e-01
RINT24623 nd2475 nd2476 2.072195255224e-01
RINT24624 nd2476 nd2477 2.072195255224e-01
RINT24625 nd2477 nd2478 2.072195255224e-01
RINT24626 nd2478 nd2479 2.072195255224e-01
RINT24627 nd2480 nd2481 1.832876633312e+00
RINT24628 nd2481 nd2482 1.666037258616e+00
RINT24629 nd2482 nd2483 5.631457535579e+01
RINT24630 nd2483 nd2484 5.726779446562e+01
RINT24631 nd2484 nd2485 3.512858170793e+00
RINT24632 nd2485 nd2486 3.453240863313e+00
RINT24633 nd2486 nd2487 9.993586560904e+00
RINT24634 nd2487 nd2488 5.786876290473e+01
RINT24635 nd2488 nd2489 7.853617822785e+01
RINT24636 nd2489 nd2490 5.786876290473e+01
RINT24637 nd2490 nd2491 5.786876290473e+01
RINT24638 nd2491 nd2492 5.786876290473e+01
RINT24639 nd2492 nd2493 5.786876290473e+01
RINT24640 nd2493 nd2494 5.786876290473e+01
RINT24641 nd2494 nd2495 5.786876290473e+01
RINT24642 nd2495 nd2496 1.591390979880e+02
RINT24643 nd2496 nd2497 2.604094330713e+02
RINT24644 nd2497 nd2498 1.303705308206e+02
RINT24645 nd2498 nd2499 1.608894908578e+00
RINT24646 nd2499 nd2500 2.789737223720e+01
RINT24647 nd2500 nd2501 2.744632754910e+01
RINT24648 nd2501 nd2502 1.984071871019e+00
RINT24649 nd2502 nd2503 1.984071871019e+00
RINT24650 nd2503 nd2504 1.984071871019e+00
RINT24651 nd2504 nd2505 1.984071871019e+00
RINT24652 nd2505 nd2506 1.984071871019e+00
RINT24653 nd2506 nd2507 1.984071871019e+00
RINT24654 nd2507 nd2508 1.984071871019e+00
RINT24655 nd2508 nd2509 1.984071871019e+00
RINT24656 nd2509 nd2510 1.984071871019e+00
RINT24657 nd2511 nd2512 2.493313941068e-01
RINT24658 nd2512 nd2513 2.266357619356e-01
RINT24659 nd2513 nd2514 7.660631014006e+00
RINT24660 nd2514 nd2515 7.790300106417e+00
RINT24661 nd2515 nd2516 4.778640357485e-01
RINT24662 nd2516 nd2517 4.697541247393e-01
RINT24663 nd2517 nd2518 2.520135011038e-01
RINT24664 nd2518 nd2519 1.199550711388e-01
RINT24665 nd2519 nd2520 1.627961679741e-01
RINT24666 nd2520 nd2521 1.199550711388e-01
RINT24667 nd2521 nd2522 1.199550711388e-01
RINT24668 nd2522 nd2523 1.199550711388e-01
RINT24669 nd2523 nd2524 1.199550711388e-01
RINT24670 nd2524 nd2525 1.199550711388e-01
RINT24671 nd2525 nd2526 1.199550711388e-01
RINT24672 nd2526 nd2527 3.298764456317e-01
RINT24673 nd2527 nd2528 5.397978201245e-01
RINT24674 nd2528 nd2529 2.924550963786e-01
RINT24675 nd2529 nd2530 2.188625263897e-01
RINT24676 nd2530 nd2531 3.794958474237e+00
RINT24677 nd2531 nd2532 3.733601589195e+00
RINT24678 nd2532 nd2533 2.698989100623e-01
RINT24679 nd2533 nd2534 2.698989100623e-01
RINT24680 nd2534 nd2535 2.698989100623e-01
RINT24681 nd2535 nd2536 2.698989100623e-01
RINT24682 nd2536 nd2537 2.698989100623e-01
RINT24683 nd2537 nd2538 2.698989100623e-01
RINT24684 nd2538 nd2539 2.698989100623e-01
RINT24685 nd2539 nd2540 2.698989100623e-01
RINT24686 nd2540 nd2541 2.698989100623e-01
RINT24687 nd2542 nd2543 2.493313941068e-01
RINT24688 nd2543 nd2544 2.266357619356e-01
RINT24689 nd2544 nd2545 7.660631014006e+00
RINT24690 nd2545 nd2546 7.790300106417e+00
RINT24691 nd2546 nd2547 4.778640357485e-01
RINT24692 nd2547 nd2548 4.697541247393e-01
RINT24693 nd2548 nd2549 2.520135011038e-01
RINT24694 nd2549 nd2550 1.199550711388e-01
RINT24695 nd2550 nd2551 1.627961679741e-01
RINT24696 nd2551 nd2552 1.199550711388e-01
RINT24697 nd2552 nd2553 1.199550711388e-01
RINT24698 nd2553 nd2554 1.199550711388e-01
RINT24699 nd2554 nd2555 1.199550711388e-01
RINT24700 nd2555 nd2556 1.199550711388e-01
RINT24701 nd2556 nd2557 1.199550711388e-01
RINT24702 nd2557 nd2558 3.298764456317e-01
RINT24703 nd2558 nd2559 5.397978201245e-01
RINT24704 nd2559 nd2560 2.924550963786e-01
RINT24705 nd2560 nd2561 2.188625263897e-01
RINT24706 nd2561 nd2562 3.794958474237e+00
RINT24707 nd2562 nd2563 3.733601589195e+00
RINT24708 nd2563 nd2564 2.698989100623e-01
RINT24709 nd2564 nd2565 2.698989100623e-01
RINT24710 nd2565 nd2566 2.698989100623e-01
RINT24711 nd2566 nd2567 2.698989100623e-01
RINT24712 nd2567 nd2568 2.698989100623e-01
RINT24713 nd2568 nd2569 2.698989100623e-01
RINT24714 nd2569 nd2570 2.698989100623e-01
RINT24715 nd2570 nd2571 2.698989100623e-01
RINT24716 nd2571 nd2572 2.698989100623e-01
RINT24717 nd2573 nd2574 2.493313941068e-01
RINT24718 nd2574 nd2575 2.266357619356e-01
RINT24719 nd2575 nd2576 7.660631014006e+00
RINT24720 nd2576 nd2577 7.790300106417e+00
RINT24721 nd2577 nd2578 4.778640357485e-01
RINT24722 nd2578 nd2579 4.697541247393e-01
RINT24723 nd2579 nd2580 2.520135011038e-01
RINT24724 nd2580 nd2581 1.199550711388e-01
RINT24725 nd2581 nd2582 1.627961679741e-01
RINT24726 nd2582 nd2583 1.199550711388e-01
RINT24727 nd2583 nd2584 1.199550711388e-01
RINT24728 nd2584 nd2585 1.199550711388e-01
RINT24729 nd2585 nd2586 1.199550711388e-01
RINT24730 nd2586 nd2587 1.199550711388e-01
RINT24731 nd2587 nd2588 1.199550711388e-01
RINT24732 nd2588 nd2589 3.298764456317e-01
RINT24733 nd2589 nd2590 5.397978201245e-01
RINT24734 nd2590 nd2591 2.924550963786e-01
RINT24735 nd2591 nd2592 2.188625263897e-01
RINT24736 nd2592 nd2593 3.794958474237e+00
RINT24737 nd2593 nd2594 3.733601589195e+00
RINT24738 nd2594 nd2595 2.698989100623e-01
RINT24739 nd2595 nd2596 2.698989100623e-01
RINT24740 nd2596 nd2597 2.698989100623e-01
RINT24741 nd2597 nd2598 2.698989100623e-01
RINT24742 nd2598 nd2599 2.698989100623e-01
RINT24743 nd2599 nd2600 2.698989100623e-01
RINT24744 nd2600 nd2601 2.698989100623e-01
RINT24745 nd2601 nd2602 2.698989100623e-01
RINT24746 nd2602 nd2603 2.698989100623e-01
RINT24747 nd2604 nd2605 2.493313941068e-01
RINT24748 nd2605 nd2606 2.266357619356e-01
RINT24749 nd2606 nd2607 7.660631014006e+00
RINT24750 nd2607 nd2608 7.790300106417e+00
RINT24751 nd2608 nd2609 4.778640357485e-01
RINT24752 nd2609 nd2610 4.697541247393e-01
RINT24753 nd2610 nd2611 2.520135011038e-01
RINT24754 nd2611 nd2612 1.199550711388e-01
RINT24755 nd2612 nd2613 1.627961679741e-01
RINT24756 nd2613 nd2614 1.199550711388e-01
RINT24757 nd2614 nd2615 1.199550711388e-01
RINT24758 nd2615 nd2616 1.199550711388e-01
RINT24759 nd2616 nd2617 1.199550711388e-01
RINT24760 nd2617 nd2618 1.199550711388e-01
RINT24761 nd2618 nd2619 1.199550711388e-01
RINT24762 nd2619 nd2620 3.298764456317e-01
RINT24763 nd2620 nd2621 5.397978201245e-01
RINT24764 nd2621 nd2622 2.924550963786e-01
RINT24765 nd2622 nd2623 2.188625263897e-01
RINT24766 nd2623 nd2624 3.794958474237e+00
RINT24767 nd2624 nd2625 3.733601589195e+00
RINT24768 nd2625 nd2626 2.698989100623e-01
RINT24769 nd2626 nd2627 2.698989100623e-01
RINT24770 nd2627 nd2628 2.698989100623e-01
RINT24771 nd2628 nd2629 2.698989100623e-01
RINT24772 nd2629 nd2630 2.698989100623e-01
RINT24773 nd2630 nd2631 2.698989100623e-01
RINT24774 nd2631 nd2632 2.698989100623e-01
RINT24775 nd2632 nd2633 2.698989100623e-01
RINT24776 nd2633 nd2634 2.698989100623e-01
RINT24777 nd2635 nd2636 2.493313941068e-01
RINT24778 nd2636 nd2637 2.266357619356e-01
RINT24779 nd2637 nd2638 7.660631014006e+00
RINT24780 nd2638 nd2639 7.790300106417e+00
RINT24781 nd2639 nd2640 4.778640357485e-01
RINT24782 nd2640 nd2641 4.697541247393e-01
RINT24783 nd2641 nd2642 2.520135011038e-01
RINT24784 nd2642 nd2643 1.199550711388e-01
RINT24785 nd2643 nd2644 1.627961679741e-01
RINT24786 nd2644 nd2645 1.199550711388e-01
RINT24787 nd2645 nd2646 1.199550711388e-01
RINT24788 nd2646 nd2647 1.199550711388e-01
RINT24789 nd2647 nd2648 1.199550711388e-01
RINT24790 nd2648 nd2649 1.199550711388e-01
RINT24791 nd2649 nd2650 1.199550711388e-01
RINT24792 nd2650 nd2651 3.298764456317e-01
RINT24793 nd2651 nd2652 5.397978201245e-01
RINT24794 nd2652 nd2653 2.924550963786e-01
RINT24795 nd2653 nd2654 2.188625263897e-01
RINT24796 nd2654 nd2655 3.794958474237e+00
RINT24797 nd2655 nd2656 3.733601589195e+00
RINT24798 nd2656 nd2657 2.698989100623e-01
RINT24799 nd2657 nd2658 2.698989100623e-01
RINT24800 nd2658 nd2659 2.698989100623e-01
RINT24801 nd2659 nd2660 2.698989100623e-01
RINT24802 nd2660 nd2661 2.698989100623e-01
RINT24803 nd2661 nd2662 2.698989100623e-01
RINT24804 nd2662 nd2663 2.698989100623e-01
RINT24805 nd2663 nd2664 2.698989100623e-01
RINT24806 nd2664 nd2665 2.698989100623e-01
RINT24807 nd2666 nd2667 2.493313941068e-01
RINT24808 nd2667 nd2668 2.266357619356e-01
RINT24809 nd2668 nd2669 7.660631014006e+00
RINT24810 nd2669 nd2670 7.790300106417e+00
RINT24811 nd2670 nd2671 4.778640357485e-01
RINT24812 nd2671 nd2672 4.697541247393e-01
RINT24813 nd2672 nd2673 2.520135011038e-01
RINT24814 nd2673 nd2674 1.199550711388e-01
RINT24815 nd2674 nd2675 1.627961679741e-01
RINT24816 nd2675 nd2676 1.199550711388e-01
RINT24817 nd2676 nd2677 1.199550711388e-01
RINT24818 nd2677 nd2678 1.199550711388e-01
RINT24819 nd2678 nd2679 1.199550711388e-01
RINT24820 nd2679 nd2680 1.199550711388e-01
RINT24821 nd2680 nd2681 1.199550711388e-01
RINT24822 nd2681 nd2682 3.298764456317e-01
RINT24823 nd2682 nd2683 5.397978201245e-01
RINT24824 nd2683 nd2684 2.924550963786e-01
RINT24825 nd2684 nd2685 2.188625263897e-01
RINT24826 nd2685 nd2686 3.794958474237e+00
RINT24827 nd2686 nd2687 3.733601589195e+00
RINT24828 nd2687 nd2688 2.698989100623e-01
RINT24829 nd2688 nd2689 2.698989100623e-01
RINT24830 nd2689 nd2690 2.698989100623e-01
RINT24831 nd2690 nd2691 2.698989100623e-01
RINT24832 nd2691 nd2692 2.698989100623e-01
RINT24833 nd2692 nd2693 2.698989100623e-01
RINT24834 nd2693 nd2694 2.698989100623e-01
RINT24835 nd2694 nd2695 2.698989100623e-01
RINT24836 nd2695 nd2696 2.698989100623e-01
RINT24837 nd2697 nd2698 1.832876633312e+00
RINT24838 nd2698 nd2699 1.666037258616e+00
RINT24839 nd2699 nd2700 5.631457535580e+01
RINT24840 nd2700 nd2701 5.726779446562e+01
RINT24841 nd2701 nd2702 3.512858170793e+00
RINT24842 nd2702 nd2703 3.453240863313e+00
RINT24843 nd2703 nd2704 9.993586560904e+00
RINT24844 nd2704 nd2705 5.786876290473e+01
RINT24845 nd2705 nd2706 7.853617822785e+01
RINT24846 nd2706 nd2707 5.786876290473e+01
RINT24847 nd2707 nd2708 5.786876290473e+01
RINT24848 nd2708 nd2709 5.786876290473e+01
RINT24849 nd2709 nd2710 5.786876290473e+01
RINT24850 nd2710 nd2711 5.786876290473e+01
RINT24851 nd2711 nd2712 5.786876290473e+01
RINT24852 nd2712 nd2713 1.591390979880e+02
RINT24853 nd2713 nd2714 2.604094330713e+02
RINT24854 nd2714 nd2715 1.303705308206e+02
RINT24855 nd2715 nd2716 1.608894908578e+00
RINT24856 nd2716 nd2717 2.789737223720e+01
RINT24857 nd2717 nd2718 2.744632754910e+01
RINT24858 nd2718 nd2719 1.984071871019e+00
RINT24859 nd2719 nd2720 1.984071871019e+00
RINT24860 nd2720 nd2721 1.984071871019e+00
RINT24861 nd2721 nd2722 1.984071871019e+00
RINT24862 nd2722 nd2723 1.984071871019e+00
RINT24863 nd2723 nd2724 1.984071871019e+00
RINT24864 nd2724 nd2725 1.984071871019e+00
RINT24865 nd2725 nd2726 1.984071871019e+00
RINT24866 nd2726 nd2727 1.984071871019e+00
RINT24867 nd2728 nd2729 1.914284617627e-01
RINT24868 nd2729 nd2730 1.740035002137e-01
RINT24869 nd2730 nd2731 5.881581083666e+00
RINT24870 nd2731 nd2732 5.981136757300e+00
RINT24871 nd2732 nd2733 3.668883239623e-01
RINT24872 nd2733 nd2734 3.606618004430e-01
RINT24873 nd2734 nd2735 1.976741618838e-01
RINT24874 nd2735 nd2736 8.656063970738e-02
RINT24875 nd2736 nd2737 1.760179307529e-01
RINT24876 nd2737 nd2738 2.136011054157e-01
RINT24877 nd2738 nd2739 2.136011054157e-01
RINT24878 nd2739 nd2740 2.136011054157e-01
RINT24879 nd2740 nd2741 2.136011054157e-01
RINT24880 nd2741 nd2742 2.136011054157e-01
RINT24881 nd2742 nd2743 2.136011054157e-01
RINT24882 nd2743 nd2744 2.884961700761e-01
RINT24883 nd2744 nd2745 4.298149835847e-01
RINT24884 nd2745 nd2746 2.654372658145e-01
RINT24885 nd2746 nd2747 1.680354650659e-01
RINT24886 nd2747 nd2748 2.913644572433e+00
RINT24887 nd2748 nd2749 2.866536769726e+00
RINT24888 nd2749 nd2750 2.072195255224e-01
RINT24889 nd2750 nd2751 2.072195255224e-01
RINT24890 nd2751 nd2752 2.072195255224e-01
RINT24891 nd2752 nd2753 2.072195255224e-01
RINT24892 nd2753 nd2754 2.072195255224e-01
RINT24893 nd2754 nd2755 2.072195255224e-01
RINT24894 nd2755 nd2756 2.072195255224e-01
RINT24895 nd2756 nd2757 2.072195255224e-01
RINT24896 nd2757 nd2758 2.072195255224e-01
RINT24897 nd2759 nd2760 1.914284617627e-01
RINT24898 nd2760 nd2761 1.740035002137e-01
RINT24899 nd2761 nd2762 5.881581083666e+00
RINT24900 nd2762 nd2763 5.981136757300e+00
RINT24901 nd2763 nd2764 3.668883239623e-01
RINT24902 nd2764 nd2765 3.606618004430e-01
RINT24903 nd2765 nd2766 1.976741618838e-01
RINT24904 nd2766 nd2767 8.656063970738e-02
RINT24905 nd2767 nd2768 1.760179307529e-01
RINT24906 nd2768 nd2769 2.136011054157e-01
RINT24907 nd2769 nd2770 2.136011054157e-01
RINT24908 nd2770 nd2771 2.136011054157e-01
RINT24909 nd2771 nd2772 2.136011054157e-01
RINT24910 nd2772 nd2773 2.136011054157e-01
RINT24911 nd2773 nd2774 2.136011054157e-01
RINT24912 nd2774 nd2775 2.884961700761e-01
RINT24913 nd2775 nd2776 4.298149835847e-01
RINT24914 nd2776 nd2777 2.654372658145e-01
RINT24915 nd2777 nd2778 1.680354650659e-01
RINT24916 nd2778 nd2779 2.913644572433e+00
RINT24917 nd2779 nd2780 2.866536769726e+00
RINT24918 nd2780 nd2781 2.072195255224e-01
RINT24919 nd2781 nd2782 2.072195255224e-01
RINT24920 nd2782 nd2783 2.072195255224e-01
RINT24921 nd2783 nd2784 2.072195255224e-01
RINT24922 nd2784 nd2785 2.072195255224e-01
RINT24923 nd2785 nd2786 2.072195255224e-01
RINT24924 nd2786 nd2787 2.072195255224e-01
RINT24925 nd2787 nd2788 2.072195255224e-01
RINT24926 nd2788 nd2789 2.072195255224e-01
RINT24927 nd2790 nd2791 1.914284617627e-01
RINT24928 nd2791 nd2792 1.740035002137e-01
RINT24929 nd2792 nd2793 5.881581083666e+00
RINT24930 nd2793 nd2794 5.981136757300e+00
RINT24931 nd2794 nd2795 3.668883239623e-01
RINT24932 nd2795 nd2796 3.606618004430e-01
RINT24933 nd2796 nd2797 1.976741618838e-01
RINT24934 nd2797 nd2798 8.656063970738e-02
RINT24935 nd2798 nd2799 1.760179307529e-01
RINT24936 nd2799 nd2800 2.136011054157e-01
RINT24937 nd2800 nd2801 2.136011054157e-01
RINT24938 nd2801 nd2802 2.136011054157e-01
RINT24939 nd2802 nd2803 2.136011054157e-01
RINT24940 nd2803 nd2804 2.136011054157e-01
RINT24941 nd2804 nd2805 2.136011054157e-01
RINT24942 nd2805 nd2806 2.884961700761e-01
RINT24943 nd2806 nd2807 4.298149835847e-01
RINT24944 nd2807 nd2808 2.654372658145e-01
RINT24945 nd2808 nd2809 1.680354650659e-01
RINT24946 nd2809 nd2810 2.913644572433e+00
RINT24947 nd2810 nd2811 2.866536769726e+00
RINT24948 nd2811 nd2812 2.072195255224e-01
RINT24949 nd2812 nd2813 2.072195255224e-01
RINT24950 nd2813 nd2814 2.072195255224e-01
RINT24951 nd2814 nd2815 2.072195255224e-01
RINT24952 nd2815 nd2816 2.072195255224e-01
RINT24953 nd2816 nd2817 2.072195255224e-01
RINT24954 nd2817 nd2818 2.072195255224e-01
RINT24955 nd2818 nd2819 2.072195255224e-01
RINT24956 nd2819 nd2820 2.072195255224e-01
RINT24957 nd2821 nd2822 1.914284617627e-01
RINT24958 nd2822 nd2823 1.740035002137e-01
RINT24959 nd2823 nd2824 5.881581083666e+00
RINT24960 nd2824 nd2825 5.981136757300e+00
RINT24961 nd2825 nd2826 3.668883239623e-01
RINT24962 nd2826 nd2827 3.606618004430e-01
RINT24963 nd2827 nd2828 1.976741618838e-01
RINT24964 nd2828 nd2829 8.656063970739e-02
RINT24965 nd2829 nd2830 1.760179307529e-01
RINT24966 nd2830 nd2831 2.136011054157e-01
RINT24967 nd2831 nd2832 2.136011054157e-01
RINT24968 nd2832 nd2833 2.136011054157e-01
RINT24969 nd2833 nd2834 2.136011054157e-01
RINT24970 nd2834 nd2835 2.136011054157e-01
RINT24971 nd2835 nd2836 2.136011054157e-01
RINT24972 nd2836 nd2837 2.884961700761e-01
RINT24973 nd2837 nd2838 4.298149835847e-01
RINT24974 nd2838 nd2839 2.654372658145e-01
RINT24975 nd2839 nd2840 1.680354650659e-01
RINT24976 nd2840 nd2841 2.913644572433e+00
RINT24977 nd2841 nd2842 2.866536769726e+00
RINT24978 nd2842 nd2843 2.072195255224e-01
RINT24979 nd2843 nd2844 2.072195255224e-01
RINT24980 nd2844 nd2845 2.072195255224e-01
RINT24981 nd2845 nd2846 2.072195255224e-01
RINT24982 nd2846 nd2847 2.072195255224e-01
RINT24983 nd2847 nd2848 2.072195255224e-01
RINT24984 nd2848 nd2849 2.072195255224e-01
RINT24985 nd2849 nd2850 2.072195255224e-01
RINT24986 nd2850 nd2851 2.072195255224e-01
RINT24987 nd2852 nd2853 1.914284617627e-01
RINT24988 nd2853 nd2854 1.740035002137e-01
RINT24989 nd2854 nd2855 5.881581083666e+00
RINT24990 nd2855 nd2856 5.981136757300e+00
RINT24991 nd2856 nd2857 3.668883239623e-01
RINT24992 nd2857 nd2858 3.606618004430e-01
RINT24993 nd2858 nd2859 1.976741618838e-01
RINT24994 nd2859 nd2860 8.656063970738e-02
RINT24995 nd2860 nd2861 1.760179307529e-01
RINT24996 nd2861 nd2862 2.136011054157e-01
RINT24997 nd2862 nd2863 2.136011054157e-01
RINT24998 nd2863 nd2864 2.136011054157e-01
RINT24999 nd2864 nd2865 2.136011054157e-01
RINT25000 nd2865 nd2866 2.136011054157e-01
RINT25001 nd2866 nd2867 2.136011054157e-01
RINT25002 nd2867 nd2868 2.884961700761e-01
RINT25003 nd2868 nd2869 4.298149835847e-01
RINT25004 nd2869 nd2870 2.654372658145e-01
RINT25005 nd2870 nd2871 1.680354650659e-01
RINT25006 nd2871 nd2872 2.913644572433e+00
RINT25007 nd2872 nd2873 2.866536769726e+00
RINT25008 nd2873 nd2874 2.072195255224e-01
RINT25009 nd2874 nd2875 2.072195255224e-01
RINT25010 nd2875 nd2876 2.072195255224e-01
RINT25011 nd2876 nd2877 2.072195255224e-01
RINT25012 nd2877 nd2878 2.072195255224e-01
RINT25013 nd2878 nd2879 2.072195255224e-01
RINT25014 nd2879 nd2880 2.072195255224e-01
RINT25015 nd2880 nd2881 2.072195255224e-01
RINT25016 nd2881 nd2882 2.072195255224e-01
RINT25017 nd2883 nd2884 1.914284617627e-01
RINT25018 nd2884 nd2885 1.740035002137e-01
RINT25019 nd2885 nd2886 5.881581083666e+00
RINT25020 nd2886 nd2887 5.981136757300e+00
RINT25021 nd2887 nd2888 3.668883239623e-01
RINT25022 nd2888 nd2889 3.606618004430e-01
RINT25023 nd2889 nd2890 1.976741618838e-01
RINT25024 nd2890 nd2891 8.656063970738e-02
RINT25025 nd2891 nd2892 1.760179307529e-01
RINT25026 nd2892 nd2893 2.136011054157e-01
RINT25027 nd2893 nd2894 2.136011054157e-01
RINT25028 nd2894 nd2895 2.136011054157e-01
RINT25029 nd2895 nd2896 2.136011054157e-01
RINT25030 nd2896 nd2897 2.136011054157e-01
RINT25031 nd2897 nd2898 2.136011054157e-01
RINT25032 nd2898 nd2899 2.884961700761e-01
RINT25033 nd2899 nd2900 4.298149835847e-01
RINT25034 nd2900 nd2901 2.654372658145e-01
RINT25035 nd2901 nd2902 1.680354650659e-01
RINT25036 nd2902 nd2903 2.913644572433e+00
RINT25037 nd2903 nd2904 2.866536769726e+00
RINT25038 nd2904 nd2905 2.072195255224e-01
RINT25039 nd2905 nd2906 2.072195255224e-01
RINT25040 nd2906 nd2907 2.072195255224e-01
RINT25041 nd2907 nd2908 2.072195255224e-01
RINT25042 nd2908 nd2909 2.072195255224e-01
RINT25043 nd2909 nd2910 2.072195255224e-01
RINT25044 nd2910 nd2911 2.072195255224e-01
RINT25045 nd2911 nd2912 2.072195255224e-01
RINT25046 nd2912 nd2913 2.072195255224e-01
RINT25047 nd2914 nd2915 1.832876633312e+00
RINT25048 nd2915 nd2916 1.666037258616e+00
RINT25049 nd2916 nd2917 5.631457535579e+01
RINT25050 nd2917 nd2918 5.726779446562e+01
RINT25051 nd2918 nd2919 3.512858170793e+00
RINT25052 nd2919 nd2920 3.453240863313e+00
RINT25053 nd2920 nd2921 9.993586560904e+00
RINT25054 nd2921 nd2922 5.786876290473e+01
RINT25055 nd2922 nd2923 7.853617822785e+01
RINT25056 nd2923 nd2924 5.786876290473e+01
RINT25057 nd2924 nd2925 5.786876290473e+01
RINT25058 nd2925 nd2926 5.786876290473e+01
RINT25059 nd2926 nd2927 5.786876290473e+01
RINT25060 nd2927 nd2928 5.786876290473e+01
RINT25061 nd2928 nd2929 5.786876290473e+01
RINT25062 nd2929 nd2930 1.591390979880e+02
RINT25063 nd2930 nd2931 2.604094330713e+02
RINT25064 nd2931 nd2932 1.303705308206e+02
RINT25065 nd2932 nd2933 1.608894908578e+00
RINT25066 nd2933 nd2934 2.789737223720e+01
RINT25067 nd2934 nd2935 2.744632754910e+01
RINT25068 nd2935 nd2936 1.984071871019e+00
RINT25069 nd2936 nd2937 1.984071871019e+00
RINT25070 nd2937 nd2938 1.984071871019e+00
RINT25071 nd2938 nd2939 1.984071871019e+00
RINT25072 nd2939 nd2940 1.984071871019e+00
RINT25073 nd2940 nd2941 1.984071871019e+00
RINT25074 nd2941 nd2942 1.984071871019e+00
RINT25075 nd2942 nd2943 1.984071871019e+00
RINT25076 nd2943 nd2944 1.984071871019e+00
RINT25077 nd2945 nd2946 1.914284617627e-01
RINT25078 nd2946 nd2947 1.740035002137e-01
RINT25079 nd2947 nd2948 5.881581083666e+00
RINT25080 nd2948 nd2949 5.981136757300e+00
RINT25081 nd2949 nd2950 3.668883239623e-01
RINT25082 nd2950 nd2951 3.606618004430e-01
RINT25083 nd2951 nd2952 1.976741618838e-01
RINT25084 nd2952 nd2953 8.656063970739e-02
RINT25085 nd2953 nd2954 1.760179307529e-01
RINT25086 nd2954 nd2955 2.136011054157e-01
RINT25087 nd2955 nd2956 2.136011054157e-01
RINT25088 nd2956 nd2957 2.136011054157e-01
RINT25089 nd2957 nd2958 2.136011054157e-01
RINT25090 nd2958 nd2959 2.136011054157e-01
RINT25091 nd2959 nd2960 2.136011054157e-01
RINT25092 nd2960 nd2961 2.884961700761e-01
RINT25093 nd2961 nd2962 4.298149835847e-01
RINT25094 nd2962 nd2963 2.654372658145e-01
RINT25095 nd2963 nd2964 1.680354650659e-01
RINT25096 nd2964 nd2965 2.913644572433e+00
RINT25097 nd2965 nd2966 2.866536769726e+00
RINT25098 nd2966 nd2967 2.072195255224e-01
RINT25099 nd2967 nd2968 2.072195255224e-01
RINT25100 nd2968 nd2969 2.072195255224e-01
RINT25101 nd2969 nd2970 2.072195255224e-01
RINT25102 nd2970 nd2971 2.072195255224e-01
RINT25103 nd2971 nd2972 2.072195255224e-01
RINT25104 nd2972 nd2973 2.072195255224e-01
RINT25105 nd2973 nd2974 2.072195255224e-01
RINT25106 nd2974 nd2975 2.072195255224e-01
RINT25107 nd2976 nd2977 1.914284617627e-01
RINT25108 nd2977 nd2978 1.740035002137e-01
RINT25109 nd2978 nd2979 5.881581083666e+00
RINT25110 nd2979 nd2980 5.981136757300e+00
RINT25111 nd2980 nd2981 3.668883239623e-01
RINT25112 nd2981 nd2982 3.606618004430e-01
RINT25113 nd2982 nd2983 1.976741618838e-01
RINT25114 nd2983 nd2984 8.656063970738e-02
RINT25115 nd2984 nd2985 1.760179307529e-01
RINT25116 nd2985 nd2986 2.136011054157e-01
RINT25117 nd2986 nd2987 2.136011054157e-01
RINT25118 nd2987 nd2988 2.136011054157e-01
RINT25119 nd2988 nd2989 2.136011054157e-01
RINT25120 nd2989 nd2990 2.136011054157e-01
RINT25121 nd2990 nd2991 2.136011054157e-01
RINT25122 nd2991 nd2992 2.884961700761e-01
RINT25123 nd2992 nd2993 4.298149835847e-01
RINT25124 nd2993 nd2994 2.654372658145e-01
RINT25125 nd2994 nd2995 1.680354650659e-01
RINT25126 nd2995 nd2996 2.913644572433e+00
RINT25127 nd2996 nd2997 2.866536769726e+00
RINT25128 nd2997 nd2998 2.072195255224e-01
RINT25129 nd2998 nd2999 2.072195255224e-01
RINT25130 nd2999 nd3000 2.072195255224e-01
RINT25131 nd3000 nd3001 2.072195255224e-01
RINT25132 nd3001 nd3002 2.072195255224e-01
RINT25133 nd3002 nd3003 2.072195255224e-01
RINT25134 nd3003 nd3004 2.072195255224e-01
RINT25135 nd3004 nd3005 2.072195255224e-01
RINT25136 nd3005 nd3006 2.072195255224e-01
RINT25137 nd3007 nd3008 1.914284617627e-01
RINT25138 nd3008 nd3009 1.740035002137e-01
RINT25139 nd3009 nd3010 5.881581083666e+00
RINT25140 nd3010 nd3011 5.981136757300e+00
RINT25141 nd3011 nd3012 3.668883239623e-01
RINT25142 nd3012 nd3013 3.606618004430e-01
RINT25143 nd3013 nd3014 1.976741618838e-01
RINT25144 nd3014 nd3015 8.656063970739e-02
RINT25145 nd3015 nd3016 1.760179307529e-01
RINT25146 nd3016 nd3017 2.136011054157e-01
RINT25147 nd3017 nd3018 2.136011054157e-01
RINT25148 nd3018 nd3019 2.136011054157e-01
RINT25149 nd3019 nd3020 2.136011054157e-01
RINT25150 nd3020 nd3021 2.136011054157e-01
RINT25151 nd3021 nd3022 2.136011054157e-01
RINT25152 nd3022 nd3023 2.884961700761e-01
RINT25153 nd3023 nd3024 4.298149835847e-01
RINT25154 nd3024 nd3025 2.654372658145e-01
RINT25155 nd3025 nd3026 1.680354650659e-01
RINT25156 nd3026 nd3027 2.913644572433e+00
RINT25157 nd3027 nd3028 2.866536769726e+00
RINT25158 nd3028 nd3029 2.072195255224e-01
RINT25159 nd3029 nd3030 2.072195255224e-01
RINT25160 nd3030 nd3031 2.072195255224e-01
RINT25161 nd3031 nd3032 2.072195255224e-01
RINT25162 nd3032 nd3033 2.072195255224e-01
RINT25163 nd3033 nd3034 2.072195255224e-01
RINT25164 nd3034 nd3035 2.072195255224e-01
RINT25165 nd3035 nd3036 2.072195255224e-01
RINT25166 nd3036 nd3037 2.072195255224e-01
RINT25167 nd3038 nd3039 1.914284617627e-01
RINT25168 nd3039 nd3040 1.740035002137e-01
RINT25169 nd3040 nd3041 5.881581083666e+00
RINT25170 nd3041 nd3042 5.981136757300e+00
RINT25171 nd3042 nd3043 3.668883239623e-01
RINT25172 nd3043 nd3044 3.606618004430e-01
RINT25173 nd3044 nd3045 1.976741618838e-01
RINT25174 nd3045 nd3046 8.656063970739e-02
RINT25175 nd3046 nd3047 1.760179307529e-01
RINT25176 nd3047 nd3048 2.136011054157e-01
RINT25177 nd3048 nd3049 2.136011054157e-01
RINT25178 nd3049 nd3050 2.136011054157e-01
RINT25179 nd3050 nd3051 2.136011054157e-01
RINT25180 nd3051 nd3052 2.136011054157e-01
RINT25181 nd3052 nd3053 2.136011054157e-01
RINT25182 nd3053 nd3054 2.884961700761e-01
RINT25183 nd3054 nd3055 4.298149835847e-01
RINT25184 nd3055 nd3056 2.654372658145e-01
RINT25185 nd3056 nd3057 1.680354650659e-01
RINT25186 nd3057 nd3058 2.913644572433e+00
RINT25187 nd3058 nd3059 2.866536769726e+00
RINT25188 nd3059 nd3060 2.072195255224e-01
RINT25189 nd3060 nd3061 2.072195255224e-01
RINT25190 nd3061 nd3062 2.072195255224e-01
RINT25191 nd3062 nd3063 2.072195255224e-01
RINT25192 nd3063 nd3064 2.072195255224e-01
RINT25193 nd3064 nd3065 2.072195255224e-01
RINT25194 nd3065 nd3066 2.072195255224e-01
RINT25195 nd3066 nd3067 2.072195255224e-01
RINT25196 nd3067 nd3068 2.072195255224e-01
RINT25197 nd3069 nd3070 1.914284617627e-01
RINT25198 nd3070 nd3071 1.740035002137e-01
RINT25199 nd3071 nd3072 5.881581083666e+00
RINT25200 nd3072 nd3073 5.981136757300e+00
RINT25201 nd3073 nd3074 3.668883239623e-01
RINT25202 nd3074 nd3075 3.606618004430e-01
RINT25203 nd3075 nd3076 1.976741618838e-01
RINT25204 nd3076 nd3077 8.656063970738e-02
RINT25205 nd3077 nd3078 1.760179307529e-01
RINT25206 nd3078 nd3079 2.136011054157e-01
RINT25207 nd3079 nd3080 2.136011054157e-01
RINT25208 nd3080 nd3081 2.136011054157e-01
RINT25209 nd3081 nd3082 2.136011054157e-01
RINT25210 nd3082 nd3083 2.136011054157e-01
RINT25211 nd3083 nd3084 2.136011054157e-01
RINT25212 nd3084 nd3085 2.884961700761e-01
RINT25213 nd3085 nd3086 4.298149835847e-01
RINT25214 nd3086 nd3087 2.654372658145e-01
RINT25215 nd3087 nd3088 1.680354650659e-01
RINT25216 nd3088 nd3089 2.913644572433e+00
RINT25217 nd3089 nd3090 2.866536769726e+00
RINT25218 nd3090 nd3091 2.072195255224e-01
RINT25219 nd3091 nd3092 2.072195255224e-01
RINT25220 nd3092 nd3093 2.072195255224e-01
RINT25221 nd3093 nd3094 2.072195255224e-01
RINT25222 nd3094 nd3095 2.072195255224e-01
RINT25223 nd3095 nd3096 2.072195255224e-01
RINT25224 nd3096 nd3097 2.072195255224e-01
RINT25225 nd3097 nd3098 2.072195255224e-01
RINT25226 nd3098 nd3099 2.072195255224e-01
RINT25227 nd3100 nd3101 1.914284617627e-01
RINT25228 nd3101 nd3102 1.740035002137e-01
RINT25229 nd3102 nd3103 5.881581083666e+00
RINT25230 nd3103 nd3104 5.981136757300e+00
RINT25231 nd3104 nd3105 3.668883239623e-01
RINT25232 nd3105 nd3106 3.606618004430e-01
RINT25233 nd3106 nd3107 1.976741618838e-01
RINT25234 nd3107 nd3108 8.656063970739e-02
RINT25235 nd3108 nd3109 1.760179307529e-01
RINT25236 nd3109 nd3110 2.136011054157e-01
RINT25237 nd3110 nd3111 2.136011054157e-01
RINT25238 nd3111 nd3112 2.136011054157e-01
RINT25239 nd3112 nd3113 2.136011054157e-01
RINT25240 nd3113 nd3114 2.136011054157e-01
RINT25241 nd3114 nd3115 2.136011054157e-01
RINT25242 nd3115 nd3116 2.884961700761e-01
RINT25243 nd3116 nd3117 4.298149835847e-01
RINT25244 nd3117 nd3118 2.654372658145e-01
RINT25245 nd3118 nd3119 1.680354650659e-01
RINT25246 nd3119 nd3120 2.913644572433e+00
RINT25247 nd3120 nd3121 2.866536769726e+00
RINT25248 nd3121 nd3122 2.072195255224e-01
RINT25249 nd3122 nd3123 2.072195255224e-01
RINT25250 nd3123 nd3124 2.072195255224e-01
RINT25251 nd3124 nd3125 2.072195255224e-01
RINT25252 nd3125 nd3126 2.072195255224e-01
RINT25253 nd3126 nd3127 2.072195255224e-01
RINT25254 nd3127 nd3128 2.072195255224e-01
RINT25255 nd3128 nd3129 2.072195255224e-01
RINT25256 nd3129 nd3130 2.072195255224e-01
RINT25257 nd3131 nd3132 1.832876633312e+00
RINT25258 nd3132 nd3133 1.666037258616e+00
RINT25259 nd3133 nd3134 5.631457535579e+01
RINT25260 nd3134 nd3135 5.726779446562e+01
RINT25261 nd3135 nd3136 3.512858170793e+00
RINT25262 nd3136 nd3137 3.453240863313e+00
RINT25263 nd3137 nd3138 9.993586560904e+00
RINT25264 nd3138 nd3139 5.786876290473e+01
RINT25265 nd3139 nd3140 7.853617822785e+01
RINT25266 nd3140 nd3141 5.786876290473e+01
RINT25267 nd3141 nd3142 5.786876290473e+01
RINT25268 nd3142 nd3143 5.786876290473e+01
RINT25269 nd3143 nd3144 5.786876290473e+01
RINT25270 nd3144 nd3145 5.786876290473e+01
RINT25271 nd3145 nd3146 5.786876290473e+01
RINT25272 nd3146 nd3147 1.591390979880e+02
RINT25273 nd3147 nd3148 2.604094330713e+02
RINT25274 nd3148 nd3149 1.303705308206e+02
RINT25275 nd3149 nd3150 1.608894908578e+00
RINT25276 nd3150 nd3151 2.789737223720e+01
RINT25277 nd3151 nd3152 2.744632754910e+01
RINT25278 nd3152 nd3153 1.984071871019e+00
RINT25279 nd3153 nd3154 1.984071871019e+00
RINT25280 nd3154 nd3155 1.984071871019e+00
RINT25281 nd3155 nd3156 1.984071871019e+00
RINT25282 nd3156 nd3157 1.984071871019e+00
RINT25283 nd3157 nd3158 1.984071871019e+00
RINT25284 nd3158 nd3159 1.984071871019e+00
RINT25285 nd3159 nd3160 1.984071871019e+00
RINT25286 nd3160 nd3161 1.984071871019e+00
RINT25287 nd3162 nd3163 2.493313941068e-01
RINT25288 nd3163 nd3164 2.266357619356e-01
RINT25289 nd3164 nd3165 7.660631014006e+00
RINT25290 nd3165 nd3166 7.790300106417e+00
RINT25291 nd3166 nd3167 4.778640357485e-01
RINT25292 nd3167 nd3168 4.697541247393e-01
RINT25293 nd3168 nd3169 2.520135011038e-01
RINT25294 nd3169 nd3170 1.199550711388e-01
RINT25295 nd3170 nd3171 1.627961679741e-01
RINT25296 nd3171 nd3172 1.199550711388e-01
RINT25297 nd3172 nd3173 1.199550711388e-01
RINT25298 nd3173 nd3174 1.199550711388e-01
RINT25299 nd3174 nd3175 1.199550711388e-01
RINT25300 nd3175 nd3176 1.199550711388e-01
RINT25301 nd3176 nd3177 1.199550711388e-01
RINT25302 nd3177 nd3178 3.298764456317e-01
RINT25303 nd3178 nd3179 5.397978201245e-01
RINT25304 nd3179 nd3180 2.924550963786e-01
RINT25305 nd3180 nd3181 2.188625263897e-01
RINT25306 nd3181 nd3182 3.794958474237e+00
RINT25307 nd3182 nd3183 3.733601589195e+00
RINT25308 nd3183 nd3184 2.698989100623e-01
RINT25309 nd3184 nd3185 2.698989100623e-01
RINT25310 nd3185 nd3186 2.698989100623e-01
RINT25311 nd3186 nd3187 2.698989100623e-01
RINT25312 nd3187 nd3188 2.698989100623e-01
RINT25313 nd3188 nd3189 2.698989100623e-01
RINT25314 nd3189 nd3190 2.698989100623e-01
RINT25315 nd3190 nd3191 2.698989100623e-01
RINT25316 nd3191 nd3192 2.698989100623e-01
RINT25317 nd3193 nd3194 2.493313941068e-01
RINT25318 nd3194 nd3195 2.266357619356e-01
RINT25319 nd3195 nd3196 7.660631014006e+00
RINT25320 nd3196 nd3197 7.790300106417e+00
RINT25321 nd3197 nd3198 4.778640357485e-01
RINT25322 nd3198 nd3199 4.697541247393e-01
RINT25323 nd3199 nd3200 2.520135011038e-01
RINT25324 nd3200 nd3201 1.199550711388e-01
RINT25325 nd3201 nd3202 1.627961679741e-01
RINT25326 nd3202 nd3203 1.199550711388e-01
RINT25327 nd3203 nd3204 1.199550711388e-01
RINT25328 nd3204 nd3205 1.199550711388e-01
RINT25329 nd3205 nd3206 1.199550711388e-01
RINT25330 nd3206 nd3207 1.199550711388e-01
RINT25331 nd3207 nd3208 1.199550711388e-01
RINT25332 nd3208 nd3209 3.298764456317e-01
RINT25333 nd3209 nd3210 5.397978201245e-01
RINT25334 nd3210 nd3211 2.924550963786e-01
RINT25335 nd3211 nd3212 2.188625263897e-01
RINT25336 nd3212 nd3213 3.794958474237e+00
RINT25337 nd3213 nd3214 3.733601589195e+00
RINT25338 nd3214 nd3215 2.698989100623e-01
RINT25339 nd3215 nd3216 2.698989100623e-01
RINT25340 nd3216 nd3217 2.698989100623e-01
RINT25341 nd3217 nd3218 2.698989100623e-01
RINT25342 nd3218 nd3219 2.698989100623e-01
RINT25343 nd3219 nd3220 2.698989100623e-01
RINT25344 nd3220 nd3221 2.698989100623e-01
RINT25345 nd3221 nd3222 2.698989100623e-01
RINT25346 nd3222 nd3223 2.698989100623e-01
RINT25347 nd3224 nd3225 2.493313941068e-01
RINT25348 nd3225 nd3226 2.266357619356e-01
RINT25349 nd3226 nd3227 7.660631014006e+00
RINT25350 nd3227 nd3228 7.790300106417e+00
RINT25351 nd3228 nd3229 4.778640357485e-01
RINT25352 nd3229 nd3230 4.697541247393e-01
RINT25353 nd3230 nd3231 2.520135011038e-01
RINT25354 nd3231 nd3232 1.199550711388e-01
RINT25355 nd3232 nd3233 1.627961679741e-01
RINT25356 nd3233 nd3234 1.199550711388e-01
RINT25357 nd3234 nd3235 1.199550711388e-01
RINT25358 nd3235 nd3236 1.199550711388e-01
RINT25359 nd3236 nd3237 1.199550711388e-01
RINT25360 nd3237 nd3238 1.199550711388e-01
RINT25361 nd3238 nd3239 1.199550711388e-01
RINT25362 nd3239 nd3240 3.298764456317e-01
RINT25363 nd3240 nd3241 5.397978201245e-01
RINT25364 nd3241 nd3242 2.924550963786e-01
RINT25365 nd3242 nd3243 2.188625263897e-01
RINT25366 nd3243 nd3244 3.794958474237e+00
RINT25367 nd3244 nd3245 3.733601589195e+00
RINT25368 nd3245 nd3246 2.698989100623e-01
RINT25369 nd3246 nd3247 2.698989100623e-01
RINT25370 nd3247 nd3248 2.698989100623e-01
RINT25371 nd3248 nd3249 2.698989100623e-01
RINT25372 nd3249 nd3250 2.698989100623e-01
RINT25373 nd3250 nd3251 2.698989100623e-01
RINT25374 nd3251 nd3252 2.698989100623e-01
RINT25375 nd3252 nd3253 2.698989100623e-01
RINT25376 nd3253 nd3254 2.698989100623e-01
RINT25377 nd3255 nd3256 2.493313941068e-01
RINT25378 nd3256 nd3257 2.266357619356e-01
RINT25379 nd3257 nd3258 7.660631014006e+00
RINT25380 nd3258 nd3259 7.790300106417e+00
RINT25381 nd3259 nd3260 4.778640357485e-01
RINT25382 nd3260 nd3261 4.697541247393e-01
RINT25383 nd3261 nd3262 2.520135011038e-01
RINT25384 nd3262 nd3263 1.199550711388e-01
RINT25385 nd3263 nd3264 1.627961679741e-01
RINT25386 nd3264 nd3265 1.199550711388e-01
RINT25387 nd3265 nd3266 1.199550711388e-01
RINT25388 nd3266 nd3267 1.199550711388e-01
RINT25389 nd3267 nd3268 1.199550711388e-01
RINT25390 nd3268 nd3269 1.199550711388e-01
RINT25391 nd3269 nd3270 1.199550711388e-01
RINT25392 nd3270 nd3271 3.298764456317e-01
RINT25393 nd3271 nd3272 5.397978201245e-01
RINT25394 nd3272 nd3273 2.924550963786e-01
RINT25395 nd3273 nd3274 2.188625263897e-01
RINT25396 nd3274 nd3275 3.794958474237e+00
RINT25397 nd3275 nd3276 3.733601589195e+00
RINT25398 nd3276 nd3277 2.698989100623e-01
RINT25399 nd3277 nd3278 2.698989100623e-01
RINT25400 nd3278 nd3279 2.698989100623e-01
RINT25401 nd3279 nd3280 2.698989100623e-01
RINT25402 nd3280 nd3281 2.698989100623e-01
RINT25403 nd3281 nd3282 2.698989100623e-01
RINT25404 nd3282 nd3283 2.698989100623e-01
RINT25405 nd3283 nd3284 2.698989100623e-01
RINT25406 nd3284 nd3285 2.698989100623e-01
RINT25407 nd3286 nd3287 2.493313941068e-01
RINT25408 nd3287 nd3288 2.266357619356e-01
RINT25409 nd3288 nd3289 7.660631014006e+00
RINT25410 nd3289 nd3290 7.790300106417e+00
RINT25411 nd3290 nd3291 4.778640357485e-01
RINT25412 nd3291 nd3292 4.697541247393e-01
RINT25413 nd3292 nd3293 2.520135011038e-01
RINT25414 nd3293 nd3294 1.199550711388e-01
RINT25415 nd3294 nd3295 1.627961679741e-01
RINT25416 nd3295 nd3296 1.199550711388e-01
RINT25417 nd3296 nd3297 1.199550711388e-01
RINT25418 nd3297 nd3298 1.199550711388e-01
RINT25419 nd3298 nd3299 1.199550711388e-01
RINT25420 nd3299 nd3300 1.199550711388e-01
RINT25421 nd3300 nd3301 1.199550711388e-01
RINT25422 nd3301 nd3302 3.298764456317e-01
RINT25423 nd3302 nd3303 5.397978201245e-01
RINT25424 nd3303 nd3304 2.924550963786e-01
RINT25425 nd3304 nd3305 2.188625263897e-01
RINT25426 nd3305 nd3306 3.794958474237e+00
RINT25427 nd3306 nd3307 3.733601589195e+00
RINT25428 nd3307 nd3308 2.698989100623e-01
RINT25429 nd3308 nd3309 2.698989100623e-01
RINT25430 nd3309 nd3310 2.698989100623e-01
RINT25431 nd3310 nd3311 2.698989100623e-01
RINT25432 nd3311 nd3312 2.698989100623e-01
RINT25433 nd3312 nd3313 2.698989100623e-01
RINT25434 nd3313 nd3314 2.698989100623e-01
RINT25435 nd3314 nd3315 2.698989100623e-01
RINT25436 nd3315 nd3316 2.698989100623e-01
RINT25437 nd3317 nd3318 2.493313941068e-01
RINT25438 nd3318 nd3319 2.266357619356e-01
RINT25439 nd3319 nd3320 7.660631014006e+00
RINT25440 nd3320 nd3321 7.790300106417e+00
RINT25441 nd3321 nd3322 4.778640357485e-01
RINT25442 nd3322 nd3323 4.697541247393e-01
RINT25443 nd3323 nd3324 2.520135011038e-01
RINT25444 nd3324 nd3325 1.199550711388e-01
RINT25445 nd3325 nd3326 1.627961679741e-01
RINT25446 nd3326 nd3327 1.199550711388e-01
RINT25447 nd3327 nd3328 1.199550711388e-01
RINT25448 nd3328 nd3329 1.199550711388e-01
RINT25449 nd3329 nd3330 1.199550711388e-01
RINT25450 nd3330 nd3331 1.199550711388e-01
RINT25451 nd3331 nd3332 1.199550711388e-01
RINT25452 nd3332 nd3333 3.298764456317e-01
RINT25453 nd3333 nd3334 5.397978201245e-01
RINT25454 nd3334 nd3335 2.924550963786e-01
RINT25455 nd3335 nd3336 2.188625263897e-01
RINT25456 nd3336 nd3337 3.794958474237e+00
RINT25457 nd3337 nd3338 3.733601589195e+00
RINT25458 nd3338 nd3339 2.698989100623e-01
RINT25459 nd3339 nd3340 2.698989100623e-01
RINT25460 nd3340 nd3341 2.698989100623e-01
RINT25461 nd3341 nd3342 2.698989100623e-01
RINT25462 nd3342 nd3343 2.698989100623e-01
RINT25463 nd3343 nd3344 2.698989100623e-01
RINT25464 nd3344 nd3345 2.698989100623e-01
RINT25465 nd3345 nd3346 2.698989100623e-01
RINT25466 nd3346 nd3347 2.698989100623e-01
RINT25467 nd3348 nd3349 1.832876633312e+00
RINT25468 nd3349 nd3350 1.666037258616e+00
RINT25469 nd3350 nd3351 5.631457535580e+01
RINT25470 nd3351 nd3352 5.726779446562e+01
RINT25471 nd3352 nd3353 3.512858170793e+00
RINT25472 nd3353 nd3354 3.453240863313e+00
RINT25473 nd3354 nd3355 9.993586560904e+00
RINT25474 nd3355 nd3356 5.786876290473e+01
RINT25475 nd3356 nd3357 7.853617822785e+01
RINT25476 nd3357 nd3358 5.786876290473e+01
RINT25477 nd3358 nd3359 5.786876290473e+01
RINT25478 nd3359 nd3360 5.786876290473e+01
RINT25479 nd3360 nd3361 5.786876290473e+01
RINT25480 nd3361 nd3362 5.786876290473e+01
RINT25481 nd3362 nd3363 5.786876290473e+01
RINT25482 nd3363 nd3364 1.591390979880e+02
RINT25483 nd3364 nd3365 2.604094330713e+02
RINT25484 nd3365 nd3366 1.303705308206e+02
RINT25485 nd3366 nd3367 1.608894908578e+00
RINT25486 nd3367 nd3368 2.789737223720e+01
RINT25487 nd3368 nd3369 2.744632754910e+01
RINT25488 nd3369 nd3370 1.984071871019e+00
RINT25489 nd3370 nd3371 1.984071871019e+00
RINT25490 nd3371 nd3372 1.984071871019e+00
RINT25491 nd3372 nd3373 1.984071871019e+00
RINT25492 nd3373 nd3374 1.984071871019e+00
RINT25493 nd3374 nd3375 1.984071871019e+00
RINT25494 nd3375 nd3376 1.984071871019e+00
RINT25495 nd3376 nd3377 1.984071871019e+00
RINT25496 nd3377 nd3378 1.984071871019e+00
RINT25497 nd3379 nd3380 1.914284617627e-01
RINT25498 nd3380 nd3381 1.740035002137e-01
RINT25499 nd3381 nd3382 5.881581083666e+00
RINT25500 nd3382 nd3383 5.981136757300e+00
RINT25501 nd3383 nd3384 3.668883239623e-01
RINT25502 nd3384 nd3385 3.606618004430e-01
RINT25503 nd3385 nd3386 1.976741618838e-01
RINT25504 nd3386 nd3387 8.656063970738e-02
RINT25505 nd3387 nd3388 1.760179307529e-01
RINT25506 nd3388 nd3389 2.136011054157e-01
RINT25507 nd3389 nd3390 2.136011054157e-01
RINT25508 nd3390 nd3391 2.136011054157e-01
RINT25509 nd3391 nd3392 2.136011054157e-01
RINT25510 nd3392 nd3393 2.136011054157e-01
RINT25511 nd3393 nd3394 2.136011054157e-01
RINT25512 nd3394 nd3395 2.884961700761e-01
RINT25513 nd3395 nd3396 4.298149835847e-01
RINT25514 nd3396 nd3397 2.654372658145e-01
RINT25515 nd3397 nd3398 1.680354650659e-01
RINT25516 nd3398 nd3399 2.913644572433e+00
RINT25517 nd3399 nd3400 2.866536769726e+00
RINT25518 nd3400 nd3401 2.072195255224e-01
RINT25519 nd3401 nd3402 2.072195255224e-01
RINT25520 nd3402 nd3403 2.072195255224e-01
RINT25521 nd3403 nd3404 2.072195255224e-01
RINT25522 nd3404 nd3405 2.072195255224e-01
RINT25523 nd3405 nd3406 2.072195255224e-01
RINT25524 nd3406 nd3407 2.072195255224e-01
RINT25525 nd3407 nd3408 2.072195255224e-01
RINT25526 nd3408 nd3409 2.072195255224e-01
RINT25527 nd3410 nd3411 1.914284617627e-01
RINT25528 nd3411 nd3412 1.740035002137e-01
RINT25529 nd3412 nd3413 5.881581083666e+00
RINT25530 nd3413 nd3414 5.981136757300e+00
RINT25531 nd3414 nd3415 3.668883239623e-01
RINT25532 nd3415 nd3416 3.606618004430e-01
RINT25533 nd3416 nd3417 1.976741618838e-01
RINT25534 nd3417 nd3418 8.656063970738e-02
RINT25535 nd3418 nd3419 1.760179307529e-01
RINT25536 nd3419 nd3420 2.136011054157e-01
RINT25537 nd3420 nd3421 2.136011054157e-01
RINT25538 nd3421 nd3422 2.136011054157e-01
RINT25539 nd3422 nd3423 2.136011054157e-01
RINT25540 nd3423 nd3424 2.136011054157e-01
RINT25541 nd3424 nd3425 2.136011054157e-01
RINT25542 nd3425 nd3426 2.884961700761e-01
RINT25543 nd3426 nd3427 4.298149835847e-01
RINT25544 nd3427 nd3428 2.654372658145e-01
RINT25545 nd3428 nd3429 1.680354650659e-01
RINT25546 nd3429 nd3430 2.913644572433e+00
RINT25547 nd3430 nd3431 2.866536769726e+00
RINT25548 nd3431 nd3432 2.072195255224e-01
RINT25549 nd3432 nd3433 2.072195255224e-01
RINT25550 nd3433 nd3434 2.072195255224e-01
RINT25551 nd3434 nd3435 2.072195255224e-01
RINT25552 nd3435 nd3436 2.072195255224e-01
RINT25553 nd3436 nd3437 2.072195255224e-01
RINT25554 nd3437 nd3438 2.072195255224e-01
RINT25555 nd3438 nd3439 2.072195255224e-01
RINT25556 nd3439 nd3440 2.072195255224e-01
RINT25557 nd3441 nd3442 1.914284617627e-01
RINT25558 nd3442 nd3443 1.740035002137e-01
RINT25559 nd3443 nd3444 5.881581083666e+00
RINT25560 nd3444 nd3445 5.981136757300e+00
RINT25561 nd3445 nd3446 3.668883239623e-01
RINT25562 nd3446 nd3447 3.606618004430e-01
RINT25563 nd3447 nd3448 1.976741618838e-01
RINT25564 nd3448 nd3449 8.656063970738e-02
RINT25565 nd3449 nd3450 1.760179307529e-01
RINT25566 nd3450 nd3451 2.136011054157e-01
RINT25567 nd3451 nd3452 2.136011054157e-01
RINT25568 nd3452 nd3453 2.136011054157e-01
RINT25569 nd3453 nd3454 2.136011054157e-01
RINT25570 nd3454 nd3455 2.136011054157e-01
RINT25571 nd3455 nd3456 2.136011054157e-01
RINT25572 nd3456 nd3457 2.884961700761e-01
RINT25573 nd3457 nd3458 4.298149835847e-01
RINT25574 nd3458 nd3459 2.654372658145e-01
RINT25575 nd3459 nd3460 1.680354650659e-01
RINT25576 nd3460 nd3461 2.913644572433e+00
RINT25577 nd3461 nd3462 2.866536769726e+00
RINT25578 nd3462 nd3463 2.072195255224e-01
RINT25579 nd3463 nd3464 2.072195255224e-01
RINT25580 nd3464 nd3465 2.072195255224e-01
RINT25581 nd3465 nd3466 2.072195255224e-01
RINT25582 nd3466 nd3467 2.072195255224e-01
RINT25583 nd3467 nd3468 2.072195255224e-01
RINT25584 nd3468 nd3469 2.072195255224e-01
RINT25585 nd3469 nd3470 2.072195255224e-01
RINT25586 nd3470 nd3471 2.072195255224e-01
RINT25587 nd3472 nd3473 1.914284617627e-01
RINT25588 nd3473 nd3474 1.740035002137e-01
RINT25589 nd3474 nd3475 5.881581083666e+00
RINT25590 nd3475 nd3476 5.981136757300e+00
RINT25591 nd3476 nd3477 3.668883239623e-01
RINT25592 nd3477 nd3478 3.606618004430e-01
RINT25593 nd3478 nd3479 1.976741618838e-01
RINT25594 nd3479 nd3480 8.656063970739e-02
RINT25595 nd3480 nd3481 1.760179307529e-01
RINT25596 nd3481 nd3482 2.136011054157e-01
RINT25597 nd3482 nd3483 2.136011054157e-01
RINT25598 nd3483 nd3484 2.136011054157e-01
RINT25599 nd3484 nd3485 2.136011054157e-01
RINT25600 nd3485 nd3486 2.136011054157e-01
RINT25601 nd3486 nd3487 2.136011054157e-01
RINT25602 nd3487 nd3488 2.884961700761e-01
RINT25603 nd3488 nd3489 4.298149835847e-01
RINT25604 nd3489 nd3490 2.654372658145e-01
RINT25605 nd3490 nd3491 1.680354650659e-01
RINT25606 nd3491 nd3492 2.913644572433e+00
RINT25607 nd3492 nd3493 2.866536769726e+00
RINT25608 nd3493 nd3494 2.072195255224e-01
RINT25609 nd3494 nd3495 2.072195255224e-01
RINT25610 nd3495 nd3496 2.072195255224e-01
RINT25611 nd3496 nd3497 2.072195255224e-01
RINT25612 nd3497 nd3498 2.072195255224e-01
RINT25613 nd3498 nd3499 2.072195255224e-01
RINT25614 nd3499 nd3500 2.072195255224e-01
RINT25615 nd3500 nd3501 2.072195255224e-01
RINT25616 nd3501 nd3502 2.072195255224e-01
RINT25617 nd3503 nd3504 1.914284617627e-01
RINT25618 nd3504 nd3505 1.740035002137e-01
RINT25619 nd3505 nd3506 5.881581083666e+00
RINT25620 nd3506 nd3507 5.981136757300e+00
RINT25621 nd3507 nd3508 3.668883239623e-01
RINT25622 nd3508 nd3509 3.606618004430e-01
RINT25623 nd3509 nd3510 1.976741618838e-01
RINT25624 nd3510 nd3511 8.656063970738e-02
RINT25625 nd3511 nd3512 1.760179307529e-01
RINT25626 nd3512 nd3513 2.136011054157e-01
RINT25627 nd3513 nd3514 2.136011054157e-01
RINT25628 nd3514 nd3515 2.136011054157e-01
RINT25629 nd3515 nd3516 2.136011054157e-01
RINT25630 nd3516 nd3517 2.136011054157e-01
RINT25631 nd3517 nd3518 2.136011054157e-01
RINT25632 nd3518 nd3519 2.884961700761e-01
RINT25633 nd3519 nd3520 4.298149835847e-01
RINT25634 nd3520 nd3521 2.654372658145e-01
RINT25635 nd3521 nd3522 1.680354650659e-01
RINT25636 nd3522 nd3523 2.913644572433e+00
RINT25637 nd3523 nd3524 2.866536769726e+00
RINT25638 nd3524 nd3525 2.072195255224e-01
RINT25639 nd3525 nd3526 2.072195255224e-01
RINT25640 nd3526 nd3527 2.072195255224e-01
RINT25641 nd3527 nd3528 2.072195255224e-01
RINT25642 nd3528 nd3529 2.072195255224e-01
RINT25643 nd3529 nd3530 2.072195255224e-01
RINT25644 nd3530 nd3531 2.072195255224e-01
RINT25645 nd3531 nd3532 2.072195255224e-01
RINT25646 nd3532 nd3533 2.072195255224e-01
RINT25647 nd3534 nd3535 1.914284617627e-01
RINT25648 nd3535 nd3536 1.740035002137e-01
RINT25649 nd3536 nd3537 5.881581083666e+00
RINT25650 nd3537 nd3538 5.981136757300e+00
RINT25651 nd3538 nd3539 3.668883239623e-01
RINT25652 nd3539 nd3540 3.606618004430e-01
RINT25653 nd3540 nd3541 1.976741618838e-01
RINT25654 nd3541 nd3542 8.656063970738e-02
RINT25655 nd3542 nd3543 1.760179307529e-01
RINT25656 nd3543 nd3544 2.136011054157e-01
RINT25657 nd3544 nd3545 2.136011054157e-01
RINT25658 nd3545 nd3546 2.136011054157e-01
RINT25659 nd3546 nd3547 2.136011054157e-01
RINT25660 nd3547 nd3548 2.136011054157e-01
RINT25661 nd3548 nd3549 2.136011054157e-01
RINT25662 nd3549 nd3550 2.884961700761e-01
RINT25663 nd3550 nd3551 4.298149835847e-01
RINT25664 nd3551 nd3552 2.654372658145e-01
RINT25665 nd3552 nd3553 1.680354650659e-01
RINT25666 nd3553 nd3554 2.913644572433e+00
RINT25667 nd3554 nd3555 2.866536769726e+00
RINT25668 nd3555 nd3556 2.072195255224e-01
RINT25669 nd3556 nd3557 2.072195255224e-01
RINT25670 nd3557 nd3558 2.072195255224e-01
RINT25671 nd3558 nd3559 2.072195255224e-01
RINT25672 nd3559 nd3560 2.072195255224e-01
RINT25673 nd3560 nd3561 2.072195255224e-01
RINT25674 nd3561 nd3562 2.072195255224e-01
RINT25675 nd3562 nd3563 2.072195255224e-01
RINT25676 nd3563 nd3564 2.072195255224e-01
RINT25677 nd3565 nd3566 1.832876633312e+00
RINT25678 nd3566 nd3567 1.666037258616e+00
RINT25679 nd3567 nd3568 5.631457535579e+01
RINT25680 nd3568 nd3569 5.726779446562e+01
RINT25681 nd3569 nd3570 3.512858170793e+00
RINT25682 nd3570 nd3571 3.453240863313e+00
RINT25683 nd3571 nd3572 9.993586560904e+00
RINT25684 nd3572 nd3573 5.786876290473e+01
RINT25685 nd3573 nd3574 7.853617822785e+01
RINT25686 nd3574 nd3575 5.786876290473e+01
RINT25687 nd3575 nd3576 5.786876290473e+01
RINT25688 nd3576 nd3577 5.786876290473e+01
RINT25689 nd3577 nd3578 5.786876290473e+01
RINT25690 nd3578 nd3579 5.786876290473e+01
RINT25691 nd3579 nd3580 5.786876290473e+01
RINT25692 nd3580 nd3581 1.591390979880e+02
RINT25693 nd3581 nd3582 2.604094330713e+02
RINT25694 nd3582 nd3583 1.303705308206e+02
RINT25695 nd3583 nd3584 1.608894908578e+00
RINT25696 nd3584 nd3585 2.789737223720e+01
RINT25697 nd3585 nd3586 2.744632754910e+01
RINT25698 nd3586 nd3587 1.984071871019e+00
RINT25699 nd3587 nd3588 1.984071871019e+00
RINT25700 nd3588 nd3589 1.984071871019e+00
RINT25701 nd3589 nd3590 1.984071871019e+00
RINT25702 nd3590 nd3591 1.984071871019e+00
RINT25703 nd3591 nd3592 1.984071871019e+00
RINT25704 nd3592 nd3593 1.984071871019e+00
RINT25705 nd3593 nd3594 1.984071871019e+00
RINT25706 nd3594 nd3595 1.984071871019e+00
RINT25707 nd3596 nd3597 1.914284617627e-01
RINT25708 nd3597 nd3598 1.740035002137e-01
RINT25709 nd3598 nd3599 5.881581083666e+00
RINT25710 nd3599 nd3600 5.981136757300e+00
RINT25711 nd3600 nd3601 3.668883239623e-01
RINT25712 nd3601 nd3602 3.606618004430e-01
RINT25713 nd3602 nd3603 1.976741618838e-01
RINT25714 nd3603 nd3604 8.656063970739e-02
RINT25715 nd3604 nd3605 1.760179307529e-01
RINT25716 nd3605 nd3606 2.136011054157e-01
RINT25717 nd3606 nd3607 2.136011054157e-01
RINT25718 nd3607 nd3608 2.136011054157e-01
RINT25719 nd3608 nd3609 2.136011054157e-01
RINT25720 nd3609 nd3610 2.136011054157e-01
RINT25721 nd3610 nd3611 2.136011054157e-01
RINT25722 nd3611 nd3612 2.884961700761e-01
RINT25723 nd3612 nd3613 4.298149835847e-01
RINT25724 nd3613 nd3614 2.654372658145e-01
RINT25725 nd3614 nd3615 1.680354650659e-01
RINT25726 nd3615 nd3616 2.913644572433e+00
RINT25727 nd3616 nd3617 2.866536769726e+00
RINT25728 nd3617 nd3618 2.072195255224e-01
RINT25729 nd3618 nd3619 2.072195255224e-01
RINT25730 nd3619 nd3620 2.072195255224e-01
RINT25731 nd3620 nd3621 2.072195255224e-01
RINT25732 nd3621 nd3622 2.072195255224e-01
RINT25733 nd3622 nd3623 2.072195255224e-01
RINT25734 nd3623 nd3624 2.072195255224e-01
RINT25735 nd3624 nd3625 2.072195255224e-01
RINT25736 nd3625 nd3626 2.072195255224e-01
RINT25737 nd3627 nd3628 1.914284617627e-01
RINT25738 nd3628 nd3629 1.740035002137e-01
RINT25739 nd3629 nd3630 5.881581083666e+00
RINT25740 nd3630 nd3631 5.981136757300e+00
RINT25741 nd3631 nd3632 3.668883239623e-01
RINT25742 nd3632 nd3633 3.606618004430e-01
RINT25743 nd3633 nd3634 1.976741618838e-01
RINT25744 nd3634 nd3635 8.656063970738e-02
RINT25745 nd3635 nd3636 1.760179307529e-01
RINT25746 nd3636 nd3637 2.136011054157e-01
RINT25747 nd3637 nd3638 2.136011054157e-01
RINT25748 nd3638 nd3639 2.136011054157e-01
RINT25749 nd3639 nd3640 2.136011054157e-01
RINT25750 nd3640 nd3641 2.136011054157e-01
RINT25751 nd3641 nd3642 2.136011054157e-01
RINT25752 nd3642 nd3643 2.884961700761e-01
RINT25753 nd3643 nd3644 4.298149835847e-01
RINT25754 nd3644 nd3645 2.654372658145e-01
RINT25755 nd3645 nd3646 1.680354650659e-01
RINT25756 nd3646 nd3647 2.913644572433e+00
RINT25757 nd3647 nd3648 2.866536769726e+00
RINT25758 nd3648 nd3649 2.072195255224e-01
RINT25759 nd3649 nd3650 2.072195255224e-01
RINT25760 nd3650 nd3651 2.072195255224e-01
RINT25761 nd3651 nd3652 2.072195255224e-01
RINT25762 nd3652 nd3653 2.072195255224e-01
RINT25763 nd3653 nd3654 2.072195255224e-01
RINT25764 nd3654 nd3655 2.072195255224e-01
RINT25765 nd3655 nd3656 2.072195255224e-01
RINT25766 nd3656 nd3657 2.072195255224e-01
RINT25767 nd3658 nd3659 1.914284617627e-01
RINT25768 nd3659 nd3660 1.740035002137e-01
RINT25769 nd3660 nd3661 5.881581083666e+00
RINT25770 nd3661 nd3662 5.981136757300e+00
RINT25771 nd3662 nd3663 3.668883239623e-01
RINT25772 nd3663 nd3664 3.606618004430e-01
RINT25773 nd3664 nd3665 1.976741618838e-01
RINT25774 nd3665 nd3666 8.656063970739e-02
RINT25775 nd3666 nd3667 1.760179307529e-01
RINT25776 nd3667 nd3668 2.136011054157e-01
RINT25777 nd3668 nd3669 2.136011054157e-01
RINT25778 nd3669 nd3670 2.136011054157e-01
RINT25779 nd3670 nd3671 2.136011054157e-01
RINT25780 nd3671 nd3672 2.136011054157e-01
RINT25781 nd3672 nd3673 2.136011054157e-01
RINT25782 nd3673 nd3674 2.884961700761e-01
RINT25783 nd3674 nd3675 4.298149835847e-01
RINT25784 nd3675 nd3676 2.654372658145e-01
RINT25785 nd3676 nd3677 1.680354650659e-01
RINT25786 nd3677 nd3678 2.913644572433e+00
RINT25787 nd3678 nd3679 2.866536769726e+00
RINT25788 nd3679 nd3680 2.072195255224e-01
RINT25789 nd3680 nd3681 2.072195255224e-01
RINT25790 nd3681 nd3682 2.072195255224e-01
RINT25791 nd3682 nd3683 2.072195255224e-01
RINT25792 nd3683 nd3684 2.072195255224e-01
RINT25793 nd3684 nd3685 2.072195255224e-01
RINT25794 nd3685 nd3686 2.072195255224e-01
RINT25795 nd3686 nd3687 2.072195255224e-01
RINT25796 nd3687 nd3688 2.072195255224e-01
RINT25797 nd3689 nd3690 1.914284617627e-01
RINT25798 nd3690 nd3691 1.740035002137e-01
RINT25799 nd3691 nd3692 5.881581083666e+00
RINT25800 nd3692 nd3693 5.981136757300e+00
RINT25801 nd3693 nd3694 3.668883239623e-01
RINT25802 nd3694 nd3695 3.606618004430e-01
RINT25803 nd3695 nd3696 1.976741618838e-01
RINT25804 nd3696 nd3697 8.656063970739e-02
RINT25805 nd3697 nd3698 1.760179307529e-01
RINT25806 nd3698 nd3699 2.136011054157e-01
RINT25807 nd3699 nd3700 2.136011054157e-01
RINT25808 nd3700 nd3701 2.136011054157e-01
RINT25809 nd3701 nd3702 2.136011054157e-01
RINT25810 nd3702 nd3703 2.136011054157e-01
RINT25811 nd3703 nd3704 2.136011054157e-01
RINT25812 nd3704 nd3705 2.884961700761e-01
RINT25813 nd3705 nd3706 4.298149835847e-01
RINT25814 nd3706 nd3707 2.654372658145e-01
RINT25815 nd3707 nd3708 1.680354650659e-01
RINT25816 nd3708 nd3709 2.913644572433e+00
RINT25817 nd3709 nd3710 2.866536769726e+00
RINT25818 nd3710 nd3711 2.072195255224e-01
RINT25819 nd3711 nd3712 2.072195255224e-01
RINT25820 nd3712 nd3713 2.072195255224e-01
RINT25821 nd3713 nd3714 2.072195255224e-01
RINT25822 nd3714 nd3715 2.072195255224e-01
RINT25823 nd3715 nd3716 2.072195255224e-01
RINT25824 nd3716 nd3717 2.072195255224e-01
RINT25825 nd3717 nd3718 2.072195255224e-01
RINT25826 nd3718 nd3719 2.072195255224e-01
RINT25827 nd3720 nd3721 1.914284617627e-01
RINT25828 nd3721 nd3722 1.740035002137e-01
RINT25829 nd3722 nd3723 5.881581083666e+00
RINT25830 nd3723 nd3724 5.981136757300e+00
RINT25831 nd3724 nd3725 3.668883239623e-01
RINT25832 nd3725 nd3726 3.606618004430e-01
RINT25833 nd3726 nd3727 1.976741618838e-01
RINT25834 nd3727 nd3728 8.656063970738e-02
RINT25835 nd3728 nd3729 1.760179307529e-01
RINT25836 nd3729 nd3730 2.136011054157e-01
RINT25837 nd3730 nd3731 2.136011054157e-01
RINT25838 nd3731 nd3732 2.136011054157e-01
RINT25839 nd3732 nd3733 2.136011054157e-01
RINT25840 nd3733 nd3734 2.136011054157e-01
RINT25841 nd3734 nd3735 2.136011054157e-01
RINT25842 nd3735 nd3736 2.884961700761e-01
RINT25843 nd3736 nd3737 4.298149835847e-01
RINT25844 nd3737 nd3738 2.654372658145e-01
RINT25845 nd3738 nd3739 1.680354650659e-01
RINT25846 nd3739 nd3740 2.913644572433e+00
RINT25847 nd3740 nd3741 2.866536769726e+00
RINT25848 nd3741 nd3742 2.072195255224e-01
RINT25849 nd3742 nd3743 2.072195255224e-01
RINT25850 nd3743 nd3744 2.072195255224e-01
RINT25851 nd3744 nd3745 2.072195255224e-01
RINT25852 nd3745 nd3746 2.072195255224e-01
RINT25853 nd3746 nd3747 2.072195255224e-01
RINT25854 nd3747 nd3748 2.072195255224e-01
RINT25855 nd3748 nd3749 2.072195255224e-01
RINT25856 nd3749 nd3750 2.072195255224e-01
RINT25857 nd3751 nd3752 1.914284617627e-01
RINT25858 nd3752 nd3753 1.740035002137e-01
RINT25859 nd3753 nd3754 5.881581083666e+00
RINT25860 nd3754 nd3755 5.981136757300e+00
RINT25861 nd3755 nd3756 3.668883239623e-01
RINT25862 nd3756 nd3757 3.606618004430e-01
RINT25863 nd3757 nd3758 1.976741618838e-01
RINT25864 nd3758 nd3759 8.656063970739e-02
RINT25865 nd3759 nd3760 1.760179307529e-01
RINT25866 nd3760 nd3761 2.136011054157e-01
RINT25867 nd3761 nd3762 2.136011054157e-01
RINT25868 nd3762 nd3763 2.136011054157e-01
RINT25869 nd3763 nd3764 2.136011054157e-01
RINT25870 nd3764 nd3765 2.136011054157e-01
RINT25871 nd3765 nd3766 2.136011054157e-01
RINT25872 nd3766 nd3767 2.884961700761e-01
RINT25873 nd3767 nd3768 4.298149835847e-01
RINT25874 nd3768 nd3769 2.654372658145e-01
RINT25875 nd3769 nd3770 1.680354650659e-01
RINT25876 nd3770 nd3771 2.913644572433e+00
RINT25877 nd3771 nd3772 2.866536769726e+00
RINT25878 nd3772 nd3773 2.072195255224e-01
RINT25879 nd3773 nd3774 2.072195255224e-01
RINT25880 nd3774 nd3775 2.072195255224e-01
RINT25881 nd3775 nd3776 2.072195255224e-01
RINT25882 nd3776 nd3777 2.072195255224e-01
RINT25883 nd3777 nd3778 2.072195255224e-01
RINT25884 nd3778 nd3779 2.072195255224e-01
RINT25885 nd3779 nd3780 2.072195255224e-01
RINT25886 nd3780 nd3781 2.072195255224e-01
RINT25887 nd3782 nd3783 1.832876633312e+00
RINT25888 nd3783 nd3784 1.666037258616e+00
RINT25889 nd3784 nd3785 5.631457535579e+01
RINT25890 nd3785 nd3786 5.726779446562e+01
RINT25891 nd3786 nd3787 3.512858170793e+00
RINT25892 nd3787 nd3788 3.453240863313e+00
RINT25893 nd3788 nd3789 9.993586560904e+00
RINT25894 nd3789 nd3790 5.786876290473e+01
RINT25895 nd3790 nd3791 7.853617822785e+01
RINT25896 nd3791 nd3792 5.786876290473e+01
RINT25897 nd3792 nd3793 5.786876290473e+01
RINT25898 nd3793 nd3794 5.786876290473e+01
RINT25899 nd3794 nd3795 5.786876290473e+01
RINT25900 nd3795 nd3796 5.786876290473e+01
RINT25901 nd3796 nd3797 5.786876290473e+01
RINT25902 nd3797 nd3798 1.591390979880e+02
RINT25903 nd3798 nd3799 2.604094330713e+02
RINT25904 nd3799 nd3800 1.303705308206e+02
RINT25905 nd3800 nd3801 1.608894908578e+00
RINT25906 nd3801 nd3802 2.789737223720e+01
RINT25907 nd3802 nd3803 2.744632754910e+01
RINT25908 nd3803 nd3804 1.984071871019e+00
RINT25909 nd3804 nd3805 1.984071871019e+00
RINT25910 nd3805 nd3806 1.984071871019e+00
RINT25911 nd3806 nd3807 1.984071871019e+00
RINT25912 nd3807 nd3808 1.984071871019e+00
RINT25913 nd3808 nd3809 1.984071871019e+00
RINT25914 nd3809 nd3810 1.984071871019e+00
RINT25915 nd3810 nd3811 1.984071871019e+00
RINT25916 nd3811 nd3812 1.984071871019e+00
RINT25917 nd3813 nd3814 2.493313941068e-01
RINT25918 nd3814 nd3815 2.266357619356e-01
RINT25919 nd3815 nd3816 7.660631014006e+00
RINT25920 nd3816 nd3817 7.790300106417e+00
RINT25921 nd3817 nd3818 4.778640357485e-01
RINT25922 nd3818 nd3819 4.697541247393e-01
RINT25923 nd3819 nd3820 2.520135011038e-01
RINT25924 nd3820 nd3821 1.199550711388e-01
RINT25925 nd3821 nd3822 1.627961679741e-01
RINT25926 nd3822 nd3823 1.199550711388e-01
RINT25927 nd3823 nd3824 1.199550711388e-01
RINT25928 nd3824 nd3825 1.199550711388e-01
RINT25929 nd3825 nd3826 1.199550711388e-01
RINT25930 nd3826 nd3827 1.199550711388e-01
RINT25931 nd3827 nd3828 1.199550711388e-01
RINT25932 nd3828 nd3829 3.298764456317e-01
RINT25933 nd3829 nd3830 5.397978201245e-01
RINT25934 nd3830 nd3831 2.924550963786e-01
RINT25935 nd3831 nd3832 2.188625263897e-01
RINT25936 nd3832 nd3833 3.794958474237e+00
RINT25937 nd3833 nd3834 3.733601589195e+00
RINT25938 nd3834 nd3835 2.698989100623e-01
RINT25939 nd3835 nd3836 2.698989100623e-01
RINT25940 nd3836 nd3837 2.698989100623e-01
RINT25941 nd3837 nd3838 2.698989100623e-01
RINT25942 nd3838 nd3839 2.698989100623e-01
RINT25943 nd3839 nd3840 2.698989100623e-01
RINT25944 nd3840 nd3841 2.698989100623e-01
RINT25945 nd3841 nd3842 2.698989100623e-01
RINT25946 nd3842 nd3843 2.698989100623e-01
RINT25947 nd3844 nd3845 2.493313941068e-01
RINT25948 nd3845 nd3846 2.266357619356e-01
RINT25949 nd3846 nd3847 7.660631014006e+00
RINT25950 nd3847 nd3848 7.790300106417e+00
RINT25951 nd3848 nd3849 4.778640357485e-01
RINT25952 nd3849 nd3850 4.697541247393e-01
RINT25953 nd3850 nd3851 2.520135011038e-01
RINT25954 nd3851 nd3852 1.199550711388e-01
RINT25955 nd3852 nd3853 1.627961679741e-01
RINT25956 nd3853 nd3854 1.199550711388e-01
RINT25957 nd3854 nd3855 1.199550711388e-01
RINT25958 nd3855 nd3856 1.199550711388e-01
RINT25959 nd3856 nd3857 1.199550711388e-01
RINT25960 nd3857 nd3858 1.199550711388e-01
RINT25961 nd3858 nd3859 1.199550711388e-01
RINT25962 nd3859 nd3860 3.298764456317e-01
RINT25963 nd3860 nd3861 5.397978201245e-01
RINT25964 nd3861 nd3862 2.924550963786e-01
RINT25965 nd3862 nd3863 2.188625263897e-01
RINT25966 nd3863 nd3864 3.794958474237e+00
RINT25967 nd3864 nd3865 3.733601589195e+00
RINT25968 nd3865 nd3866 2.698989100623e-01
RINT25969 nd3866 nd3867 2.698989100623e-01
RINT25970 nd3867 nd3868 2.698989100623e-01
RINT25971 nd3868 nd3869 2.698989100623e-01
RINT25972 nd3869 nd3870 2.698989100623e-01
RINT25973 nd3870 nd3871 2.698989100623e-01
RINT25974 nd3871 nd3872 2.698989100623e-01
RINT25975 nd3872 nd3873 2.698989100623e-01
RINT25976 nd3873 nd3874 2.698989100623e-01
RINT25977 nd3875 nd3876 2.493313941068e-01
RINT25978 nd3876 nd3877 2.266357619356e-01
RINT25979 nd3877 nd3878 7.660631014006e+00
RINT25980 nd3878 nd3879 7.790300106417e+00
RINT25981 nd3879 nd3880 4.778640357485e-01
RINT25982 nd3880 nd3881 4.697541247393e-01
RINT25983 nd3881 nd3882 2.520135011038e-01
RINT25984 nd3882 nd3883 1.199550711388e-01
RINT25985 nd3883 nd3884 1.627961679741e-01
RINT25986 nd3884 nd3885 1.199550711388e-01
RINT25987 nd3885 nd3886 1.199550711388e-01
RINT25988 nd3886 nd3887 1.199550711388e-01
RINT25989 nd3887 nd3888 1.199550711388e-01
RINT25990 nd3888 nd3889 1.199550711388e-01
RINT25991 nd3889 nd3890 1.199550711388e-01
RINT25992 nd3890 nd3891 3.298764456317e-01
RINT25993 nd3891 nd3892 5.397978201245e-01
RINT25994 nd3892 nd3893 2.924550963786e-01
RINT25995 nd3893 nd3894 2.188625263897e-01
RINT25996 nd3894 nd3895 3.794958474237e+00
RINT25997 nd3895 nd3896 3.733601589195e+00
RINT25998 nd3896 nd3897 2.698989100623e-01
RINT25999 nd3897 nd3898 2.698989100623e-01
RINT26000 nd3898 nd3899 2.698989100623e-01
RINT26001 nd3899 nd3900 2.698989100623e-01
RINT26002 nd3900 nd3901 2.698989100623e-01
RINT26003 nd3901 nd3902 2.698989100623e-01
RINT26004 nd3902 nd3903 2.698989100623e-01
RINT26005 nd3903 nd3904 2.698989100623e-01
RINT26006 nd3904 nd3905 2.698989100623e-01
RINT26007 nd3906 nd3907 2.356247123801e+00
RINT26008 nd3907 nd3908 2.141767442179e+00
RINT26009 nd3908 nd3909 7.239497399800e+01
RINT26010 nd3909 nd3910 7.362038095942e+01
RINT26011 nd3910 nd3911 4.515940577133e+00
RINT26012 nd3911 nd3912 4.439299789244e+00
RINT26013 nd3912 nd3913 2.381593738975e+00
RINT26014 nd3913 nd3914 1.133606910468e+00
RINT26015 nd3914 nd3915 1.538466521349e+00
RINT26016 nd3915 nd3916 1.133606910468e+00
RINT26017 nd3916 nd3917 1.133606910468e+00
RINT26018 nd3917 nd3918 1.133606910468e+00
RINT26019 nd3918 nd3919 1.133606910468e+00
RINT26020 nd3919 nd3920 1.133606910468e+00
RINT26021 nd3920 nd3921 1.133606910468e+00
RINT26022 nd3921 nd3922 3.117419003786e+00
RINT26023 nd3922 nd3923 5.101231097105e+00
RINT26024 nd3923 nd3924 2.763777430240e+00
RINT26025 nd3924 nd3925 2.068308325796e+00
RINT26026 nd3925 nd3926 3.586335375814e+01
RINT26027 nd3926 nd3927 3.528351508831e+01
RINT26028 nd3927 nd3928 2.550615548552e+00
RINT26029 nd3928 nd3929 2.550615548552e+00
RINT26030 nd3929 nd3930 2.550615548552e+00
RINT26031 nd3930 nd3931 2.550615548552e+00
RINT26032 nd3931 nd3932 2.550615548552e+00
RINT26033 nd3932 nd3933 2.550615548552e+00
RINT26034 nd3933 nd3934 2.550615548552e+00
RINT26035 nd3934 nd3935 2.550615548552e+00
RINT26036 nd3935 nd3936 2.550615548552e+00
RINT26037 nd3937 nd3938 2.356247123801e+00
RINT26038 nd3938 nd3939 2.141767442179e+00
RINT26039 nd3939 nd3940 7.239497399800e+01
RINT26040 nd3940 nd3941 7.362038095942e+01
RINT26041 nd3941 nd3942 4.515940577133e+00
RINT26042 nd3942 nd3943 4.439299789244e+00
RINT26043 nd3943 nd3944 2.381593738975e+00
RINT26044 nd3944 nd3945 1.133606910468e+00
RINT26045 nd3945 nd3946 1.538466521349e+00
RINT26046 nd3946 nd3947 1.133606910468e+00
RINT26047 nd3947 nd3948 1.133606910468e+00
RINT26048 nd3948 nd3949 1.133606910468e+00
RINT26049 nd3949 nd3950 1.133606910468e+00
RINT26050 nd3950 nd3951 1.133606910468e+00
RINT26051 nd3951 nd3952 1.133606910468e+00
RINT26052 nd3952 nd3953 3.117419003786e+00
RINT26053 nd3953 nd3954 5.101231097105e+00
RINT26054 nd3954 nd3955 2.763777430240e+00
RINT26055 nd3955 nd3956 2.068308325796e+00
RINT26056 nd3956 nd3957 3.586335375814e+01
RINT26057 nd3957 nd3958 3.528351508831e+01
RINT26058 nd3958 nd3959 2.550615548552e+00
RINT26059 nd3959 nd3960 2.550615548552e+00
RINT26060 nd3960 nd3961 2.550615548552e+00
RINT26061 nd3961 nd3962 2.550615548552e+00
RINT26062 nd3962 nd3963 2.550615548552e+00
RINT26063 nd3963 nd3964 2.550615548552e+00
RINT26064 nd3964 nd3965 2.550615548552e+00
RINT26065 nd3965 nd3966 2.550615548552e+00
RINT26066 nd3966 nd3967 2.550615548552e+00
RINT26067 nd3968 nd3969 2.356247123801e+00
RINT26068 nd3969 nd3970 2.141767442179e+00
RINT26069 nd3970 nd3971 7.239497399800e+01
RINT26070 nd3971 nd3972 7.362038095942e+01
RINT26071 nd3972 nd3973 4.515940577133e+00
RINT26072 nd3973 nd3974 4.439299789244e+00
RINT26073 nd3974 nd3975 2.381593738975e+00
RINT26074 nd3975 nd3976 1.133606910468e+00
RINT26075 nd3976 nd3977 1.538466521349e+00
RINT26076 nd3977 nd3978 1.133606910468e+00
RINT26077 nd3978 nd3979 1.133606910468e+00
RINT26078 nd3979 nd3980 1.133606910468e+00
RINT26079 nd3980 nd3981 1.133606910468e+00
RINT26080 nd3981 nd3982 1.133606910468e+00
RINT26081 nd3982 nd3983 1.133606910468e+00
RINT26082 nd3983 nd3984 3.117419003786e+00
RINT26083 nd3984 nd3985 5.101231097105e+00
RINT26084 nd3985 nd3986 2.763777430240e+00
RINT26085 nd3986 nd3987 2.068308325796e+00
RINT26086 nd3987 nd3988 3.586335375814e+01
RINT26087 nd3988 nd3989 3.528351508831e+01
RINT26088 nd3989 nd3990 2.550615548552e+00
RINT26089 nd3990 nd3991 2.550615548552e+00
RINT26090 nd3991 nd3992 2.550615548552e+00
RINT26091 nd3992 nd3993 2.550615548552e+00
RINT26092 nd3993 nd3994 2.550615548552e+00
RINT26093 nd3994 nd3995 2.550615548552e+00
RINT26094 nd3995 nd3996 2.550615548552e+00
RINT26095 nd3996 nd3997 2.550615548552e+00
RINT26096 nd3997 nd3998 2.550615548552e+00
RINT26097 nd3999 nd4000 1.732116531491e+01
RINT26098 nd4000 nd4001 1.574448942870e+01
RINT26099 nd4001 nd4002 5.321875196883e+02
RINT26100 nd4002 nd4003 5.411956904962e+02
RINT26101 nd4003 nd4004 3.319743183927e+01
RINT26102 nd4004 nd4005 3.263403263403e+01
RINT26103 nd4005 nd4006 9.444201631702e+01
RINT26104 nd4006 nd4007 5.468750000000e+02
RINT26105 nd4007 nd4008 7.421875000000e+02
RINT26106 nd4008 nd4009 5.468750000000e+02
RINT26107 nd4009 nd4010 5.468750000000e+02
RINT26108 nd4010 nd4011 5.468750000000e+02
RINT26109 nd4011 nd4012 5.468750000000e+02
RINT26110 nd4012 nd4013 5.468750000000e+02
RINT26111 nd4013 nd4014 5.468750000000e+02
RINT26112 nd4014 nd4015 1.503906250000e+03
RINT26113 nd4015 nd4016 2.460937500000e+03
RINT26114 nd4016 nd4017 1.232035738519e+03
RINT26115 nd4017 nd4018 1.520447922098e+01
RINT26116 nd4018 nd4019 2.636374907017e+02
RINT26117 nd4019 nd4020 2.593750000000e+02
RINT26118 nd4020 nd4021 1.875000000000e+01
RINT26119 nd4021 nd4022 1.875000000000e+01
RINT26120 nd4022 nd4023 1.875000000000e+01
RINT26121 nd4023 nd4024 1.875000000000e+01
RINT26122 nd4024 nd4025 1.875000000000e+01
RINT26123 nd4025 nd4026 1.875000000000e+01
RINT26124 nd4026 nd4027 1.875000000000e+01
RINT26125 nd4027 nd4028 1.875000000000e+01
RINT26126 nd4028 nd4029 1.875000000000e+01
RINT26127 nd4030 nd4031 1.809049213629e+00
RINT26128 nd4031 nd4032 1.644378752938e+00
RINT26129 nd4032 nd4033 5.558248515568e+01
RINT26130 nd4033 nd4034 5.652331240488e+01
RINT26131 nd4034 nd4035 3.467190969629e+00
RINT26132 nd4035 nd4036 3.408348687909e+00
RINT26133 nd4036 nd4037 9.863669807754e+00
RINT26134 nd4037 nd4038 5.711646824659e+01
RINT26135 nd4038 nd4039 7.751520690609e+01
RINT26136 nd4039 nd4040 5.711646824659e+01
RINT26137 nd4040 nd4041 5.711646824659e+01
RINT26138 nd4041 nd4042 5.711646824659e+01
RINT26139 nd4042 nd4043 5.711646824659e+01
RINT26140 nd4043 nd4044 5.711646824659e+01
RINT26141 nd4044 nd4045 5.711646824659e+01
RINT26142 nd4045 nd4046 1.570702876781e+02
RINT26143 nd4046 nd4047 2.570241071097e+02
RINT26144 nd4047 nd4048 1.286757122520e+02
RINT26145 nd4048 nd4049 1.587979254183e+00
RINT26146 nd4049 nd4050 2.753470604119e+01
RINT26147 nd4050 nd4051 2.708952493981e+01
RINT26148 nd4051 nd4052 1.958278911312e+00
RINT26149 nd4052 nd4053 1.958278911312e+00
RINT26150 nd4053 nd4054 1.958278911312e+00
RINT26151 nd4054 nd4055 1.958278911312e+00
RINT26152 nd4055 nd4056 1.958278911312e+00
RINT26153 nd4056 nd4057 1.958278911312e+00
RINT26154 nd4057 nd4058 1.958278911312e+00
RINT26155 nd4058 nd4059 1.958278911312e+00
RINT26156 nd4059 nd4060 1.958278911312e+00
RINT26157 nd4061 nd4062 1.809049213629e+00
RINT26158 nd4062 nd4063 1.644378752938e+00
RINT26159 nd4063 nd4064 5.558248515568e+01
RINT26160 nd4064 nd4065 5.652331240488e+01
RINT26161 nd4065 nd4066 3.467190969629e+00
RINT26162 nd4066 nd4067 3.408348687909e+00
RINT26163 nd4067 nd4068 9.863669807754e+00
RINT26164 nd4068 nd4069 5.711646824659e+01
RINT26165 nd4069 nd4070 7.751520690609e+01
RINT26166 nd4070 nd4071 5.711646824659e+01
RINT26167 nd4071 nd4072 5.711646824659e+01
RINT26168 nd4072 nd4073 5.711646824659e+01
RINT26169 nd4073 nd4074 5.711646824659e+01
RINT26170 nd4074 nd4075 5.711646824659e+01
RINT26171 nd4075 nd4076 5.711646824659e+01
RINT26172 nd4076 nd4077 1.570702876781e+02
RINT26173 nd4077 nd4078 2.570241071097e+02
RINT26174 nd4078 nd4079 1.286757122520e+02
RINT26175 nd4079 nd4080 1.587979254183e+00
RINT26176 nd4080 nd4081 2.753470604119e+01
RINT26177 nd4081 nd4082 2.708952493981e+01
RINT26178 nd4082 nd4083 1.958278911312e+00
RINT26179 nd4083 nd4084 1.958278911312e+00
RINT26180 nd4084 nd4085 1.958278911312e+00
RINT26181 nd4085 nd4086 1.958278911312e+00
RINT26182 nd4086 nd4087 1.958278911312e+00
RINT26183 nd4087 nd4088 1.958278911312e+00
RINT26184 nd4088 nd4089 1.958278911312e+00
RINT26185 nd4089 nd4090 1.958278911312e+00
RINT26186 nd4090 nd4091 1.958278911312e+00
RINT26187 nd4092 nd4093 1.809049213629e+00
RINT26188 nd4093 nd4094 1.644378752938e+00
RINT26189 nd4094 nd4095 5.558248515568e+01
RINT26190 nd4095 nd4096 5.652331240488e+01
RINT26191 nd4096 nd4097 3.467190969629e+00
RINT26192 nd4097 nd4098 3.408348687909e+00
RINT26193 nd4098 nd4099 9.863669807754e+00
RINT26194 nd4099 nd4100 5.711646824659e+01
RINT26195 nd4100 nd4101 7.751520690609e+01
RINT26196 nd4101 nd4102 5.711646824659e+01
RINT26197 nd4102 nd4103 5.711646824659e+01
RINT26198 nd4103 nd4104 5.711646824659e+01
RINT26199 nd4104 nd4105 5.711646824659e+01
RINT26200 nd4105 nd4106 5.711646824659e+01
RINT26201 nd4106 nd4107 5.711646824659e+01
RINT26202 nd4107 nd4108 1.570702876781e+02
RINT26203 nd4108 nd4109 2.570241071097e+02
RINT26204 nd4109 nd4110 1.286757122520e+02
RINT26205 nd4110 nd4111 1.587979254183e+00
RINT26206 nd4111 nd4112 2.753470604119e+01
RINT26207 nd4112 nd4113 2.708952493981e+01
RINT26208 nd4113 nd4114 1.958278911312e+00
RINT26209 nd4114 nd4115 1.958278911312e+00
RINT26210 nd4115 nd4116 1.958278911312e+00
RINT26211 nd4116 nd4117 1.958278911312e+00
RINT26212 nd4117 nd4118 1.958278911312e+00
RINT26213 nd4118 nd4119 1.958278911312e+00
RINT26214 nd4119 nd4120 1.958278911312e+00
RINT26215 nd4120 nd4121 1.958278911312e+00
RINT26216 nd4121 nd4122 1.958278911312e+00
RINT26217 nd4123 nd4124 1.809049213629e+00
RINT26218 nd4124 nd4125 1.644378752938e+00
RINT26219 nd4125 nd4126 5.558248515568e+01
RINT26220 nd4126 nd4127 5.652331240488e+01
RINT26221 nd4127 nd4128 3.467190969629e+00
RINT26222 nd4128 nd4129 3.408348687909e+00
RINT26223 nd4129 nd4130 9.863669807754e+00
RINT26224 nd4130 nd4131 5.711646824659e+01
RINT26225 nd4131 nd4132 7.751520690609e+01
RINT26226 nd4132 nd4133 5.711646824659e+01
RINT26227 nd4133 nd4134 5.711646824659e+01
RINT26228 nd4134 nd4135 5.711646824659e+01
RINT26229 nd4135 nd4136 5.711646824659e+01
RINT26230 nd4136 nd4137 5.711646824659e+01
RINT26231 nd4137 nd4138 5.711646824659e+01
RINT26232 nd4138 nd4139 1.570702876781e+02
RINT26233 nd4139 nd4140 2.570241071097e+02
RINT26234 nd4140 nd4141 1.286757122520e+02
RINT26235 nd4141 nd4142 1.587979254183e+00
RINT26236 nd4142 nd4143 2.753470604119e+01
RINT26237 nd4143 nd4144 2.708952493981e+01
RINT26238 nd4144 nd4145 1.958278911312e+00
RINT26239 nd4145 nd4146 1.958278911312e+00
RINT26240 nd4146 nd4147 1.958278911312e+00
RINT26241 nd4147 nd4148 1.958278911312e+00
RINT26242 nd4148 nd4149 1.958278911312e+00
RINT26243 nd4149 nd4150 1.958278911312e+00
RINT26244 nd4150 nd4151 1.958278911312e+00
RINT26245 nd4151 nd4152 1.958278911312e+00
RINT26246 nd4152 nd4153 1.958278911312e+00
RINT26247 nd4154 nd4155 1.809049213629e+00
RINT26248 nd4155 nd4156 1.644378752938e+00
RINT26249 nd4156 nd4157 5.558248515568e+01
RINT26250 nd4157 nd4158 5.652331240488e+01
RINT26251 nd4158 nd4159 3.467190969629e+00
RINT26252 nd4159 nd4160 3.408348687909e+00
RINT26253 nd4160 nd4161 9.863669807754e+00
RINT26254 nd4161 nd4162 5.711646824659e+01
RINT26255 nd4162 nd4163 7.751520690609e+01
RINT26256 nd4163 nd4164 5.711646824659e+01
RINT26257 nd4164 nd4165 5.711646824659e+01
RINT26258 nd4165 nd4166 5.711646824659e+01
RINT26259 nd4166 nd4167 5.711646824659e+01
RINT26260 nd4167 nd4168 5.711646824659e+01
RINT26261 nd4168 nd4169 5.711646824659e+01
RINT26262 nd4169 nd4170 1.570702876781e+02
RINT26263 nd4170 nd4171 2.570241071097e+02
RINT26264 nd4171 nd4172 1.286757122520e+02
RINT26265 nd4172 nd4173 1.587979254183e+00
RINT26266 nd4173 nd4174 2.753470604119e+01
RINT26267 nd4174 nd4175 2.708952493981e+01
RINT26268 nd4175 nd4176 1.958278911312e+00
RINT26269 nd4176 nd4177 1.958278911312e+00
RINT26270 nd4177 nd4178 1.958278911312e+00
RINT26271 nd4178 nd4179 1.958278911312e+00
RINT26272 nd4179 nd4180 1.958278911312e+00
RINT26273 nd4180 nd4181 1.958278911312e+00
RINT26274 nd4181 nd4182 1.958278911312e+00
RINT26275 nd4182 nd4183 1.958278911312e+00
RINT26276 nd4183 nd4184 1.958278911312e+00
RINT26277 nd4185 nd4186 1.809049213629e+00
RINT26278 nd4186 nd4187 1.644378752938e+00
RINT26279 nd4187 nd4188 5.558248515568e+01
RINT26280 nd4188 nd4189 5.652331240488e+01
RINT26281 nd4189 nd4190 3.467190969629e+00
RINT26282 nd4190 nd4191 3.408348687909e+00
RINT26283 nd4191 nd4192 9.863669807754e+00
RINT26284 nd4192 nd4193 5.711646824659e+01
RINT26285 nd4193 nd4194 7.751520690609e+01
RINT26286 nd4194 nd4195 5.711646824659e+01
RINT26287 nd4195 nd4196 5.711646824659e+01
RINT26288 nd4196 nd4197 5.711646824659e+01
RINT26289 nd4197 nd4198 5.711646824659e+01
RINT26290 nd4198 nd4199 5.711646824659e+01
RINT26291 nd4199 nd4200 5.711646824659e+01
RINT26292 nd4200 nd4201 1.570702876781e+02
RINT26293 nd4201 nd4202 2.570241071097e+02
RINT26294 nd4202 nd4203 1.286757122520e+02
RINT26295 nd4203 nd4204 1.587979254183e+00
RINT26296 nd4204 nd4205 2.753470604119e+01
RINT26297 nd4205 nd4206 2.708952493981e+01
RINT26298 nd4206 nd4207 1.958278911312e+00
RINT26299 nd4207 nd4208 1.958278911312e+00
RINT26300 nd4208 nd4209 1.958278911312e+00
RINT26301 nd4209 nd4210 1.958278911312e+00
RINT26302 nd4210 nd4211 1.958278911312e+00
RINT26303 nd4211 nd4212 1.958278911312e+00
RINT26304 nd4212 nd4213 1.958278911312e+00
RINT26305 nd4213 nd4214 1.958278911312e+00
RINT26306 nd4214 nd4215 1.958278911312e+00
RINT26307 nd4216 nd4217 1.732116531491e+01
RINT26308 nd4217 nd4218 1.574448942870e+01
RINT26309 nd4218 nd4219 5.321875196883e+02
RINT26310 nd4219 nd4220 5.411956904962e+02
RINT26311 nd4220 nd4221 3.319743183927e+01
RINT26312 nd4221 nd4222 3.263403263403e+01
RINT26313 nd4222 nd4223 9.444201631702e+01
RINT26314 nd4223 nd4224 5.468750000000e+02
RINT26315 nd4224 nd4225 7.421875000000e+02
RINT26316 nd4225 nd4226 5.468750000000e+02
RINT26317 nd4226 nd4227 5.468750000000e+02
RINT26318 nd4227 nd4228 5.468750000000e+02
RINT26319 nd4228 nd4229 5.468750000000e+02
RINT26320 nd4229 nd4230 5.468750000000e+02
RINT26321 nd4230 nd4231 5.468750000000e+02
RINT26322 nd4231 nd4232 1.503906250000e+03
RINT26323 nd4232 nd4233 2.460937500000e+03
RINT26324 nd4233 nd4234 1.232035738519e+03
RINT26325 nd4234 nd4235 1.520447922098e+01
RINT26326 nd4235 nd4236 2.636374907017e+02
RINT26327 nd4236 nd4237 2.593750000000e+02
RINT26328 nd4237 nd4238 1.875000000000e+01
RINT26329 nd4238 nd4239 1.875000000000e+01
RINT26330 nd4239 nd4240 1.875000000000e+01
RINT26331 nd4240 nd4241 1.875000000000e+01
RINT26332 nd4241 nd4242 1.875000000000e+01
RINT26333 nd4242 nd4243 1.875000000000e+01
RINT26334 nd4243 nd4244 1.875000000000e+01
RINT26335 nd4244 nd4245 1.875000000000e+01
RINT26336 nd4245 nd4246 1.875000000000e+01
RINT26337 nd4247 nd4248 1.809049213629e+00
RINT26338 nd4248 nd4249 1.644378752938e+00
RINT26339 nd4249 nd4250 5.558248515568e+01
RINT26340 nd4250 nd4251 5.652331240488e+01
RINT26341 nd4251 nd4252 3.467190969629e+00
RINT26342 nd4252 nd4253 3.408348687909e+00
RINT26343 nd4253 nd4254 9.863669807754e+00
RINT26344 nd4254 nd4255 5.711646824659e+01
RINT26345 nd4255 nd4256 7.751520690609e+01
RINT26346 nd4256 nd4257 5.711646824659e+01
RINT26347 nd4257 nd4258 5.711646824659e+01
RINT26348 nd4258 nd4259 5.711646824659e+01
RINT26349 nd4259 nd4260 5.711646824659e+01
RINT26350 nd4260 nd4261 5.711646824659e+01
RINT26351 nd4261 nd4262 5.711646824659e+01
RINT26352 nd4262 nd4263 1.570702876781e+02
RINT26353 nd4263 nd4264 2.570241071097e+02
RINT26354 nd4264 nd4265 1.286757122520e+02
RINT26355 nd4265 nd4266 1.587979254183e+00
RINT26356 nd4266 nd4267 2.753470604119e+01
RINT26357 nd4267 nd4268 2.708952493981e+01
RINT26358 nd4268 nd4269 1.958278911312e+00
RINT26359 nd4269 nd4270 1.958278911312e+00
RINT26360 nd4270 nd4271 1.958278911312e+00
RINT26361 nd4271 nd4272 1.958278911312e+00
RINT26362 nd4272 nd4273 1.958278911312e+00
RINT26363 nd4273 nd4274 1.958278911312e+00
RINT26364 nd4274 nd4275 1.958278911312e+00
RINT26365 nd4275 nd4276 1.958278911312e+00
RINT26366 nd4276 nd4277 1.958278911312e+00
RINT26367 nd4278 nd4279 1.809049213629e+00
RINT26368 nd4279 nd4280 1.644378752938e+00
RINT26369 nd4280 nd4281 5.558248515568e+01
RINT26370 nd4281 nd4282 5.652331240488e+01
RINT26371 nd4282 nd4283 3.467190969629e+00
RINT26372 nd4283 nd4284 3.408348687909e+00
RINT26373 nd4284 nd4285 9.863669807754e+00
RINT26374 nd4285 nd4286 5.711646824659e+01
RINT26375 nd4286 nd4287 7.751520690609e+01
RINT26376 nd4287 nd4288 5.711646824659e+01
RINT26377 nd4288 nd4289 5.711646824659e+01
RINT26378 nd4289 nd4290 5.711646824659e+01
RINT26379 nd4290 nd4291 5.711646824659e+01
RINT26380 nd4291 nd4292 5.711646824659e+01
RINT26381 nd4292 nd4293 5.711646824659e+01
RINT26382 nd4293 nd4294 1.570702876781e+02
RINT26383 nd4294 nd4295 2.570241071097e+02
RINT26384 nd4295 nd4296 1.286757122520e+02
RINT26385 nd4296 nd4297 1.587979254183e+00
RINT26386 nd4297 nd4298 2.753470604119e+01
RINT26387 nd4298 nd4299 2.708952493981e+01
RINT26388 nd4299 nd4300 1.958278911312e+00
RINT26389 nd4300 nd4301 1.958278911312e+00
RINT26390 nd4301 nd4302 1.958278911312e+00
RINT26391 nd4302 nd4303 1.958278911312e+00
RINT26392 nd4303 nd4304 1.958278911312e+00
RINT26393 nd4304 nd4305 1.958278911312e+00
RINT26394 nd4305 nd4306 1.958278911312e+00
RINT26395 nd4306 nd4307 1.958278911312e+00
RINT26396 nd4307 nd4308 1.958278911312e+00
RINT26397 nd4309 nd4310 1.809049213629e+00
RINT26398 nd4310 nd4311 1.644378752938e+00
RINT26399 nd4311 nd4312 5.558248515568e+01
RINT26400 nd4312 nd4313 5.652331240488e+01
RINT26401 nd4313 nd4314 3.467190969629e+00
RINT26402 nd4314 nd4315 3.408348687909e+00
RINT26403 nd4315 nd4316 9.863669807754e+00
RINT26404 nd4316 nd4317 5.711646824659e+01
RINT26405 nd4317 nd4318 7.751520690609e+01
RINT26406 nd4318 nd4319 5.711646824659e+01
RINT26407 nd4319 nd4320 5.711646824659e+01
RINT26408 nd4320 nd4321 5.711646824659e+01
RINT26409 nd4321 nd4322 5.711646824659e+01
RINT26410 nd4322 nd4323 5.711646824659e+01
RINT26411 nd4323 nd4324 5.711646824659e+01
RINT26412 nd4324 nd4325 1.570702876781e+02
RINT26413 nd4325 nd4326 2.570241071097e+02
RINT26414 nd4326 nd4327 1.286757122520e+02
RINT26415 nd4327 nd4328 1.587979254183e+00
RINT26416 nd4328 nd4329 2.753470604119e+01
RINT26417 nd4329 nd4330 2.708952493981e+01
RINT26418 nd4330 nd4331 1.958278911312e+00
RINT26419 nd4331 nd4332 1.958278911312e+00
RINT26420 nd4332 nd4333 1.958278911312e+00
RINT26421 nd4333 nd4334 1.958278911312e+00
RINT26422 nd4334 nd4335 1.958278911312e+00
RINT26423 nd4335 nd4336 1.958278911312e+00
RINT26424 nd4336 nd4337 1.958278911312e+00
RINT26425 nd4337 nd4338 1.958278911312e+00
RINT26426 nd4338 nd4339 1.958278911312e+00
RINT26427 nd4340 nd4341 1.809049213629e+00
RINT26428 nd4341 nd4342 1.644378752938e+00
RINT26429 nd4342 nd4343 5.558248515568e+01
RINT26430 nd4343 nd4344 5.652331240488e+01
RINT26431 nd4344 nd4345 3.467190969629e+00
RINT26432 nd4345 nd4346 3.408348687909e+00
RINT26433 nd4346 nd4347 9.863669807754e+00
RINT26434 nd4347 nd4348 5.711646824659e+01
RINT26435 nd4348 nd4349 7.751520690609e+01
RINT26436 nd4349 nd4350 5.711646824659e+01
RINT26437 nd4350 nd4351 5.711646824659e+01
RINT26438 nd4351 nd4352 5.711646824659e+01
RINT26439 nd4352 nd4353 5.711646824659e+01
RINT26440 nd4353 nd4354 5.711646824659e+01
RINT26441 nd4354 nd4355 5.711646824659e+01
RINT26442 nd4355 nd4356 1.570702876781e+02
RINT26443 nd4356 nd4357 2.570241071097e+02
RINT26444 nd4357 nd4358 1.286757122520e+02
RINT26445 nd4358 nd4359 1.587979254183e+00
RINT26446 nd4359 nd4360 2.753470604119e+01
RINT26447 nd4360 nd4361 2.708952493981e+01
RINT26448 nd4361 nd4362 1.958278911312e+00
RINT26449 nd4362 nd4363 1.958278911312e+00
RINT26450 nd4363 nd4364 1.958278911312e+00
RINT26451 nd4364 nd4365 1.958278911312e+00
RINT26452 nd4365 nd4366 1.958278911312e+00
RINT26453 nd4366 nd4367 1.958278911312e+00
RINT26454 nd4367 nd4368 1.958278911312e+00
RINT26455 nd4368 nd4369 1.958278911312e+00
RINT26456 nd4369 nd4370 1.958278911312e+00
RINT26457 nd4371 nd4372 1.809049213629e+00
RINT26458 nd4372 nd4373 1.644378752938e+00
RINT26459 nd4373 nd4374 5.558248515568e+01
RINT26460 nd4374 nd4375 5.652331240488e+01
RINT26461 nd4375 nd4376 3.467190969629e+00
RINT26462 nd4376 nd4377 3.408348687909e+00
RINT26463 nd4377 nd4378 9.863669807754e+00
RINT26464 nd4378 nd4379 5.711646824659e+01
RINT26465 nd4379 nd4380 7.751520690609e+01
RINT26466 nd4380 nd4381 5.711646824659e+01
RINT26467 nd4381 nd4382 5.711646824659e+01
RINT26468 nd4382 nd4383 5.711646824659e+01
RINT26469 nd4383 nd4384 5.711646824659e+01
RINT26470 nd4384 nd4385 5.711646824659e+01
RINT26471 nd4385 nd4386 5.711646824659e+01
RINT26472 nd4386 nd4387 1.570702876781e+02
RINT26473 nd4387 nd4388 2.570241071097e+02
RINT26474 nd4388 nd4389 1.286757122520e+02
RINT26475 nd4389 nd4390 1.587979254183e+00
RINT26476 nd4390 nd4391 2.753470604119e+01
RINT26477 nd4391 nd4392 2.708952493981e+01
RINT26478 nd4392 nd4393 1.958278911312e+00
RINT26479 nd4393 nd4394 1.958278911312e+00
RINT26480 nd4394 nd4395 1.958278911312e+00
RINT26481 nd4395 nd4396 1.958278911312e+00
RINT26482 nd4396 nd4397 1.958278911312e+00
RINT26483 nd4397 nd4398 1.958278911312e+00
RINT26484 nd4398 nd4399 1.958278911312e+00
RINT26485 nd4399 nd4400 1.958278911312e+00
RINT26486 nd4400 nd4401 1.958278911312e+00
RINT26487 nd4402 nd4403 1.809049213629e+00
RINT26488 nd4403 nd4404 1.644378752938e+00
RINT26489 nd4404 nd4405 5.558248515568e+01
RINT26490 nd4405 nd4406 5.652331240488e+01
RINT26491 nd4406 nd4407 3.467190969629e+00
RINT26492 nd4407 nd4408 3.408348687909e+00
RINT26493 nd4408 nd4409 9.863669807754e+00
RINT26494 nd4409 nd4410 5.711646824659e+01
RINT26495 nd4410 nd4411 7.751520690609e+01
RINT26496 nd4411 nd4412 5.711646824659e+01
RINT26497 nd4412 nd4413 5.711646824659e+01
RINT26498 nd4413 nd4414 5.711646824659e+01
RINT26499 nd4414 nd4415 5.711646824659e+01
RINT26500 nd4415 nd4416 5.711646824659e+01
RINT26501 nd4416 nd4417 5.711646824659e+01
RINT26502 nd4417 nd4418 1.570702876781e+02
RINT26503 nd4418 nd4419 2.570241071097e+02
RINT26504 nd4419 nd4420 1.286757122520e+02
RINT26505 nd4420 nd4421 1.587979254183e+00
RINT26506 nd4421 nd4422 2.753470604119e+01
RINT26507 nd4422 nd4423 2.708952493981e+01
RINT26508 nd4423 nd4424 1.958278911312e+00
RINT26509 nd4424 nd4425 1.958278911312e+00
RINT26510 nd4425 nd4426 1.958278911312e+00
RINT26511 nd4426 nd4427 1.958278911312e+00
RINT26512 nd4427 nd4428 1.958278911312e+00
RINT26513 nd4428 nd4429 1.958278911312e+00
RINT26514 nd4429 nd4430 1.958278911312e+00
RINT26515 nd4430 nd4431 1.958278911312e+00
RINT26516 nd4431 nd4432 1.958278911312e+00
RINT26517 nd4433 nd4434 1.732116531491e+01
RINT26518 nd4434 nd4435 1.574448942870e+01
RINT26519 nd4435 nd4436 5.321875196883e+02
RINT26520 nd4436 nd4437 5.411956904962e+02
RINT26521 nd4437 nd4438 3.319743183927e+01
RINT26522 nd4438 nd4439 3.263403263403e+01
RINT26523 nd4439 nd4440 9.444201631702e+01
RINT26524 nd4440 nd4441 5.468750000000e+02
RINT26525 nd4441 nd4442 7.421875000000e+02
RINT26526 nd4442 nd4443 5.468750000000e+02
RINT26527 nd4443 nd4444 5.468750000000e+02
RINT26528 nd4444 nd4445 5.468750000000e+02
RINT26529 nd4445 nd4446 5.468750000000e+02
RINT26530 nd4446 nd4447 5.468750000000e+02
RINT26531 nd4447 nd4448 5.468750000000e+02
RINT26532 nd4448 nd4449 1.503906250000e+03
RINT26533 nd4449 nd4450 2.460937500000e+03
RINT26534 nd4450 nd4451 1.232035738519e+03
RINT26535 nd4451 nd4452 1.520447922098e+01
RINT26536 nd4452 nd4453 2.636374907017e+02
RINT26537 nd4453 nd4454 2.593750000000e+02
RINT26538 nd4454 nd4455 1.875000000000e+01
RINT26539 nd4455 nd4456 1.875000000000e+01
RINT26540 nd4456 nd4457 1.875000000000e+01
RINT26541 nd4457 nd4458 1.875000000000e+01
RINT26542 nd4458 nd4459 1.875000000000e+01
RINT26543 nd4459 nd4460 1.875000000000e+01
RINT26544 nd4460 nd4461 1.875000000000e+01
RINT26545 nd4461 nd4462 1.875000000000e+01
RINT26546 nd4462 nd4463 1.875000000000e+01
RINT26547 nd4464 nd4465 2.356247123801e+00
RINT26548 nd4465 nd4466 2.141767442179e+00
RINT26549 nd4466 nd4467 7.239497399800e+01
RINT26550 nd4467 nd4468 7.362038095942e+01
RINT26551 nd4468 nd4469 4.515940577133e+00
RINT26552 nd4469 nd4470 4.439299789244e+00
RINT26553 nd4470 nd4471 2.381593738975e+00
RINT26554 nd4471 nd4472 1.133606910468e+00
RINT26555 nd4472 nd4473 1.538466521349e+00
RINT26556 nd4473 nd4474 1.133606910468e+00
RINT26557 nd4474 nd4475 1.133606910468e+00
RINT26558 nd4475 nd4476 1.133606910468e+00
RINT26559 nd4476 nd4477 1.133606910468e+00
RINT26560 nd4477 nd4478 1.133606910468e+00
RINT26561 nd4478 nd4479 1.133606910468e+00
RINT26562 nd4479 nd4480 3.117419003786e+00
RINT26563 nd4480 nd4481 5.101231097105e+00
RINT26564 nd4481 nd4482 2.763777430240e+00
RINT26565 nd4482 nd4483 2.068308325796e+00
RINT26566 nd4483 nd4484 3.586335375814e+01
RINT26567 nd4484 nd4485 3.528351508831e+01
RINT26568 nd4485 nd4486 2.550615548552e+00
RINT26569 nd4486 nd4487 2.550615548552e+00
RINT26570 nd4487 nd4488 2.550615548552e+00
RINT26571 nd4488 nd4489 2.550615548552e+00
RINT26572 nd4489 nd4490 2.550615548552e+00
RINT26573 nd4490 nd4491 2.550615548552e+00
RINT26574 nd4491 nd4492 2.550615548552e+00
RINT26575 nd4492 nd4493 2.550615548552e+00
RINT26576 nd4493 nd4494 2.550615548552e+00
RINT26577 nd4495 nd4496 2.356247123801e+00
RINT26578 nd4496 nd4497 2.141767442179e+00
RINT26579 nd4497 nd4498 7.239497399800e+01
RINT26580 nd4498 nd4499 7.362038095942e+01
RINT26581 nd4499 nd4500 4.515940577133e+00
RINT26582 nd4500 nd4501 4.439299789244e+00
RINT26583 nd4501 nd4502 2.381593738975e+00
RINT26584 nd4502 nd4503 1.133606910468e+00
RINT26585 nd4503 nd4504 1.538466521349e+00
RINT26586 nd4504 nd4505 1.133606910468e+00
RINT26587 nd4505 nd4506 1.133606910468e+00
RINT26588 nd4506 nd4507 1.133606910468e+00
RINT26589 nd4507 nd4508 1.133606910468e+00
RINT26590 nd4508 nd4509 1.133606910468e+00
RINT26591 nd4509 nd4510 1.133606910468e+00
RINT26592 nd4510 nd4511 3.117419003786e+00
RINT26593 nd4511 nd4512 5.101231097105e+00
RINT26594 nd4512 nd4513 2.763777430240e+00
RINT26595 nd4513 nd4514 2.068308325796e+00
RINT26596 nd4514 nd4515 3.586335375814e+01
RINT26597 nd4515 nd4516 3.528351508831e+01
RINT26598 nd4516 nd4517 2.550615548552e+00
RINT26599 nd4517 nd4518 2.550615548552e+00
RINT26600 nd4518 nd4519 2.550615548552e+00
RINT26601 nd4519 nd4520 2.550615548552e+00
RINT26602 nd4520 nd4521 2.550615548552e+00
RINT26603 nd4521 nd4522 2.550615548552e+00
RINT26604 nd4522 nd4523 2.550615548552e+00
RINT26605 nd4523 nd4524 2.550615548552e+00
RINT26606 nd4524 nd4525 2.550615548552e+00
RINT26607 nd4526 nd4527 2.356247123801e+00
RINT26608 nd4527 nd4528 2.141767442179e+00
RINT26609 nd4528 nd4529 7.239497399800e+01
RINT26610 nd4529 nd4530 7.362038095942e+01
RINT26611 nd4530 nd4531 4.515940577133e+00
RINT26612 nd4531 nd4532 4.439299789244e+00
RINT26613 nd4532 nd4533 2.381593738975e+00
RINT26614 nd4533 nd4534 1.133606910468e+00
RINT26615 nd4534 nd4535 1.538466521349e+00
RINT26616 nd4535 nd4536 1.133606910468e+00
RINT26617 nd4536 nd4537 1.133606910468e+00
RINT26618 nd4537 nd4538 1.133606910468e+00
RINT26619 nd4538 nd4539 1.133606910468e+00
RINT26620 nd4539 nd4540 1.133606910468e+00
RINT26621 nd4540 nd4541 1.133606910468e+00
RINT26622 nd4541 nd4542 3.117419003786e+00
RINT26623 nd4542 nd4543 5.101231097105e+00
RINT26624 nd4543 nd4544 2.763777430240e+00
RINT26625 nd4544 nd4545 2.068308325796e+00
RINT26626 nd4545 nd4546 3.586335375814e+01
RINT26627 nd4546 nd4547 3.528351508831e+01
RINT26628 nd4547 nd4548 2.550615548552e+00
RINT26629 nd4548 nd4549 2.550615548552e+00
RINT26630 nd4549 nd4550 2.550615548552e+00
RINT26631 nd4550 nd4551 2.550615548552e+00
RINT26632 nd4551 nd4552 2.550615548552e+00
RINT26633 nd4552 nd4553 2.550615548552e+00
RINT26634 nd4553 nd4554 2.550615548552e+00
RINT26635 nd4554 nd4555 2.550615548552e+00
RINT26636 nd4555 nd4556 2.550615548552e+00
RINT26637 nd4557 nd4558 2.493313941068e-01
RINT26638 nd4558 nd4559 2.266357619356e-01
RINT26639 nd4559 nd4560 7.660631014006e+00
RINT26640 nd4560 nd4561 7.790300106417e+00
RINT26641 nd4561 nd4562 4.778640357485e-01
RINT26642 nd4562 nd4563 4.697541247393e-01
RINT26643 nd4563 nd4564 2.520135011038e-01
RINT26644 nd4564 nd4565 1.199550711388e-01
RINT26645 nd4565 nd4566 1.627961679741e-01
RINT26646 nd4566 nd4567 1.199550711388e-01
RINT26647 nd4567 nd4568 1.199550711388e-01
RINT26648 nd4568 nd4569 1.199550711388e-01
RINT26649 nd4569 nd4570 1.199550711388e-01
RINT26650 nd4570 nd4571 1.199550711388e-01
RINT26651 nd4571 nd4572 1.199550711388e-01
RINT26652 nd4572 nd4573 3.298764456317e-01
RINT26653 nd4573 nd4574 5.397978201245e-01
RINT26654 nd4574 nd4575 2.924550963786e-01
RINT26655 nd4575 nd4576 2.188625263897e-01
RINT26656 nd4576 nd4577 3.794958474237e+00
RINT26657 nd4577 nd4578 3.733601589195e+00
RINT26658 nd4578 nd4579 2.698989100623e-01
RINT26659 nd4579 nd4580 2.698989100623e-01
RINT26660 nd4580 nd4581 2.698989100623e-01
RINT26661 nd4581 nd4582 2.698989100623e-01
RINT26662 nd4582 nd4583 2.698989100623e-01
RINT26663 nd4583 nd4584 2.698989100623e-01
RINT26664 nd4584 nd4585 2.698989100623e-01
RINT26665 nd4585 nd4586 2.698989100623e-01
RINT26666 nd4586 nd4587 2.698989100623e-01
RINT26667 nd4588 nd4589 2.493313941068e-01
RINT26668 nd4589 nd4590 2.266357619356e-01
RINT26669 nd4590 nd4591 7.660631014006e+00
RINT26670 nd4591 nd4592 7.790300106417e+00
RINT26671 nd4592 nd4593 4.778640357485e-01
RINT26672 nd4593 nd4594 4.697541247393e-01
RINT26673 nd4594 nd4595 2.520135011038e-01
RINT26674 nd4595 nd4596 1.199550711388e-01
RINT26675 nd4596 nd4597 1.627961679741e-01
RINT26676 nd4597 nd4598 1.199550711388e-01
RINT26677 nd4598 nd4599 1.199550711388e-01
RINT26678 nd4599 nd4600 1.199550711388e-01
RINT26679 nd4600 nd4601 1.199550711388e-01
RINT26680 nd4601 nd4602 1.199550711388e-01
RINT26681 nd4602 nd4603 1.199550711388e-01
RINT26682 nd4603 nd4604 3.298764456317e-01
RINT26683 nd4604 nd4605 5.397978201245e-01
RINT26684 nd4605 nd4606 2.924550963786e-01
RINT26685 nd4606 nd4607 2.188625263897e-01
RINT26686 nd4607 nd4608 3.794958474237e+00
RINT26687 nd4608 nd4609 3.733601589195e+00
RINT26688 nd4609 nd4610 2.698989100623e-01
RINT26689 nd4610 nd4611 2.698989100623e-01
RINT26690 nd4611 nd4612 2.698989100623e-01
RINT26691 nd4612 nd4613 2.698989100623e-01
RINT26692 nd4613 nd4614 2.698989100623e-01
RINT26693 nd4614 nd4615 2.698989100623e-01
RINT26694 nd4615 nd4616 2.698989100623e-01
RINT26695 nd4616 nd4617 2.698989100623e-01
RINT26696 nd4617 nd4618 2.698989100623e-01
RINT26697 nd4619 nd4620 2.493313941068e-01
RINT26698 nd4620 nd4621 2.266357619356e-01
RINT26699 nd4621 nd4622 7.660631014006e+00
RINT26700 nd4622 nd4623 7.790300106417e+00
RINT26701 nd4623 nd4624 4.778640357485e-01
RINT26702 nd4624 nd4625 4.697541247393e-01
RINT26703 nd4625 nd4626 2.520135011038e-01
RINT26704 nd4626 nd4627 1.199550711388e-01
RINT26705 nd4627 nd4628 1.627961679741e-01
RINT26706 nd4628 nd4629 1.199550711388e-01
RINT26707 nd4629 nd4630 1.199550711388e-01
RINT26708 nd4630 nd4631 1.199550711388e-01
RINT26709 nd4631 nd4632 1.199550711388e-01
RINT26710 nd4632 nd4633 1.199550711388e-01
RINT26711 nd4633 nd4634 1.199550711388e-01
RINT26712 nd4634 nd4635 3.298764456317e-01
RINT26713 nd4635 nd4636 5.397978201245e-01
RINT26714 nd4636 nd4637 2.924550963786e-01
RINT26715 nd4637 nd4638 2.188625263897e-01
RINT26716 nd4638 nd4639 3.794958474237e+00
RINT26717 nd4639 nd4640 3.733601589195e+00
RINT26718 nd4640 nd4641 2.698989100623e-01
RINT26719 nd4641 nd4642 2.698989100623e-01
RINT26720 nd4642 nd4643 2.698989100623e-01
RINT26721 nd4643 nd4644 2.698989100623e-01
RINT26722 nd4644 nd4645 2.698989100623e-01
RINT26723 nd4645 nd4646 2.698989100623e-01
RINT26724 nd4646 nd4647 2.698989100623e-01
RINT26725 nd4647 nd4648 2.698989100623e-01
RINT26726 nd4648 nd4649 2.698989100623e-01
RINT26727 nd4650 nd4651 1.832876633312e+00
RINT26728 nd4651 nd4652 1.666037258616e+00
RINT26729 nd4652 nd4653 5.631457535580e+01
RINT26730 nd4653 nd4654 5.726779446562e+01
RINT26731 nd4654 nd4655 3.512858170793e+00
RINT26732 nd4655 nd4656 3.453240863313e+00
RINT26733 nd4656 nd4657 9.993586560904e+00
RINT26734 nd4657 nd4658 5.786876290473e+01
RINT26735 nd4658 nd4659 7.853617822785e+01
RINT26736 nd4659 nd4660 5.786876290473e+01
RINT26737 nd4660 nd4661 5.786876290473e+01
RINT26738 nd4661 nd4662 5.786876290473e+01
RINT26739 nd4662 nd4663 5.786876290473e+01
RINT26740 nd4663 nd4664 5.786876290473e+01
RINT26741 nd4664 nd4665 5.786876290473e+01
RINT26742 nd4665 nd4666 1.591390979880e+02
RINT26743 nd4666 nd4667 2.604094330713e+02
RINT26744 nd4667 nd4668 1.303705308206e+02
RINT26745 nd4668 nd4669 1.608894908578e+00
RINT26746 nd4669 nd4670 2.789737223720e+01
RINT26747 nd4670 nd4671 2.744632754910e+01
RINT26748 nd4671 nd4672 1.984071871019e+00
RINT26749 nd4672 nd4673 1.984071871019e+00
RINT26750 nd4673 nd4674 1.984071871019e+00
RINT26751 nd4674 nd4675 1.984071871019e+00
RINT26752 nd4675 nd4676 1.984071871019e+00
RINT26753 nd4676 nd4677 1.984071871019e+00
RINT26754 nd4677 nd4678 1.984071871019e+00
RINT26755 nd4678 nd4679 1.984071871019e+00
RINT26756 nd4679 nd4680 1.984071871019e+00
RINT26757 nd4681 nd4682 1.914284617627e-01
RINT26758 nd4682 nd4683 1.740035002137e-01
RINT26759 nd4683 nd4684 5.881581083666e+00
RINT26760 nd4684 nd4685 5.981136757300e+00
RINT26761 nd4685 nd4686 3.668883239623e-01
RINT26762 nd4686 nd4687 3.606618004430e-01
RINT26763 nd4687 nd4688 1.976741618838e-01
RINT26764 nd4688 nd4689 8.656063970739e-02
RINT26765 nd4689 nd4690 1.760179307529e-01
RINT26766 nd4690 nd4691 2.136011054157e-01
RINT26767 nd4691 nd4692 2.136011054157e-01
RINT26768 nd4692 nd4693 2.136011054157e-01
RINT26769 nd4693 nd4694 2.136011054157e-01
RINT26770 nd4694 nd4695 2.136011054157e-01
RINT26771 nd4695 nd4696 2.136011054157e-01
RINT26772 nd4696 nd4697 2.884961700761e-01
RINT26773 nd4697 nd4698 4.298149835847e-01
RINT26774 nd4698 nd4699 2.654372658145e-01
RINT26775 nd4699 nd4700 1.680354650659e-01
RINT26776 nd4700 nd4701 2.913644572433e+00
RINT26777 nd4701 nd4702 2.866536769726e+00
RINT26778 nd4702 nd4703 2.072195255224e-01
RINT26779 nd4703 nd4704 2.072195255224e-01
RINT26780 nd4704 nd4705 2.072195255224e-01
RINT26781 nd4705 nd4706 2.072195255224e-01
RINT26782 nd4706 nd4707 2.072195255224e-01
RINT26783 nd4707 nd4708 2.072195255224e-01
RINT26784 nd4708 nd4709 2.072195255224e-01
RINT26785 nd4709 nd4710 2.072195255224e-01
RINT26786 nd4710 nd4711 2.072195255224e-01
RINT26787 nd4712 nd4713 1.914284617627e-01
RINT26788 nd4713 nd4714 1.740035002137e-01
RINT26789 nd4714 nd4715 5.881581083666e+00
RINT26790 nd4715 nd4716 5.981136757300e+00
RINT26791 nd4716 nd4717 3.668883239623e-01
RINT26792 nd4717 nd4718 3.606618004430e-01
RINT26793 nd4718 nd4719 1.976741618838e-01
RINT26794 nd4719 nd4720 8.656063970739e-02
RINT26795 nd4720 nd4721 1.760179307529e-01
RINT26796 nd4721 nd4722 2.136011054157e-01
RINT26797 nd4722 nd4723 2.136011054157e-01
RINT26798 nd4723 nd4724 2.136011054157e-01
RINT26799 nd4724 nd4725 2.136011054157e-01
RINT26800 nd4725 nd4726 2.136011054157e-01
RINT26801 nd4726 nd4727 2.136011054157e-01
RINT26802 nd4727 nd4728 2.884961700761e-01
RINT26803 nd4728 nd4729 4.298149835847e-01
RINT26804 nd4729 nd4730 2.654372658145e-01
RINT26805 nd4730 nd4731 1.680354650659e-01
RINT26806 nd4731 nd4732 2.913644572433e+00
RINT26807 nd4732 nd4733 2.866536769726e+00
RINT26808 nd4733 nd4734 2.072195255224e-01
RINT26809 nd4734 nd4735 2.072195255224e-01
RINT26810 nd4735 nd4736 2.072195255224e-01
RINT26811 nd4736 nd4737 2.072195255224e-01
RINT26812 nd4737 nd4738 2.072195255224e-01
RINT26813 nd4738 nd4739 2.072195255224e-01
RINT26814 nd4739 nd4740 2.072195255224e-01
RINT26815 nd4740 nd4741 2.072195255224e-01
RINT26816 nd4741 nd4742 2.072195255224e-01
RINT26817 nd4743 nd4744 1.914284617627e-01
RINT26818 nd4744 nd4745 1.740035002137e-01
RINT26819 nd4745 nd4746 5.881581083666e+00
RINT26820 nd4746 nd4747 5.981136757300e+00
RINT26821 nd4747 nd4748 3.668883239623e-01
RINT26822 nd4748 nd4749 3.606618004430e-01
RINT26823 nd4749 nd4750 1.976741618838e-01
RINT26824 nd4750 nd4751 8.656063970739e-02
RINT26825 nd4751 nd4752 1.760179307529e-01
RINT26826 nd4752 nd4753 2.136011054157e-01
RINT26827 nd4753 nd4754 2.136011054157e-01
RINT26828 nd4754 nd4755 2.136011054157e-01
RINT26829 nd4755 nd4756 2.136011054157e-01
RINT26830 nd4756 nd4757 2.136011054157e-01
RINT26831 nd4757 nd4758 2.136011054157e-01
RINT26832 nd4758 nd4759 2.884961700761e-01
RINT26833 nd4759 nd4760 4.298149835847e-01
RINT26834 nd4760 nd4761 2.654372658145e-01
RINT26835 nd4761 nd4762 1.680354650659e-01
RINT26836 nd4762 nd4763 2.913644572433e+00
RINT26837 nd4763 nd4764 2.866536769726e+00
RINT26838 nd4764 nd4765 2.072195255224e-01
RINT26839 nd4765 nd4766 2.072195255224e-01
RINT26840 nd4766 nd4767 2.072195255224e-01
RINT26841 nd4767 nd4768 2.072195255224e-01
RINT26842 nd4768 nd4769 2.072195255224e-01
RINT26843 nd4769 nd4770 2.072195255224e-01
RINT26844 nd4770 nd4771 2.072195255224e-01
RINT26845 nd4771 nd4772 2.072195255224e-01
RINT26846 nd4772 nd4773 2.072195255224e-01
RINT26847 nd4774 nd4775 1.914284617627e-01
RINT26848 nd4775 nd4776 1.740035002137e-01
RINT26849 nd4776 nd4777 5.881581083666e+00
RINT26850 nd4777 nd4778 5.981136757300e+00
RINT26851 nd4778 nd4779 3.668883239623e-01
RINT26852 nd4779 nd4780 3.606618004430e-01
RINT26853 nd4780 nd4781 1.976741618838e-01
RINT26854 nd4781 nd4782 8.656063970739e-02
RINT26855 nd4782 nd4783 1.760179307529e-01
RINT26856 nd4783 nd4784 2.136011054157e-01
RINT26857 nd4784 nd4785 2.136011054157e-01
RINT26858 nd4785 nd4786 2.136011054157e-01
RINT26859 nd4786 nd4787 2.136011054157e-01
RINT26860 nd4787 nd4788 2.136011054157e-01
RINT26861 nd4788 nd4789 2.136011054157e-01
RINT26862 nd4789 nd4790 2.884961700761e-01
RINT26863 nd4790 nd4791 4.298149835847e-01
RINT26864 nd4791 nd4792 2.654372658145e-01
RINT26865 nd4792 nd4793 1.680354650659e-01
RINT26866 nd4793 nd4794 2.913644572433e+00
RINT26867 nd4794 nd4795 2.866536769726e+00
RINT26868 nd4795 nd4796 2.072195255224e-01
RINT26869 nd4796 nd4797 2.072195255224e-01
RINT26870 nd4797 nd4798 2.072195255224e-01
RINT26871 nd4798 nd4799 2.072195255224e-01
RINT26872 nd4799 nd4800 2.072195255224e-01
RINT26873 nd4800 nd4801 2.072195255224e-01
RINT26874 nd4801 nd4802 2.072195255224e-01
RINT26875 nd4802 nd4803 2.072195255224e-01
RINT26876 nd4803 nd4804 2.072195255224e-01
RINT26877 nd4805 nd4806 1.914284617627e-01
RINT26878 nd4806 nd4807 1.740035002137e-01
RINT26879 nd4807 nd4808 5.881581083666e+00
RINT26880 nd4808 nd4809 5.981136757300e+00
RINT26881 nd4809 nd4810 3.668883239623e-01
RINT26882 nd4810 nd4811 3.606618004430e-01
RINT26883 nd4811 nd4812 1.976741618838e-01
RINT26884 nd4812 nd4813 8.656063970739e-02
RINT26885 nd4813 nd4814 1.760179307529e-01
RINT26886 nd4814 nd4815 2.136011054157e-01
RINT26887 nd4815 nd4816 2.136011054157e-01
RINT26888 nd4816 nd4817 2.136011054157e-01
RINT26889 nd4817 nd4818 2.136011054157e-01
RINT26890 nd4818 nd4819 2.136011054157e-01
RINT26891 nd4819 nd4820 2.136011054157e-01
RINT26892 nd4820 nd4821 2.884961700761e-01
RINT26893 nd4821 nd4822 4.298149835847e-01
RINT26894 nd4822 nd4823 2.654372658145e-01
RINT26895 nd4823 nd4824 1.680354650659e-01
RINT26896 nd4824 nd4825 2.913644572433e+00
RINT26897 nd4825 nd4826 2.866536769726e+00
RINT26898 nd4826 nd4827 2.072195255224e-01
RINT26899 nd4827 nd4828 2.072195255224e-01
RINT26900 nd4828 nd4829 2.072195255224e-01
RINT26901 nd4829 nd4830 2.072195255224e-01
RINT26902 nd4830 nd4831 2.072195255224e-01
RINT26903 nd4831 nd4832 2.072195255224e-01
RINT26904 nd4832 nd4833 2.072195255224e-01
RINT26905 nd4833 nd4834 2.072195255224e-01
RINT26906 nd4834 nd4835 2.072195255224e-01
RINT26907 nd4836 nd4837 1.914284617627e-01
RINT26908 nd4837 nd4838 1.740035002137e-01
RINT26909 nd4838 nd4839 5.881581083666e+00
RINT26910 nd4839 nd4840 5.981136757300e+00
RINT26911 nd4840 nd4841 3.668883239623e-01
RINT26912 nd4841 nd4842 3.606618004430e-01
RINT26913 nd4842 nd4843 1.976741618838e-01
RINT26914 nd4843 nd4844 8.656063970739e-02
RINT26915 nd4844 nd4845 1.760179307529e-01
RINT26916 nd4845 nd4846 2.136011054157e-01
RINT26917 nd4846 nd4847 2.136011054157e-01
RINT26918 nd4847 nd4848 2.136011054157e-01
RINT26919 nd4848 nd4849 2.136011054157e-01
RINT26920 nd4849 nd4850 2.136011054157e-01
RINT26921 nd4850 nd4851 2.136011054157e-01
RINT26922 nd4851 nd4852 2.884961700761e-01
RINT26923 nd4852 nd4853 4.298149835847e-01
RINT26924 nd4853 nd4854 2.654372658145e-01
RINT26925 nd4854 nd4855 1.680354650659e-01
RINT26926 nd4855 nd4856 2.913644572433e+00
RINT26927 nd4856 nd4857 2.866536769726e+00
RINT26928 nd4857 nd4858 2.072195255224e-01
RINT26929 nd4858 nd4859 2.072195255224e-01
RINT26930 nd4859 nd4860 2.072195255224e-01
RINT26931 nd4860 nd4861 2.072195255224e-01
RINT26932 nd4861 nd4862 2.072195255224e-01
RINT26933 nd4862 nd4863 2.072195255224e-01
RINT26934 nd4863 nd4864 2.072195255224e-01
RINT26935 nd4864 nd4865 2.072195255224e-01
RINT26936 nd4865 nd4866 2.072195255224e-01
RINT26937 nd4867 nd4868 1.832876633312e+00
RINT26938 nd4868 nd4869 1.666037258616e+00
RINT26939 nd4869 nd4870 5.631457535579e+01
RINT26940 nd4870 nd4871 5.726779446562e+01
RINT26941 nd4871 nd4872 3.512858170793e+00
RINT26942 nd4872 nd4873 3.453240863313e+00
RINT26943 nd4873 nd4874 9.993586560904e+00
RINT26944 nd4874 nd4875 5.786876290473e+01
RINT26945 nd4875 nd4876 7.853617822785e+01
RINT26946 nd4876 nd4877 5.786876290473e+01
RINT26947 nd4877 nd4878 5.786876290473e+01
RINT26948 nd4878 nd4879 5.786876290473e+01
RINT26949 nd4879 nd4880 5.786876290473e+01
RINT26950 nd4880 nd4881 5.786876290473e+01
RINT26951 nd4881 nd4882 5.786876290473e+01
RINT26952 nd4882 nd4883 1.591390979880e+02
RINT26953 nd4883 nd4884 2.604094330713e+02
RINT26954 nd4884 nd4885 1.303705308206e+02
RINT26955 nd4885 nd4886 1.608894908578e+00
RINT26956 nd4886 nd4887 2.789737223720e+01
RINT26957 nd4887 nd4888 2.744632754910e+01
RINT26958 nd4888 nd4889 1.984071871019e+00
RINT26959 nd4889 nd4890 1.984071871019e+00
RINT26960 nd4890 nd4891 1.984071871019e+00
RINT26961 nd4891 nd4892 1.984071871019e+00
RINT26962 nd4892 nd4893 1.984071871019e+00
RINT26963 nd4893 nd4894 1.984071871019e+00
RINT26964 nd4894 nd4895 1.984071871019e+00
RINT26965 nd4895 nd4896 1.984071871019e+00
RINT26966 nd4896 nd4897 1.984071871019e+00
RINT26967 nd4898 nd4899 1.914284617627e-01
RINT26968 nd4899 nd4900 1.740035002137e-01
RINT26969 nd4900 nd4901 5.881581083666e+00
RINT26970 nd4901 nd4902 5.981136757300e+00
RINT26971 nd4902 nd4903 3.668883239623e-01
RINT26972 nd4903 nd4904 3.606618004430e-01
RINT26973 nd4904 nd4905 1.976741618838e-01
RINT26974 nd4905 nd4906 8.656063970739e-02
RINT26975 nd4906 nd4907 1.760179307529e-01
RINT26976 nd4907 nd4908 2.136011054157e-01
RINT26977 nd4908 nd4909 2.136011054157e-01
RINT26978 nd4909 nd4910 2.136011054157e-01
RINT26979 nd4910 nd4911 2.136011054157e-01
RINT26980 nd4911 nd4912 2.136011054157e-01
RINT26981 nd4912 nd4913 2.136011054157e-01
RINT26982 nd4913 nd4914 2.884961700761e-01
RINT26983 nd4914 nd4915 4.298149835847e-01
RINT26984 nd4915 nd4916 2.654372658145e-01
RINT26985 nd4916 nd4917 1.680354650659e-01
RINT26986 nd4917 nd4918 2.913644572433e+00
RINT26987 nd4918 nd4919 2.866536769726e+00
RINT26988 nd4919 nd4920 2.072195255224e-01
RINT26989 nd4920 nd4921 2.072195255224e-01
RINT26990 nd4921 nd4922 2.072195255224e-01
RINT26991 nd4922 nd4923 2.072195255224e-01
RINT26992 nd4923 nd4924 2.072195255224e-01
RINT26993 nd4924 nd4925 2.072195255224e-01
RINT26994 nd4925 nd4926 2.072195255224e-01
RINT26995 nd4926 nd4927 2.072195255224e-01
RINT26996 nd4927 nd4928 2.072195255224e-01
RINT26997 nd4929 nd4930 1.914284617627e-01
RINT26998 nd4930 nd4931 1.740035002137e-01
RINT26999 nd4931 nd4932 5.881581083666e+00
RINT27000 nd4932 nd4933 5.981136757300e+00
RINT27001 nd4933 nd4934 3.668883239623e-01
RINT27002 nd4934 nd4935 3.606618004430e-01
RINT27003 nd4935 nd4936 1.976741618838e-01
RINT27004 nd4936 nd4937 8.656063970738e-02
RINT27005 nd4937 nd4938 1.760179307529e-01
RINT27006 nd4938 nd4939 2.136011054157e-01
RINT27007 nd4939 nd4940 2.136011054157e-01
RINT27008 nd4940 nd4941 2.136011054157e-01
RINT27009 nd4941 nd4942 2.136011054157e-01
RINT27010 nd4942 nd4943 2.136011054157e-01
RINT27011 nd4943 nd4944 2.136011054157e-01
RINT27012 nd4944 nd4945 2.884961700761e-01
RINT27013 nd4945 nd4946 4.298149835847e-01
RINT27014 nd4946 nd4947 2.654372658145e-01
RINT27015 nd4947 nd4948 1.680354650659e-01
RINT27016 nd4948 nd4949 2.913644572433e+00
RINT27017 nd4949 nd4950 2.866536769726e+00
RINT27018 nd4950 nd4951 2.072195255224e-01
RINT27019 nd4951 nd4952 2.072195255224e-01
RINT27020 nd4952 nd4953 2.072195255224e-01
RINT27021 nd4953 nd4954 2.072195255224e-01
RINT27022 nd4954 nd4955 2.072195255224e-01
RINT27023 nd4955 nd4956 2.072195255224e-01
RINT27024 nd4956 nd4957 2.072195255224e-01
RINT27025 nd4957 nd4958 2.072195255224e-01
RINT27026 nd4958 nd4959 2.072195255224e-01
RINT27027 nd4960 nd4961 1.914284617627e-01
RINT27028 nd4961 nd4962 1.740035002137e-01
RINT27029 nd4962 nd4963 5.881581083666e+00
RINT27030 nd4963 nd4964 5.981136757300e+00
RINT27031 nd4964 nd4965 3.668883239623e-01
RINT27032 nd4965 nd4966 3.606618004430e-01
RINT27033 nd4966 nd4967 1.976741618838e-01
RINT27034 nd4967 nd4968 8.656063970739e-02
RINT27035 nd4968 nd4969 1.760179307529e-01
RINT27036 nd4969 nd4970 2.136011054157e-01
RINT27037 nd4970 nd4971 2.136011054157e-01
RINT27038 nd4971 nd4972 2.136011054157e-01
RINT27039 nd4972 nd4973 2.136011054157e-01
RINT27040 nd4973 nd4974 2.136011054157e-01
RINT27041 nd4974 nd4975 2.136011054157e-01
RINT27042 nd4975 nd4976 2.884961700761e-01
RINT27043 nd4976 nd4977 4.298149835847e-01
RINT27044 nd4977 nd4978 2.654372658145e-01
RINT27045 nd4978 nd4979 1.680354650659e-01
RINT27046 nd4979 nd4980 2.913644572433e+00
RINT27047 nd4980 nd4981 2.866536769726e+00
RINT27048 nd4981 nd4982 2.072195255224e-01
RINT27049 nd4982 nd4983 2.072195255224e-01
RINT27050 nd4983 nd4984 2.072195255224e-01
RINT27051 nd4984 nd4985 2.072195255224e-01
RINT27052 nd4985 nd4986 2.072195255224e-01
RINT27053 nd4986 nd4987 2.072195255224e-01
RINT27054 nd4987 nd4988 2.072195255224e-01
RINT27055 nd4988 nd4989 2.072195255224e-01
RINT27056 nd4989 nd4990 2.072195255224e-01
RINT27057 nd4991 nd4992 1.914284617627e-01
RINT27058 nd4992 nd4993 1.740035002137e-01
RINT27059 nd4993 nd4994 5.881581083666e+00
RINT27060 nd4994 nd4995 5.981136757300e+00
RINT27061 nd4995 nd4996 3.668883239623e-01
RINT27062 nd4996 nd4997 3.606618004430e-01
RINT27063 nd4997 nd4998 1.976741618838e-01
RINT27064 nd4998 nd4999 8.656063970739e-02
RINT27065 nd4999 nd5000 1.760179307529e-01
RINT27066 nd5000 nd5001 2.136011054157e-01
RINT27067 nd5001 nd5002 2.136011054157e-01
RINT27068 nd5002 nd5003 2.136011054157e-01
RINT27069 nd5003 nd5004 2.136011054157e-01
RINT27070 nd5004 nd5005 2.136011054157e-01
RINT27071 nd5005 nd5006 2.136011054157e-01
RINT27072 nd5006 nd5007 2.884961700761e-01
RINT27073 nd5007 nd5008 4.298149835847e-01
RINT27074 nd5008 nd5009 2.654372658145e-01
RINT27075 nd5009 nd5010 1.680354650659e-01
RINT27076 nd5010 nd5011 2.913644572433e+00
RINT27077 nd5011 nd5012 2.866536769726e+00
RINT27078 nd5012 nd5013 2.072195255224e-01
RINT27079 nd5013 nd5014 2.072195255224e-01
RINT27080 nd5014 nd5015 2.072195255224e-01
RINT27081 nd5015 nd5016 2.072195255224e-01
RINT27082 nd5016 nd5017 2.072195255224e-01
RINT27083 nd5017 nd5018 2.072195255224e-01
RINT27084 nd5018 nd5019 2.072195255224e-01
RINT27085 nd5019 nd5020 2.072195255224e-01
RINT27086 nd5020 nd5021 2.072195255224e-01
RINT27087 nd5022 nd5023 1.914284617627e-01
RINT27088 nd5023 nd5024 1.740035002137e-01
RINT27089 nd5024 nd5025 5.881581083666e+00
RINT27090 nd5025 nd5026 5.981136757300e+00
RINT27091 nd5026 nd5027 3.668883239623e-01
RINT27092 nd5027 nd5028 3.606618004430e-01
RINT27093 nd5028 nd5029 1.976741618838e-01
RINT27094 nd5029 nd5030 8.656063970738e-02
RINT27095 nd5030 nd5031 1.760179307529e-01
RINT27096 nd5031 nd5032 2.136011054157e-01
RINT27097 nd5032 nd5033 2.136011054157e-01
RINT27098 nd5033 nd5034 2.136011054157e-01
RINT27099 nd5034 nd5035 2.136011054157e-01
RINT27100 nd5035 nd5036 2.136011054157e-01
RINT27101 nd5036 nd5037 2.136011054157e-01
RINT27102 nd5037 nd5038 2.884961700761e-01
RINT27103 nd5038 nd5039 4.298149835847e-01
RINT27104 nd5039 nd5040 2.654372658145e-01
RINT27105 nd5040 nd5041 1.680354650659e-01
RINT27106 nd5041 nd5042 2.913644572433e+00
RINT27107 nd5042 nd5043 2.866536769726e+00
RINT27108 nd5043 nd5044 2.072195255224e-01
RINT27109 nd5044 nd5045 2.072195255224e-01
RINT27110 nd5045 nd5046 2.072195255224e-01
RINT27111 nd5046 nd5047 2.072195255224e-01
RINT27112 nd5047 nd5048 2.072195255224e-01
RINT27113 nd5048 nd5049 2.072195255224e-01
RINT27114 nd5049 nd5050 2.072195255224e-01
RINT27115 nd5050 nd5051 2.072195255224e-01
RINT27116 nd5051 nd5052 2.072195255224e-01
RINT27117 nd5053 nd5054 1.914284617627e-01
RINT27118 nd5054 nd5055 1.740035002137e-01
RINT27119 nd5055 nd5056 5.881581083666e+00
RINT27120 nd5056 nd5057 5.981136757300e+00
RINT27121 nd5057 nd5058 3.668883239623e-01
RINT27122 nd5058 nd5059 3.606618004430e-01
RINT27123 nd5059 nd5060 1.976741618838e-01
RINT27124 nd5060 nd5061 8.656063970739e-02
RINT27125 nd5061 nd5062 1.760179307529e-01
RINT27126 nd5062 nd5063 2.136011054157e-01
RINT27127 nd5063 nd5064 2.136011054157e-01
RINT27128 nd5064 nd5065 2.136011054157e-01
RINT27129 nd5065 nd5066 2.136011054157e-01
RINT27130 nd5066 nd5067 2.136011054157e-01
RINT27131 nd5067 nd5068 2.136011054157e-01
RINT27132 nd5068 nd5069 2.884961700761e-01
RINT27133 nd5069 nd5070 4.298149835847e-01
RINT27134 nd5070 nd5071 2.654372658145e-01
RINT27135 nd5071 nd5072 1.680354650659e-01
RINT27136 nd5072 nd5073 2.913644572433e+00
RINT27137 nd5073 nd5074 2.866536769726e+00
RINT27138 nd5074 nd5075 2.072195255224e-01
RINT27139 nd5075 nd5076 2.072195255224e-01
RINT27140 nd5076 nd5077 2.072195255224e-01
RINT27141 nd5077 nd5078 2.072195255224e-01
RINT27142 nd5078 nd5079 2.072195255224e-01
RINT27143 nd5079 nd5080 2.072195255224e-01
RINT27144 nd5080 nd5081 2.072195255224e-01
RINT27145 nd5081 nd5082 2.072195255224e-01
RINT27146 nd5082 nd5083 2.072195255224e-01
RINT27147 nd5084 nd5085 1.832876633312e+00
RINT27148 nd5085 nd5086 1.666037258616e+00
RINT27149 nd5086 nd5087 5.631457535579e+01
RINT27150 nd5087 nd5088 5.726779446562e+01
RINT27151 nd5088 nd5089 3.512858170793e+00
RINT27152 nd5089 nd5090 3.453240863313e+00
RINT27153 nd5090 nd5091 9.993586560904e+00
RINT27154 nd5091 nd5092 5.786876290473e+01
RINT27155 nd5092 nd5093 7.853617822785e+01
RINT27156 nd5093 nd5094 5.786876290473e+01
RINT27157 nd5094 nd5095 5.786876290473e+01
RINT27158 nd5095 nd5096 5.786876290473e+01
RINT27159 nd5096 nd5097 5.786876290473e+01
RINT27160 nd5097 nd5098 5.786876290473e+01
RINT27161 nd5098 nd5099 5.786876290473e+01
RINT27162 nd5099 nd5100 1.591390979880e+02
RINT27163 nd5100 nd5101 2.604094330713e+02
RINT27164 nd5101 nd5102 1.303705308206e+02
RINT27165 nd5102 nd5103 1.608894908578e+00
RINT27166 nd5103 nd5104 2.789737223720e+01
RINT27167 nd5104 nd5105 2.744632754910e+01
RINT27168 nd5105 nd5106 1.984071871019e+00
RINT27169 nd5106 nd5107 1.984071871019e+00
RINT27170 nd5107 nd5108 1.984071871019e+00
RINT27171 nd5108 nd5109 1.984071871019e+00
RINT27172 nd5109 nd5110 1.984071871019e+00
RINT27173 nd5110 nd5111 1.984071871019e+00
RINT27174 nd5111 nd5112 1.984071871019e+00
RINT27175 nd5112 nd5113 1.984071871019e+00
RINT27176 nd5113 nd5114 1.984071871019e+00
RINT27177 nd5115 nd5116 2.493313941068e-01
RINT27178 nd5116 nd5117 2.266357619356e-01
RINT27179 nd5117 nd5118 7.660631014006e+00
RINT27180 nd5118 nd5119 7.790300106417e+00
RINT27181 nd5119 nd5120 4.778640357485e-01
RINT27182 nd5120 nd5121 4.697541247393e-01
RINT27183 nd5121 nd5122 2.520135011038e-01
RINT27184 nd5122 nd5123 1.199550711388e-01
RINT27185 nd5123 nd5124 1.627961679741e-01
RINT27186 nd5124 nd5125 1.199550711388e-01
RINT27187 nd5125 nd5126 1.199550711388e-01
RINT27188 nd5126 nd5127 1.199550711388e-01
RINT27189 nd5127 nd5128 1.199550711388e-01
RINT27190 nd5128 nd5129 1.199550711388e-01
RINT27191 nd5129 nd5130 1.199550711388e-01
RINT27192 nd5130 nd5131 3.298764456317e-01
RINT27193 nd5131 nd5132 5.397978201245e-01
RINT27194 nd5132 nd5133 2.924550963786e-01
RINT27195 nd5133 nd5134 2.188625263897e-01
RINT27196 nd5134 nd5135 3.794958474237e+00
RINT27197 nd5135 nd5136 3.733601589195e+00
RINT27198 nd5136 nd5137 2.698989100623e-01
RINT27199 nd5137 nd5138 2.698989100623e-01
RINT27200 nd5138 nd5139 2.698989100623e-01
RINT27201 nd5139 nd5140 2.698989100623e-01
RINT27202 nd5140 nd5141 2.698989100623e-01
RINT27203 nd5141 nd5142 2.698989100623e-01
RINT27204 nd5142 nd5143 2.698989100623e-01
RINT27205 nd5143 nd5144 2.698989100623e-01
RINT27206 nd5144 nd5145 2.698989100623e-01
RINT27207 nd5146 nd5147 2.493313941068e-01
RINT27208 nd5147 nd5148 2.266357619356e-01
RINT27209 nd5148 nd5149 7.660631014006e+00
RINT27210 nd5149 nd5150 7.790300106417e+00
RINT27211 nd5150 nd5151 4.778640357485e-01
RINT27212 nd5151 nd5152 4.697541247393e-01
RINT27213 nd5152 nd5153 2.520135011038e-01
RINT27214 nd5153 nd5154 1.199550711388e-01
RINT27215 nd5154 nd5155 1.627961679741e-01
RINT27216 nd5155 nd5156 1.199550711388e-01
RINT27217 nd5156 nd5157 1.199550711388e-01
RINT27218 nd5157 nd5158 1.199550711388e-01
RINT27219 nd5158 nd5159 1.199550711388e-01
RINT27220 nd5159 nd5160 1.199550711388e-01
RINT27221 nd5160 nd5161 1.199550711388e-01
RINT27222 nd5161 nd5162 3.298764456317e-01
RINT27223 nd5162 nd5163 5.397978201245e-01
RINT27224 nd5163 nd5164 2.924550963786e-01
RINT27225 nd5164 nd5165 2.188625263897e-01
RINT27226 nd5165 nd5166 3.794958474237e+00
RINT27227 nd5166 nd5167 3.733601589195e+00
RINT27228 nd5167 nd5168 2.698989100623e-01
RINT27229 nd5168 nd5169 2.698989100623e-01
RINT27230 nd5169 nd5170 2.698989100623e-01
RINT27231 nd5170 nd5171 2.698989100623e-01
RINT27232 nd5171 nd5172 2.698989100623e-01
RINT27233 nd5172 nd5173 2.698989100623e-01
RINT27234 nd5173 nd5174 2.698989100623e-01
RINT27235 nd5174 nd5175 2.698989100623e-01
RINT27236 nd5175 nd5176 2.698989100623e-01
RINT27237 nd5177 nd5178 2.493313941068e-01
RINT27238 nd5178 nd5179 2.266357619356e-01
RINT27239 nd5179 nd5180 7.660631014006e+00
RINT27240 nd5180 nd5181 7.790300106417e+00
RINT27241 nd5181 nd5182 4.778640357485e-01
RINT27242 nd5182 nd5183 4.697541247393e-01
RINT27243 nd5183 nd5184 2.520135011038e-01
RINT27244 nd5184 nd5185 1.199550711388e-01
RINT27245 nd5185 nd5186 1.627961679741e-01
RINT27246 nd5186 nd5187 1.199550711388e-01
RINT27247 nd5187 nd5188 1.199550711388e-01
RINT27248 nd5188 nd5189 1.199550711388e-01
RINT27249 nd5189 nd5190 1.199550711388e-01
RINT27250 nd5190 nd5191 1.199550711388e-01
RINT27251 nd5191 nd5192 1.199550711388e-01
RINT27252 nd5192 nd5193 3.298764456317e-01
RINT27253 nd5193 nd5194 5.397978201245e-01
RINT27254 nd5194 nd5195 2.924550963786e-01
RINT27255 nd5195 nd5196 2.188625263897e-01
RINT27256 nd5196 nd5197 3.794958474237e+00
RINT27257 nd5197 nd5198 3.733601589195e+00
RINT27258 nd5198 nd5199 2.698989100623e-01
RINT27259 nd5199 nd5200 2.698989100623e-01
RINT27260 nd5200 nd5201 2.698989100623e-01
RINT27261 nd5201 nd5202 2.698989100623e-01
RINT27262 nd5202 nd5203 2.698989100623e-01
RINT27263 nd5203 nd5204 2.698989100623e-01
RINT27264 nd5204 nd5205 2.698989100623e-01
RINT27265 nd5205 nd5206 2.698989100623e-01
RINT27266 nd5206 nd5207 2.698989100623e-01
RINT27267 nd5208 nd5209 2.493313941068e-01
RINT27268 nd5209 nd5210 2.266357619356e-01
RINT27269 nd5210 nd5211 7.660631014006e+00
RINT27270 nd5211 nd5212 7.790300106417e+00
RINT27271 nd5212 nd5213 4.778640357485e-01
RINT27272 nd5213 nd5214 4.697541247393e-01
RINT27273 nd5214 nd5215 2.520135011038e-01
RINT27274 nd5215 nd5216 1.199550711388e-01
RINT27275 nd5216 nd5217 1.627961679741e-01
RINT27276 nd5217 nd5218 1.199550711388e-01
RINT27277 nd5218 nd5219 1.199550711388e-01
RINT27278 nd5219 nd5220 1.199550711388e-01
RINT27279 nd5220 nd5221 1.199550711388e-01
RINT27280 nd5221 nd5222 1.199550711388e-01
RINT27281 nd5222 nd5223 1.199550711388e-01
RINT27282 nd5223 nd5224 3.298764456317e-01
RINT27283 nd5224 nd5225 5.397978201245e-01
RINT27284 nd5225 nd5226 2.924550963786e-01
RINT27285 nd5226 nd5227 2.188625263897e-01
RINT27286 nd5227 nd5228 3.794958474237e+00
RINT27287 nd5228 nd5229 3.733601589195e+00
RINT27288 nd5229 nd5230 2.698989100623e-01
RINT27289 nd5230 nd5231 2.698989100623e-01
RINT27290 nd5231 nd5232 2.698989100623e-01
RINT27291 nd5232 nd5233 2.698989100623e-01
RINT27292 nd5233 nd5234 2.698989100623e-01
RINT27293 nd5234 nd5235 2.698989100623e-01
RINT27294 nd5235 nd5236 2.698989100623e-01
RINT27295 nd5236 nd5237 2.698989100623e-01
RINT27296 nd5237 nd5238 2.698989100623e-01
RINT27297 nd5239 nd5240 2.493313941068e-01
RINT27298 nd5240 nd5241 2.266357619356e-01
RINT27299 nd5241 nd5242 7.660631014006e+00
RINT27300 nd5242 nd5243 7.790300106417e+00
RINT27301 nd5243 nd5244 4.778640357485e-01
RINT27302 nd5244 nd5245 4.697541247393e-01
RINT27303 nd5245 nd5246 2.520135011038e-01
RINT27304 nd5246 nd5247 1.199550711388e-01
RINT27305 nd5247 nd5248 1.627961679741e-01
RINT27306 nd5248 nd5249 1.199550711388e-01
RINT27307 nd5249 nd5250 1.199550711388e-01
RINT27308 nd5250 nd5251 1.199550711388e-01
RINT27309 nd5251 nd5252 1.199550711388e-01
RINT27310 nd5252 nd5253 1.199550711388e-01
RINT27311 nd5253 nd5254 1.199550711388e-01
RINT27312 nd5254 nd5255 3.298764456317e-01
RINT27313 nd5255 nd5256 5.397978201245e-01
RINT27314 nd5256 nd5257 2.924550963786e-01
RINT27315 nd5257 nd5258 2.188625263897e-01
RINT27316 nd5258 nd5259 3.794958474237e+00
RINT27317 nd5259 nd5260 3.733601589195e+00
RINT27318 nd5260 nd5261 2.698989100623e-01
RINT27319 nd5261 nd5262 2.698989100623e-01
RINT27320 nd5262 nd5263 2.698989100623e-01
RINT27321 nd5263 nd5264 2.698989100623e-01
RINT27322 nd5264 nd5265 2.698989100623e-01
RINT27323 nd5265 nd5266 2.698989100623e-01
RINT27324 nd5266 nd5267 2.698989100623e-01
RINT27325 nd5267 nd5268 2.698989100623e-01
RINT27326 nd5268 nd5269 2.698989100623e-01
RINT27327 nd5270 nd5271 2.493313941068e-01
RINT27328 nd5271 nd5272 2.266357619356e-01
RINT27329 nd5272 nd5273 7.660631014006e+00
RINT27330 nd5273 nd5274 7.790300106417e+00
RINT27331 nd5274 nd5275 4.778640357485e-01
RINT27332 nd5275 nd5276 4.697541247393e-01
RINT27333 nd5276 nd5277 2.520135011038e-01
RINT27334 nd5277 nd5278 1.199550711388e-01
RINT27335 nd5278 nd5279 1.627961679741e-01
RINT27336 nd5279 nd5280 1.199550711388e-01
RINT27337 nd5280 nd5281 1.199550711388e-01
RINT27338 nd5281 nd5282 1.199550711388e-01
RINT27339 nd5282 nd5283 1.199550711388e-01
RINT27340 nd5283 nd5284 1.199550711388e-01
RINT27341 nd5284 nd5285 1.199550711388e-01
RINT27342 nd5285 nd5286 3.298764456317e-01
RINT27343 nd5286 nd5287 5.397978201245e-01
RINT27344 nd5287 nd5288 2.924550963786e-01
RINT27345 nd5288 nd5289 2.188625263897e-01
RINT27346 nd5289 nd5290 3.794958474237e+00
RINT27347 nd5290 nd5291 3.733601589195e+00
RINT27348 nd5291 nd5292 2.698989100623e-01
RINT27349 nd5292 nd5293 2.698989100623e-01
RINT27350 nd5293 nd5294 2.698989100623e-01
RINT27351 nd5294 nd5295 2.698989100623e-01
RINT27352 nd5295 nd5296 2.698989100623e-01
RINT27353 nd5296 nd5297 2.698989100623e-01
RINT27354 nd5297 nd5298 2.698989100623e-01
RINT27355 nd5298 nd5299 2.698989100623e-01
RINT27356 nd5299 nd5300 2.698989100623e-01
RINT27357 nd5301 nd5302 1.832876633312e+00
RINT27358 nd5302 nd5303 1.666037258616e+00
RINT27359 nd5303 nd5304 5.631457535580e+01
RINT27360 nd5304 nd5305 5.726779446562e+01
RINT27361 nd5305 nd5306 3.512858170793e+00
RINT27362 nd5306 nd5307 3.453240863313e+00
RINT27363 nd5307 nd5308 9.993586560904e+00
RINT27364 nd5308 nd5309 5.786876290473e+01
RINT27365 nd5309 nd5310 7.853617822785e+01
RINT27366 nd5310 nd5311 5.786876290473e+01
RINT27367 nd5311 nd5312 5.786876290473e+01
RINT27368 nd5312 nd5313 5.786876290473e+01
RINT27369 nd5313 nd5314 5.786876290473e+01
RINT27370 nd5314 nd5315 5.786876290473e+01
RINT27371 nd5315 nd5316 5.786876290473e+01
RINT27372 nd5316 nd5317 1.591390979880e+02
RINT27373 nd5317 nd5318 2.604094330713e+02
RINT27374 nd5318 nd5319 1.303705308206e+02
RINT27375 nd5319 nd5320 1.608894908578e+00
RINT27376 nd5320 nd5321 2.789737223720e+01
RINT27377 nd5321 nd5322 2.744632754910e+01
RINT27378 nd5322 nd5323 1.984071871019e+00
RINT27379 nd5323 nd5324 1.984071871019e+00
RINT27380 nd5324 nd5325 1.984071871019e+00
RINT27381 nd5325 nd5326 1.984071871019e+00
RINT27382 nd5326 nd5327 1.984071871019e+00
RINT27383 nd5327 nd5328 1.984071871019e+00
RINT27384 nd5328 nd5329 1.984071871019e+00
RINT27385 nd5329 nd5330 1.984071871019e+00
RINT27386 nd5330 nd5331 1.984071871019e+00
RINT27387 nd5332 nd5333 1.914284617627e-01
RINT27388 nd5333 nd5334 1.740035002137e-01
RINT27389 nd5334 nd5335 5.881581083666e+00
RINT27390 nd5335 nd5336 5.981136757300e+00
RINT27391 nd5336 nd5337 3.668883239623e-01
RINT27392 nd5337 nd5338 3.606618004430e-01
RINT27393 nd5338 nd5339 1.976741618838e-01
RINT27394 nd5339 nd5340 8.656063970738e-02
RINT27395 nd5340 nd5341 1.760179307529e-01
RINT27396 nd5341 nd5342 2.136011054157e-01
RINT27397 nd5342 nd5343 2.136011054157e-01
RINT27398 nd5343 nd5344 2.136011054157e-01
RINT27399 nd5344 nd5345 2.136011054157e-01
RINT27400 nd5345 nd5346 2.136011054157e-01
RINT27401 nd5346 nd5347 2.136011054157e-01
RINT27402 nd5347 nd5348 2.884961700761e-01
RINT27403 nd5348 nd5349 4.298149835847e-01
RINT27404 nd5349 nd5350 2.654372658145e-01
RINT27405 nd5350 nd5351 1.680354650659e-01
RINT27406 nd5351 nd5352 2.913644572433e+00
RINT27407 nd5352 nd5353 2.866536769726e+00
RINT27408 nd5353 nd5354 2.072195255224e-01
RINT27409 nd5354 nd5355 2.072195255224e-01
RINT27410 nd5355 nd5356 2.072195255224e-01
RINT27411 nd5356 nd5357 2.072195255224e-01
RINT27412 nd5357 nd5358 2.072195255224e-01
RINT27413 nd5358 nd5359 2.072195255224e-01
RINT27414 nd5359 nd5360 2.072195255224e-01
RINT27415 nd5360 nd5361 2.072195255224e-01
RINT27416 nd5361 nd5362 2.072195255224e-01
RINT27417 nd5363 nd5364 1.914284617627e-01
RINT27418 nd5364 nd5365 1.740035002137e-01
RINT27419 nd5365 nd5366 5.881581083666e+00
RINT27420 nd5366 nd5367 5.981136757300e+00
RINT27421 nd5367 nd5368 3.668883239623e-01
RINT27422 nd5368 nd5369 3.606618004430e-01
RINT27423 nd5369 nd5370 1.976741618838e-01
RINT27424 nd5370 nd5371 8.656063970738e-02
RINT27425 nd5371 nd5372 1.760179307529e-01
RINT27426 nd5372 nd5373 2.136011054157e-01
RINT27427 nd5373 nd5374 2.136011054157e-01
RINT27428 nd5374 nd5375 2.136011054157e-01
RINT27429 nd5375 nd5376 2.136011054157e-01
RINT27430 nd5376 nd5377 2.136011054157e-01
RINT27431 nd5377 nd5378 2.136011054157e-01
RINT27432 nd5378 nd5379 2.884961700761e-01
RINT27433 nd5379 nd5380 4.298149835847e-01
RINT27434 nd5380 nd5381 2.654372658145e-01
RINT27435 nd5381 nd5382 1.680354650659e-01
RINT27436 nd5382 nd5383 2.913644572433e+00
RINT27437 nd5383 nd5384 2.866536769726e+00
RINT27438 nd5384 nd5385 2.072195255224e-01
RINT27439 nd5385 nd5386 2.072195255224e-01
RINT27440 nd5386 nd5387 2.072195255224e-01
RINT27441 nd5387 nd5388 2.072195255224e-01
RINT27442 nd5388 nd5389 2.072195255224e-01
RINT27443 nd5389 nd5390 2.072195255224e-01
RINT27444 nd5390 nd5391 2.072195255224e-01
RINT27445 nd5391 nd5392 2.072195255224e-01
RINT27446 nd5392 nd5393 2.072195255224e-01
RINT27447 nd5394 nd5395 1.914284617627e-01
RINT27448 nd5395 nd5396 1.740035002137e-01
RINT27449 nd5396 nd5397 5.881581083666e+00
RINT27450 nd5397 nd5398 5.981136757300e+00
RINT27451 nd5398 nd5399 3.668883239623e-01
RINT27452 nd5399 nd5400 3.606618004430e-01
RINT27453 nd5400 nd5401 1.976741618838e-01
RINT27454 nd5401 nd5402 8.656063970738e-02
RINT27455 nd5402 nd5403 1.760179307529e-01
RINT27456 nd5403 nd5404 2.136011054157e-01
RINT27457 nd5404 nd5405 2.136011054157e-01
RINT27458 nd5405 nd5406 2.136011054157e-01
RINT27459 nd5406 nd5407 2.136011054157e-01
RINT27460 nd5407 nd5408 2.136011054157e-01
RINT27461 nd5408 nd5409 2.136011054157e-01
RINT27462 nd5409 nd5410 2.884961700761e-01
RINT27463 nd5410 nd5411 4.298149835847e-01
RINT27464 nd5411 nd5412 2.654372658145e-01
RINT27465 nd5412 nd5413 1.680354650659e-01
RINT27466 nd5413 nd5414 2.913644572433e+00
RINT27467 nd5414 nd5415 2.866536769726e+00
RINT27468 nd5415 nd5416 2.072195255224e-01
RINT27469 nd5416 nd5417 2.072195255224e-01
RINT27470 nd5417 nd5418 2.072195255224e-01
RINT27471 nd5418 nd5419 2.072195255224e-01
RINT27472 nd5419 nd5420 2.072195255224e-01
RINT27473 nd5420 nd5421 2.072195255224e-01
RINT27474 nd5421 nd5422 2.072195255224e-01
RINT27475 nd5422 nd5423 2.072195255224e-01
RINT27476 nd5423 nd5424 2.072195255224e-01
RINT27477 nd5425 nd5426 1.914284617627e-01
RINT27478 nd5426 nd5427 1.740035002137e-01
RINT27479 nd5427 nd5428 5.881581083666e+00
RINT27480 nd5428 nd5429 5.981136757300e+00
RINT27481 nd5429 nd5430 3.668883239623e-01
RINT27482 nd5430 nd5431 3.606618004430e-01
RINT27483 nd5431 nd5432 1.976741618838e-01
RINT27484 nd5432 nd5433 8.656063970739e-02
RINT27485 nd5433 nd5434 1.760179307529e-01
RINT27486 nd5434 nd5435 2.136011054157e-01
RINT27487 nd5435 nd5436 2.136011054157e-01
RINT27488 nd5436 nd5437 2.136011054157e-01
RINT27489 nd5437 nd5438 2.136011054157e-01
RINT27490 nd5438 nd5439 2.136011054157e-01
RINT27491 nd5439 nd5440 2.136011054157e-01
RINT27492 nd5440 nd5441 2.884961700761e-01
RINT27493 nd5441 nd5442 4.298149835847e-01
RINT27494 nd5442 nd5443 2.654372658145e-01
RINT27495 nd5443 nd5444 1.680354650659e-01
RINT27496 nd5444 nd5445 2.913644572433e+00
RINT27497 nd5445 nd5446 2.866536769726e+00
RINT27498 nd5446 nd5447 2.072195255224e-01
RINT27499 nd5447 nd5448 2.072195255224e-01
RINT27500 nd5448 nd5449 2.072195255224e-01
RINT27501 nd5449 nd5450 2.072195255224e-01
RINT27502 nd5450 nd5451 2.072195255224e-01
RINT27503 nd5451 nd5452 2.072195255224e-01
RINT27504 nd5452 nd5453 2.072195255224e-01
RINT27505 nd5453 nd5454 2.072195255224e-01
RINT27506 nd5454 nd5455 2.072195255224e-01
RINT27507 nd5456 nd5457 1.914284617627e-01
RINT27508 nd5457 nd5458 1.740035002137e-01
RINT27509 nd5458 nd5459 5.881581083666e+00
RINT27510 nd5459 nd5460 5.981136757300e+00
RINT27511 nd5460 nd5461 3.668883239623e-01
RINT27512 nd5461 nd5462 3.606618004430e-01
RINT27513 nd5462 nd5463 1.976741618838e-01
RINT27514 nd5463 nd5464 8.656063970738e-02
RINT27515 nd5464 nd5465 1.760179307529e-01
RINT27516 nd5465 nd5466 2.136011054157e-01
RINT27517 nd5466 nd5467 2.136011054157e-01
RINT27518 nd5467 nd5468 2.136011054157e-01
RINT27519 nd5468 nd5469 2.136011054157e-01
RINT27520 nd5469 nd5470 2.136011054157e-01
RINT27521 nd5470 nd5471 2.136011054157e-01
RINT27522 nd5471 nd5472 2.884961700761e-01
RINT27523 nd5472 nd5473 4.298149835847e-01
RINT27524 nd5473 nd5474 2.654372658145e-01
RINT27525 nd5474 nd5475 1.680354650659e-01
RINT27526 nd5475 nd5476 2.913644572433e+00
RINT27527 nd5476 nd5477 2.866536769726e+00
RINT27528 nd5477 nd5478 2.072195255224e-01
RINT27529 nd5478 nd5479 2.072195255224e-01
RINT27530 nd5479 nd5480 2.072195255224e-01
RINT27531 nd5480 nd5481 2.072195255224e-01
RINT27532 nd5481 nd5482 2.072195255224e-01
RINT27533 nd5482 nd5483 2.072195255224e-01
RINT27534 nd5483 nd5484 2.072195255224e-01
RINT27535 nd5484 nd5485 2.072195255224e-01
RINT27536 nd5485 nd5486 2.072195255224e-01
RINT27537 nd5487 nd5488 1.914284617627e-01
RINT27538 nd5488 nd5489 1.740035002137e-01
RINT27539 nd5489 nd5490 5.881581083666e+00
RINT27540 nd5490 nd5491 5.981136757300e+00
RINT27541 nd5491 nd5492 3.668883239623e-01
RINT27542 nd5492 nd5493 3.606618004430e-01
RINT27543 nd5493 nd5494 1.976741618838e-01
RINT27544 nd5494 nd5495 8.656063970738e-02
RINT27545 nd5495 nd5496 1.760179307529e-01
RINT27546 nd5496 nd5497 2.136011054157e-01
RINT27547 nd5497 nd5498 2.136011054157e-01
RINT27548 nd5498 nd5499 2.136011054157e-01
RINT27549 nd5499 nd5500 2.136011054157e-01
RINT27550 nd5500 nd5501 2.136011054157e-01
RINT27551 nd5501 nd5502 2.136011054157e-01
RINT27552 nd5502 nd5503 2.884961700761e-01
RINT27553 nd5503 nd5504 4.298149835847e-01
RINT27554 nd5504 nd5505 2.654372658145e-01
RINT27555 nd5505 nd5506 1.680354650659e-01
RINT27556 nd5506 nd5507 2.913644572433e+00
RINT27557 nd5507 nd5508 2.866536769726e+00
RINT27558 nd5508 nd5509 2.072195255224e-01
RINT27559 nd5509 nd5510 2.072195255224e-01
RINT27560 nd5510 nd5511 2.072195255224e-01
RINT27561 nd5511 nd5512 2.072195255224e-01
RINT27562 nd5512 nd5513 2.072195255224e-01
RINT27563 nd5513 nd5514 2.072195255224e-01
RINT27564 nd5514 nd5515 2.072195255224e-01
RINT27565 nd5515 nd5516 2.072195255224e-01
RINT27566 nd5516 nd5517 2.072195255224e-01
RINT27567 nd5518 nd5519 1.832876633312e+00
RINT27568 nd5519 nd5520 1.666037258616e+00
RINT27569 nd5520 nd5521 5.631457535579e+01
RINT27570 nd5521 nd5522 5.726779446562e+01
RINT27571 nd5522 nd5523 3.512858170793e+00
RINT27572 nd5523 nd5524 3.453240863313e+00
RINT27573 nd5524 nd5525 9.993586560904e+00
RINT27574 nd5525 nd5526 5.786876290473e+01
RINT27575 nd5526 nd5527 7.853617822785e+01
RINT27576 nd5527 nd5528 5.786876290473e+01
RINT27577 nd5528 nd5529 5.786876290473e+01
RINT27578 nd5529 nd5530 5.786876290473e+01
RINT27579 nd5530 nd5531 5.786876290473e+01
RINT27580 nd5531 nd5532 5.786876290473e+01
RINT27581 nd5532 nd5533 5.786876290473e+01
RINT27582 nd5533 nd5534 1.591390979880e+02
RINT27583 nd5534 nd5535 2.604094330713e+02
RINT27584 nd5535 nd5536 1.303705308206e+02
RINT27585 nd5536 nd5537 1.608894908578e+00
RINT27586 nd5537 nd5538 2.789737223720e+01
RINT27587 nd5538 nd5539 2.744632754910e+01
RINT27588 nd5539 nd5540 1.984071871019e+00
RINT27589 nd5540 nd5541 1.984071871019e+00
RINT27590 nd5541 nd5542 1.984071871019e+00
RINT27591 nd5542 nd5543 1.984071871019e+00
RINT27592 nd5543 nd5544 1.984071871019e+00
RINT27593 nd5544 nd5545 1.984071871019e+00
RINT27594 nd5545 nd5546 1.984071871019e+00
RINT27595 nd5546 nd5547 1.984071871019e+00
RINT27596 nd5547 nd5548 1.984071871019e+00
RINT27597 nd5549 nd5550 1.914284617627e-01
RINT27598 nd5550 nd5551 1.740035002137e-01
RINT27599 nd5551 nd5552 5.881581083666e+00
RINT27600 nd5552 nd5553 5.981136757300e+00
RINT27601 nd5553 nd5554 3.668883239623e-01
RINT27602 nd5554 nd5555 3.606618004430e-01
RINT27603 nd5555 nd5556 1.976741618838e-01
RINT27604 nd5556 nd5557 8.656063970739e-02
RINT27605 nd5557 nd5558 1.760179307529e-01
RINT27606 nd5558 nd5559 2.136011054157e-01
RINT27607 nd5559 nd5560 2.136011054157e-01
RINT27608 nd5560 nd5561 2.136011054157e-01
RINT27609 nd5561 nd5562 2.136011054157e-01
RINT27610 nd5562 nd5563 2.136011054157e-01
RINT27611 nd5563 nd5564 2.136011054157e-01
RINT27612 nd5564 nd5565 2.884961700761e-01
RINT27613 nd5565 nd5566 4.298149835847e-01
RINT27614 nd5566 nd5567 2.654372658145e-01
RINT27615 nd5567 nd5568 1.680354650659e-01
RINT27616 nd5568 nd5569 2.913644572433e+00
RINT27617 nd5569 nd5570 2.866536769726e+00
RINT27618 nd5570 nd5571 2.072195255224e-01
RINT27619 nd5571 nd5572 2.072195255224e-01
RINT27620 nd5572 nd5573 2.072195255224e-01
RINT27621 nd5573 nd5574 2.072195255224e-01
RINT27622 nd5574 nd5575 2.072195255224e-01
RINT27623 nd5575 nd5576 2.072195255224e-01
RINT27624 nd5576 nd5577 2.072195255224e-01
RINT27625 nd5577 nd5578 2.072195255224e-01
RINT27626 nd5578 nd5579 2.072195255224e-01
RINT27627 nd5580 nd5581 1.914284617627e-01
RINT27628 nd5581 nd5582 1.740035002137e-01
RINT27629 nd5582 nd5583 5.881581083666e+00
RINT27630 nd5583 nd5584 5.981136757300e+00
RINT27631 nd5584 nd5585 3.668883239623e-01
RINT27632 nd5585 nd5586 3.606618004430e-01
RINT27633 nd5586 nd5587 1.976741618838e-01
RINT27634 nd5587 nd5588 8.656063970738e-02
RINT27635 nd5588 nd5589 1.760179307529e-01
RINT27636 nd5589 nd5590 2.136011054157e-01
RINT27637 nd5590 nd5591 2.136011054157e-01
RINT27638 nd5591 nd5592 2.136011054157e-01
RINT27639 nd5592 nd5593 2.136011054157e-01
RINT27640 nd5593 nd5594 2.136011054157e-01
RINT27641 nd5594 nd5595 2.136011054157e-01
RINT27642 nd5595 nd5596 2.884961700761e-01
RINT27643 nd5596 nd5597 4.298149835847e-01
RINT27644 nd5597 nd5598 2.654372658145e-01
RINT27645 nd5598 nd5599 1.680354650659e-01
RINT27646 nd5599 nd5600 2.913644572433e+00
RINT27647 nd5600 nd5601 2.866536769726e+00
RINT27648 nd5601 nd5602 2.072195255224e-01
RINT27649 nd5602 nd5603 2.072195255224e-01
RINT27650 nd5603 nd5604 2.072195255224e-01
RINT27651 nd5604 nd5605 2.072195255224e-01
RINT27652 nd5605 nd5606 2.072195255224e-01
RINT27653 nd5606 nd5607 2.072195255224e-01
RINT27654 nd5607 nd5608 2.072195255224e-01
RINT27655 nd5608 nd5609 2.072195255224e-01
RINT27656 nd5609 nd5610 2.072195255224e-01
RINT27657 nd5611 nd5612 1.914284617627e-01
RINT27658 nd5612 nd5613 1.740035002137e-01
RINT27659 nd5613 nd5614 5.881581083666e+00
RINT27660 nd5614 nd5615 5.981136757300e+00
RINT27661 nd5615 nd5616 3.668883239623e-01
RINT27662 nd5616 nd5617 3.606618004430e-01
RINT27663 nd5617 nd5618 1.976741618838e-01
RINT27664 nd5618 nd5619 8.656063970739e-02
RINT27665 nd5619 nd5620 1.760179307529e-01
RINT27666 nd5620 nd5621 2.136011054157e-01
RINT27667 nd5621 nd5622 2.136011054157e-01
RINT27668 nd5622 nd5623 2.136011054157e-01
RINT27669 nd5623 nd5624 2.136011054157e-01
RINT27670 nd5624 nd5625 2.136011054157e-01
RINT27671 nd5625 nd5626 2.136011054157e-01
RINT27672 nd5626 nd5627 2.884961700761e-01
RINT27673 nd5627 nd5628 4.298149835847e-01
RINT27674 nd5628 nd5629 2.654372658145e-01
RINT27675 nd5629 nd5630 1.680354650659e-01
RINT27676 nd5630 nd5631 2.913644572433e+00
RINT27677 nd5631 nd5632 2.866536769726e+00
RINT27678 nd5632 nd5633 2.072195255224e-01
RINT27679 nd5633 nd5634 2.072195255224e-01
RINT27680 nd5634 nd5635 2.072195255224e-01
RINT27681 nd5635 nd5636 2.072195255224e-01
RINT27682 nd5636 nd5637 2.072195255224e-01
RINT27683 nd5637 nd5638 2.072195255224e-01
RINT27684 nd5638 nd5639 2.072195255224e-01
RINT27685 nd5639 nd5640 2.072195255224e-01
RINT27686 nd5640 nd5641 2.072195255224e-01
RINT27687 nd5642 nd5643 1.914284617627e-01
RINT27688 nd5643 nd5644 1.740035002137e-01
RINT27689 nd5644 nd5645 5.881581083666e+00
RINT27690 nd5645 nd5646 5.981136757300e+00
RINT27691 nd5646 nd5647 3.668883239623e-01
RINT27692 nd5647 nd5648 3.606618004430e-01
RINT27693 nd5648 nd5649 1.976741618838e-01
RINT27694 nd5649 nd5650 8.656063970739e-02
RINT27695 nd5650 nd5651 1.760179307529e-01
RINT27696 nd5651 nd5652 2.136011054157e-01
RINT27697 nd5652 nd5653 2.136011054157e-01
RINT27698 nd5653 nd5654 2.136011054157e-01
RINT27699 nd5654 nd5655 2.136011054157e-01
RINT27700 nd5655 nd5656 2.136011054157e-01
RINT27701 nd5656 nd5657 2.136011054157e-01
RINT27702 nd5657 nd5658 2.884961700761e-01
RINT27703 nd5658 nd5659 4.298149835847e-01
RINT27704 nd5659 nd5660 2.654372658145e-01
RINT27705 nd5660 nd5661 1.680354650659e-01
RINT27706 nd5661 nd5662 2.913644572433e+00
RINT27707 nd5662 nd5663 2.866536769726e+00
RINT27708 nd5663 nd5664 2.072195255224e-01
RINT27709 nd5664 nd5665 2.072195255224e-01
RINT27710 nd5665 nd5666 2.072195255224e-01
RINT27711 nd5666 nd5667 2.072195255224e-01
RINT27712 nd5667 nd5668 2.072195255224e-01
RINT27713 nd5668 nd5669 2.072195255224e-01
RINT27714 nd5669 nd5670 2.072195255224e-01
RINT27715 nd5670 nd5671 2.072195255224e-01
RINT27716 nd5671 nd5672 2.072195255224e-01
RINT27717 nd5673 nd5674 1.914284617627e-01
RINT27718 nd5674 nd5675 1.740035002137e-01
RINT27719 nd5675 nd5676 5.881581083666e+00
RINT27720 nd5676 nd5677 5.981136757300e+00
RINT27721 nd5677 nd5678 3.668883239623e-01
RINT27722 nd5678 nd5679 3.606618004430e-01
RINT27723 nd5679 nd5680 1.976741618838e-01
RINT27724 nd5680 nd5681 8.656063970738e-02
RINT27725 nd5681 nd5682 1.760179307529e-01
RINT27726 nd5682 nd5683 2.136011054157e-01
RINT27727 nd5683 nd5684 2.136011054157e-01
RINT27728 nd5684 nd5685 2.136011054157e-01
RINT27729 nd5685 nd5686 2.136011054157e-01
RINT27730 nd5686 nd5687 2.136011054157e-01
RINT27731 nd5687 nd5688 2.136011054157e-01
RINT27732 nd5688 nd5689 2.884961700761e-01
RINT27733 nd5689 nd5690 4.298149835847e-01
RINT27734 nd5690 nd5691 2.654372658145e-01
RINT27735 nd5691 nd5692 1.680354650659e-01
RINT27736 nd5692 nd5693 2.913644572433e+00
RINT27737 nd5693 nd5694 2.866536769726e+00
RINT27738 nd5694 nd5695 2.072195255224e-01
RINT27739 nd5695 nd5696 2.072195255224e-01
RINT27740 nd5696 nd5697 2.072195255224e-01
RINT27741 nd5697 nd5698 2.072195255224e-01
RINT27742 nd5698 nd5699 2.072195255224e-01
RINT27743 nd5699 nd5700 2.072195255224e-01
RINT27744 nd5700 nd5701 2.072195255224e-01
RINT27745 nd5701 nd5702 2.072195255224e-01
RINT27746 nd5702 nd5703 2.072195255224e-01
RINT27747 nd5704 nd5705 1.914284617627e-01
RINT27748 nd5705 nd5706 1.740035002137e-01
RINT27749 nd5706 nd5707 5.881581083666e+00
RINT27750 nd5707 nd5708 5.981136757300e+00
RINT27751 nd5708 nd5709 3.668883239623e-01
RINT27752 nd5709 nd5710 3.606618004430e-01
RINT27753 nd5710 nd5711 1.976741618838e-01
RINT27754 nd5711 nd5712 8.656063970739e-02
RINT27755 nd5712 nd5713 1.760179307529e-01
RINT27756 nd5713 nd5714 2.136011054157e-01
RINT27757 nd5714 nd5715 2.136011054157e-01
RINT27758 nd5715 nd5716 2.136011054157e-01
RINT27759 nd5716 nd5717 2.136011054157e-01
RINT27760 nd5717 nd5718 2.136011054157e-01
RINT27761 nd5718 nd5719 2.136011054157e-01
RINT27762 nd5719 nd5720 2.884961700761e-01
RINT27763 nd5720 nd5721 4.298149835847e-01
RINT27764 nd5721 nd5722 2.654372658145e-01
RINT27765 nd5722 nd5723 1.680354650659e-01
RINT27766 nd5723 nd5724 2.913644572433e+00
RINT27767 nd5724 nd5725 2.866536769726e+00
RINT27768 nd5725 nd5726 2.072195255224e-01
RINT27769 nd5726 nd5727 2.072195255224e-01
RINT27770 nd5727 nd5728 2.072195255224e-01
RINT27771 nd5728 nd5729 2.072195255224e-01
RINT27772 nd5729 nd5730 2.072195255224e-01
RINT27773 nd5730 nd5731 2.072195255224e-01
RINT27774 nd5731 nd5732 2.072195255224e-01
RINT27775 nd5732 nd5733 2.072195255224e-01
RINT27776 nd5733 nd5734 2.072195255224e-01
RINT27777 nd5735 nd5736 1.832876633312e+00
RINT27778 nd5736 nd5737 1.666037258616e+00
RINT27779 nd5737 nd5738 5.631457535579e+01
RINT27780 nd5738 nd5739 5.726779446562e+01
RINT27781 nd5739 nd5740 3.512858170793e+00
RINT27782 nd5740 nd5741 3.453240863313e+00
RINT27783 nd5741 nd5742 9.993586560904e+00
RINT27784 nd5742 nd5743 5.786876290473e+01
RINT27785 nd5743 nd5744 7.853617822785e+01
RINT27786 nd5744 nd5745 5.786876290473e+01
RINT27787 nd5745 nd5746 5.786876290473e+01
RINT27788 nd5746 nd5747 5.786876290473e+01
RINT27789 nd5747 nd5748 5.786876290473e+01
RINT27790 nd5748 nd5749 5.786876290473e+01
RINT27791 nd5749 nd5750 5.786876290473e+01
RINT27792 nd5750 nd5751 1.591390979880e+02
RINT27793 nd5751 nd5752 2.604094330713e+02
RINT27794 nd5752 nd5753 1.303705308206e+02
RINT27795 nd5753 nd5754 1.608894908578e+00
RINT27796 nd5754 nd5755 2.789737223720e+01
RINT27797 nd5755 nd5756 2.744632754910e+01
RINT27798 nd5756 nd5757 1.984071871019e+00
RINT27799 nd5757 nd5758 1.984071871019e+00
RINT27800 nd5758 nd5759 1.984071871019e+00
RINT27801 nd5759 nd5760 1.984071871019e+00
RINT27802 nd5760 nd5761 1.984071871019e+00
RINT27803 nd5761 nd5762 1.984071871019e+00
RINT27804 nd5762 nd5763 1.984071871019e+00
RINT27805 nd5763 nd5764 1.984071871019e+00
RINT27806 nd5764 nd5765 1.984071871019e+00
RINT27807 nd5766 nd5767 2.493313941068e-01
RINT27808 nd5767 nd5768 2.266357619356e-01
RINT27809 nd5768 nd5769 7.660631014006e+00
RINT27810 nd5769 nd5770 7.790300106417e+00
RINT27811 nd5770 nd5771 4.778640357485e-01
RINT27812 nd5771 nd5772 4.697541247393e-01
RINT27813 nd5772 nd5773 2.520135011038e-01
RINT27814 nd5773 nd5774 1.199550711388e-01
RINT27815 nd5774 nd5775 1.627961679741e-01
RINT27816 nd5775 nd5776 1.199550711388e-01
RINT27817 nd5776 nd5777 1.199550711388e-01
RINT27818 nd5777 nd5778 1.199550711388e-01
RINT27819 nd5778 nd5779 1.199550711388e-01
RINT27820 nd5779 nd5780 1.199550711388e-01
RINT27821 nd5780 nd5781 1.199550711388e-01
RINT27822 nd5781 nd5782 3.298764456317e-01
RINT27823 nd5782 nd5783 5.397978201245e-01
RINT27824 nd5783 nd5784 2.924550963786e-01
RINT27825 nd5784 nd5785 2.188625263897e-01
RINT27826 nd5785 nd5786 3.794958474237e+00
RINT27827 nd5786 nd5787 3.733601589195e+00
RINT27828 nd5787 nd5788 2.698989100623e-01
RINT27829 nd5788 nd5789 2.698989100623e-01
RINT27830 nd5789 nd5790 2.698989100623e-01
RINT27831 nd5790 nd5791 2.698989100623e-01
RINT27832 nd5791 nd5792 2.698989100623e-01
RINT27833 nd5792 nd5793 2.698989100623e-01
RINT27834 nd5793 nd5794 2.698989100623e-01
RINT27835 nd5794 nd5795 2.698989100623e-01
RINT27836 nd5795 nd5796 2.698989100623e-01
RINT27837 nd5797 nd5798 2.493313941068e-01
RINT27838 nd5798 nd5799 2.266357619356e-01
RINT27839 nd5799 nd5800 7.660631014006e+00
RINT27840 nd5800 nd5801 7.790300106417e+00
RINT27841 nd5801 nd5802 4.778640357485e-01
RINT27842 nd5802 nd5803 4.697541247393e-01
RINT27843 nd5803 nd5804 2.520135011038e-01
RINT27844 nd5804 nd5805 1.199550711388e-01
RINT27845 nd5805 nd5806 1.627961679741e-01
RINT27846 nd5806 nd5807 1.199550711388e-01
RINT27847 nd5807 nd5808 1.199550711388e-01
RINT27848 nd5808 nd5809 1.199550711388e-01
RINT27849 nd5809 nd5810 1.199550711388e-01
RINT27850 nd5810 nd5811 1.199550711388e-01
RINT27851 nd5811 nd5812 1.199550711388e-01
RINT27852 nd5812 nd5813 3.298764456317e-01
RINT27853 nd5813 nd5814 5.397978201245e-01
RINT27854 nd5814 nd5815 2.924550963786e-01
RINT27855 nd5815 nd5816 2.188625263897e-01
RINT27856 nd5816 nd5817 3.794958474237e+00
RINT27857 nd5817 nd5818 3.733601589195e+00
RINT27858 nd5818 nd5819 2.698989100623e-01
RINT27859 nd5819 nd5820 2.698989100623e-01
RINT27860 nd5820 nd5821 2.698989100623e-01
RINT27861 nd5821 nd5822 2.698989100623e-01
RINT27862 nd5822 nd5823 2.698989100623e-01
RINT27863 nd5823 nd5824 2.698989100623e-01
RINT27864 nd5824 nd5825 2.698989100623e-01
RINT27865 nd5825 nd5826 2.698989100623e-01
RINT27866 nd5826 nd5827 2.698989100623e-01
RINT27867 nd5828 nd5829 2.493313941068e-01
RINT27868 nd5829 nd5830 2.266357619356e-01
RINT27869 nd5830 nd5831 7.660631014006e+00
RINT27870 nd5831 nd5832 7.790300106417e+00
RINT27871 nd5832 nd5833 4.778640357485e-01
RINT27872 nd5833 nd5834 4.697541247393e-01
RINT27873 nd5834 nd5835 2.520135011038e-01
RINT27874 nd5835 nd5836 1.199550711388e-01
RINT27875 nd5836 nd5837 1.627961679741e-01
RINT27876 nd5837 nd5838 1.199550711388e-01
RINT27877 nd5838 nd5839 1.199550711388e-01
RINT27878 nd5839 nd5840 1.199550711388e-01
RINT27879 nd5840 nd5841 1.199550711388e-01
RINT27880 nd5841 nd5842 1.199550711388e-01
RINT27881 nd5842 nd5843 1.199550711388e-01
RINT27882 nd5843 nd5844 3.298764456317e-01
RINT27883 nd5844 nd5845 5.397978201245e-01
RINT27884 nd5845 nd5846 2.924550963786e-01
RINT27885 nd5846 nd5847 2.188625263897e-01
RINT27886 nd5847 nd5848 3.794958474237e+00
RINT27887 nd5848 nd5849 3.733601589195e+00
RINT27888 nd5849 nd5850 2.698989100623e-01
RINT27889 nd5850 nd5851 2.698989100623e-01
RINT27890 nd5851 nd5852 2.698989100623e-01
RINT27891 nd5852 nd5853 2.698989100623e-01
RINT27892 nd5853 nd5854 2.698989100623e-01
RINT27893 nd5854 nd5855 2.698989100623e-01
RINT27894 nd5855 nd5856 2.698989100623e-01
RINT27895 nd5856 nd5857 2.698989100623e-01
RINT27896 nd5857 nd5858 2.698989100623e-01
RINT27897 nd5859 nd5860 2.493313941068e-01
RINT27898 nd5860 nd5861 2.266357619356e-01
RINT27899 nd5861 nd5862 7.660631014006e+00
RINT27900 nd5862 nd5863 7.790300106417e+00
RINT27901 nd5863 nd5864 4.778640357485e-01
RINT27902 nd5864 nd5865 4.697541247393e-01
RINT27903 nd5865 nd5866 2.520135011038e-01
RINT27904 nd5866 nd5867 1.199550711388e-01
RINT27905 nd5867 nd5868 1.627961679741e-01
RINT27906 nd5868 nd5869 1.199550711388e-01
RINT27907 nd5869 nd5870 1.199550711388e-01
RINT27908 nd5870 nd5871 1.199550711388e-01
RINT27909 nd5871 nd5872 1.199550711388e-01
RINT27910 nd5872 nd5873 1.199550711388e-01
RINT27911 nd5873 nd5874 1.199550711388e-01
RINT27912 nd5874 nd5875 3.298764456317e-01
RINT27913 nd5875 nd5876 5.397978201245e-01
RINT27914 nd5876 nd5877 2.924550963786e-01
RINT27915 nd5877 nd5878 2.188625263897e-01
RINT27916 nd5878 nd5879 3.794958474237e+00
RINT27917 nd5879 nd5880 3.733601589195e+00
RINT27918 nd5880 nd5881 2.698989100623e-01
RINT27919 nd5881 nd5882 2.698989100623e-01
RINT27920 nd5882 nd5883 2.698989100623e-01
RINT27921 nd5883 nd5884 2.698989100623e-01
RINT27922 nd5884 nd5885 2.698989100623e-01
RINT27923 nd5885 nd5886 2.698989100623e-01
RINT27924 nd5886 nd5887 2.698989100623e-01
RINT27925 nd5887 nd5888 2.698989100623e-01
RINT27926 nd5888 nd5889 2.698989100623e-01
RINT27927 nd5890 nd5891 2.493313941068e-01
RINT27928 nd5891 nd5892 2.266357619356e-01
RINT27929 nd5892 nd5893 7.660631014006e+00
RINT27930 nd5893 nd5894 7.790300106417e+00
RINT27931 nd5894 nd5895 4.778640357485e-01
RINT27932 nd5895 nd5896 4.697541247393e-01
RINT27933 nd5896 nd5897 2.520135011038e-01
RINT27934 nd5897 nd5898 1.199550711388e-01
RINT27935 nd5898 nd5899 1.627961679741e-01
RINT27936 nd5899 nd5900 1.199550711388e-01
RINT27937 nd5900 nd5901 1.199550711388e-01
RINT27938 nd5901 nd5902 1.199550711388e-01
RINT27939 nd5902 nd5903 1.199550711388e-01
RINT27940 nd5903 nd5904 1.199550711388e-01
RINT27941 nd5904 nd5905 1.199550711388e-01
RINT27942 nd5905 nd5906 3.298764456317e-01
RINT27943 nd5906 nd5907 5.397978201245e-01
RINT27944 nd5907 nd5908 2.924550963786e-01
RINT27945 nd5908 nd5909 2.188625263897e-01
RINT27946 nd5909 nd5910 3.794958474237e+00
RINT27947 nd5910 nd5911 3.733601589195e+00
RINT27948 nd5911 nd5912 2.698989100623e-01
RINT27949 nd5912 nd5913 2.698989100623e-01
RINT27950 nd5913 nd5914 2.698989100623e-01
RINT27951 nd5914 nd5915 2.698989100623e-01
RINT27952 nd5915 nd5916 2.698989100623e-01
RINT27953 nd5916 nd5917 2.698989100623e-01
RINT27954 nd5917 nd5918 2.698989100623e-01
RINT27955 nd5918 nd5919 2.698989100623e-01
RINT27956 nd5919 nd5920 2.698989100623e-01
RINT27957 nd5921 nd5922 2.493313941068e-01
RINT27958 nd5922 nd5923 2.266357619356e-01
RINT27959 nd5923 nd5924 7.660631014006e+00
RINT27960 nd5924 nd5925 7.790300106417e+00
RINT27961 nd5925 nd5926 4.778640357485e-01
RINT27962 nd5926 nd5927 4.697541247393e-01
RINT27963 nd5927 nd5928 2.520135011038e-01
RINT27964 nd5928 nd5929 1.199550711388e-01
RINT27965 nd5929 nd5930 1.627961679741e-01
RINT27966 nd5930 nd5931 1.199550711388e-01
RINT27967 nd5931 nd5932 1.199550711388e-01
RINT27968 nd5932 nd5933 1.199550711388e-01
RINT27969 nd5933 nd5934 1.199550711388e-01
RINT27970 nd5934 nd5935 1.199550711388e-01
RINT27971 nd5935 nd5936 1.199550711388e-01
RINT27972 nd5936 nd5937 3.298764456317e-01
RINT27973 nd5937 nd5938 5.397978201245e-01
RINT27974 nd5938 nd5939 2.924550963786e-01
RINT27975 nd5939 nd5940 2.188625263897e-01
RINT27976 nd5940 nd5941 3.794958474237e+00
RINT27977 nd5941 nd5942 3.733601589195e+00
RINT27978 nd5942 nd5943 2.698989100623e-01
RINT27979 nd5943 nd5944 2.698989100623e-01
RINT27980 nd5944 nd5945 2.698989100623e-01
RINT27981 nd5945 nd5946 2.698989100623e-01
RINT27982 nd5946 nd5947 2.698989100623e-01
RINT27983 nd5947 nd5948 2.698989100623e-01
RINT27984 nd5948 nd5949 2.698989100623e-01
RINT27985 nd5949 nd5950 2.698989100623e-01
RINT27986 nd5950 nd5951 2.698989100623e-01
RINT27987 nd5952 nd5953 1.832876633312e+00
RINT27988 nd5953 nd5954 1.666037258616e+00
RINT27989 nd5954 nd5955 5.631457535580e+01
RINT27990 nd5955 nd5956 5.726779446562e+01
RINT27991 nd5956 nd5957 3.512858170793e+00
RINT27992 nd5957 nd5958 3.453240863313e+00
RINT27993 nd5958 nd5959 9.993586560904e+00
RINT27994 nd5959 nd5960 5.786876290473e+01
RINT27995 nd5960 nd5961 7.853617822785e+01
RINT27996 nd5961 nd5962 5.786876290473e+01
RINT27997 nd5962 nd5963 5.786876290473e+01
RINT27998 nd5963 nd5964 5.786876290473e+01
RINT27999 nd5964 nd5965 5.786876290473e+01
RINT28000 nd5965 nd5966 5.786876290473e+01
RINT28001 nd5966 nd5967 5.786876290473e+01
RINT28002 nd5967 nd5968 1.591390979880e+02
RINT28003 nd5968 nd5969 2.604094330713e+02
RINT28004 nd5969 nd5970 1.303705308206e+02
RINT28005 nd5970 nd5971 1.608894908578e+00
RINT28006 nd5971 nd5972 2.789737223720e+01
RINT28007 nd5972 nd5973 2.744632754910e+01
RINT28008 nd5973 nd5974 1.984071871019e+00
RINT28009 nd5974 nd5975 1.984071871019e+00
RINT28010 nd5975 nd5976 1.984071871019e+00
RINT28011 nd5976 nd5977 1.984071871019e+00
RINT28012 nd5977 nd5978 1.984071871019e+00
RINT28013 nd5978 nd5979 1.984071871019e+00
RINT28014 nd5979 nd5980 1.984071871019e+00
RINT28015 nd5980 nd5981 1.984071871019e+00
RINT28016 nd5981 nd5982 1.984071871019e+00
RINT28017 nd5983 nd5984 1.914284617627e-01
RINT28018 nd5984 nd5985 1.740035002137e-01
RINT28019 nd5985 nd5986 5.881581083666e+00
RINT28020 nd5986 nd5987 5.981136757300e+00
RINT28021 nd5987 nd5988 3.668883239623e-01
RINT28022 nd5988 nd5989 3.606618004430e-01
RINT28023 nd5989 nd5990 1.976741618838e-01
RINT28024 nd5990 nd5991 8.656063970739e-02
RINT28025 nd5991 nd5992 1.760179307529e-01
RINT28026 nd5992 nd5993 2.136011054157e-01
RINT28027 nd5993 nd5994 2.136011054157e-01
RINT28028 nd5994 nd5995 2.136011054157e-01
RINT28029 nd5995 nd5996 2.136011054157e-01
RINT28030 nd5996 nd5997 2.136011054157e-01
RINT28031 nd5997 nd5998 2.136011054157e-01
RINT28032 nd5998 nd5999 2.884961700761e-01
RINT28033 nd5999 nd6000 4.298149835847e-01
RINT28034 nd6000 nd6001 2.654372658145e-01
RINT28035 nd6001 nd6002 1.680354650659e-01
RINT28036 nd6002 nd6003 2.913644572433e+00
RINT28037 nd6003 nd6004 2.866536769726e+00
RINT28038 nd6004 nd6005 2.072195255224e-01
RINT28039 nd6005 nd6006 2.072195255224e-01
RINT28040 nd6006 nd6007 2.072195255224e-01
RINT28041 nd6007 nd6008 2.072195255224e-01
RINT28042 nd6008 nd6009 2.072195255224e-01
RINT28043 nd6009 nd6010 2.072195255224e-01
RINT28044 nd6010 nd6011 2.072195255224e-01
RINT28045 nd6011 nd6012 2.072195255224e-01
RINT28046 nd6012 nd6013 2.072195255224e-01
RINT28047 nd6014 nd6015 1.914284617627e-01
RINT28048 nd6015 nd6016 1.740035002137e-01
RINT28049 nd6016 nd6017 5.881581083666e+00
RINT28050 nd6017 nd6018 5.981136757300e+00
RINT28051 nd6018 nd6019 3.668883239623e-01
RINT28052 nd6019 nd6020 3.606618004430e-01
RINT28053 nd6020 nd6021 1.976741618838e-01
RINT28054 nd6021 nd6022 8.656063970739e-02
RINT28055 nd6022 nd6023 1.760179307529e-01
RINT28056 nd6023 nd6024 2.136011054157e-01
RINT28057 nd6024 nd6025 2.136011054157e-01
RINT28058 nd6025 nd6026 2.136011054157e-01
RINT28059 nd6026 nd6027 2.136011054157e-01
RINT28060 nd6027 nd6028 2.136011054157e-01
RINT28061 nd6028 nd6029 2.136011054157e-01
RINT28062 nd6029 nd6030 2.884961700761e-01
RINT28063 nd6030 nd6031 4.298149835847e-01
RINT28064 nd6031 nd6032 2.654372658145e-01
RINT28065 nd6032 nd6033 1.680354650659e-01
RINT28066 nd6033 nd6034 2.913644572433e+00
RINT28067 nd6034 nd6035 2.866536769726e+00
RINT28068 nd6035 nd6036 2.072195255224e-01
RINT28069 nd6036 nd6037 2.072195255224e-01
RINT28070 nd6037 nd6038 2.072195255224e-01
RINT28071 nd6038 nd6039 2.072195255224e-01
RINT28072 nd6039 nd6040 2.072195255224e-01
RINT28073 nd6040 nd6041 2.072195255224e-01
RINT28074 nd6041 nd6042 2.072195255224e-01
RINT28075 nd6042 nd6043 2.072195255224e-01
RINT28076 nd6043 nd6044 2.072195255224e-01
RINT28077 nd6045 nd6046 1.914284617627e-01
RINT28078 nd6046 nd6047 1.740035002137e-01
RINT28079 nd6047 nd6048 5.881581083666e+00
RINT28080 nd6048 nd6049 5.981136757300e+00
RINT28081 nd6049 nd6050 3.668883239623e-01
RINT28082 nd6050 nd6051 3.606618004430e-01
RINT28083 nd6051 nd6052 1.976741618838e-01
RINT28084 nd6052 nd6053 8.656063970739e-02
RINT28085 nd6053 nd6054 1.760179307529e-01
RINT28086 nd6054 nd6055 2.136011054157e-01
RINT28087 nd6055 nd6056 2.136011054157e-01
RINT28088 nd6056 nd6057 2.136011054157e-01
RINT28089 nd6057 nd6058 2.136011054157e-01
RINT28090 nd6058 nd6059 2.136011054157e-01
RINT28091 nd6059 nd6060 2.136011054157e-01
RINT28092 nd6060 nd6061 2.884961700761e-01
RINT28093 nd6061 nd6062 4.298149835847e-01
RINT28094 nd6062 nd6063 2.654372658145e-01
RINT28095 nd6063 nd6064 1.680354650659e-01
RINT28096 nd6064 nd6065 2.913644572433e+00
RINT28097 nd6065 nd6066 2.866536769726e+00
RINT28098 nd6066 nd6067 2.072195255224e-01
RINT28099 nd6067 nd6068 2.072195255224e-01
RINT28100 nd6068 nd6069 2.072195255224e-01
RINT28101 nd6069 nd6070 2.072195255224e-01
RINT28102 nd6070 nd6071 2.072195255224e-01
RINT28103 nd6071 nd6072 2.072195255224e-01
RINT28104 nd6072 nd6073 2.072195255224e-01
RINT28105 nd6073 nd6074 2.072195255224e-01
RINT28106 nd6074 nd6075 2.072195255224e-01
RINT28107 nd6076 nd6077 1.914284617627e-01
RINT28108 nd6077 nd6078 1.740035002137e-01
RINT28109 nd6078 nd6079 5.881581083666e+00
RINT28110 nd6079 nd6080 5.981136757300e+00
RINT28111 nd6080 nd6081 3.668883239623e-01
RINT28112 nd6081 nd6082 3.606618004430e-01
RINT28113 nd6082 nd6083 1.976741618838e-01
RINT28114 nd6083 nd6084 8.656063970739e-02
RINT28115 nd6084 nd6085 1.760179307529e-01
RINT28116 nd6085 nd6086 2.136011054157e-01
RINT28117 nd6086 nd6087 2.136011054157e-01
RINT28118 nd6087 nd6088 2.136011054157e-01
RINT28119 nd6088 nd6089 2.136011054157e-01
RINT28120 nd6089 nd6090 2.136011054157e-01
RINT28121 nd6090 nd6091 2.136011054157e-01
RINT28122 nd6091 nd6092 2.884961700761e-01
RINT28123 nd6092 nd6093 4.298149835847e-01
RINT28124 nd6093 nd6094 2.654372658145e-01
RINT28125 nd6094 nd6095 1.680354650659e-01
RINT28126 nd6095 nd6096 2.913644572433e+00
RINT28127 nd6096 nd6097 2.866536769726e+00
RINT28128 nd6097 nd6098 2.072195255224e-01
RINT28129 nd6098 nd6099 2.072195255224e-01
RINT28130 nd6099 nd6100 2.072195255224e-01
RINT28131 nd6100 nd6101 2.072195255224e-01
RINT28132 nd6101 nd6102 2.072195255224e-01
RINT28133 nd6102 nd6103 2.072195255224e-01
RINT28134 nd6103 nd6104 2.072195255224e-01
RINT28135 nd6104 nd6105 2.072195255224e-01
RINT28136 nd6105 nd6106 2.072195255224e-01
RINT28137 nd6107 nd6108 1.914284617627e-01
RINT28138 nd6108 nd6109 1.740035002137e-01
RINT28139 nd6109 nd6110 5.881581083666e+00
RINT28140 nd6110 nd6111 5.981136757300e+00
RINT28141 nd6111 nd6112 3.668883239623e-01
RINT28142 nd6112 nd6113 3.606618004430e-01
RINT28143 nd6113 nd6114 1.976741618838e-01
RINT28144 nd6114 nd6115 8.656063970739e-02
RINT28145 nd6115 nd6116 1.760179307529e-01
RINT28146 nd6116 nd6117 2.136011054157e-01
RINT28147 nd6117 nd6118 2.136011054157e-01
RINT28148 nd6118 nd6119 2.136011054157e-01
RINT28149 nd6119 nd6120 2.136011054157e-01
RINT28150 nd6120 nd6121 2.136011054157e-01
RINT28151 nd6121 nd6122 2.136011054157e-01
RINT28152 nd6122 nd6123 2.884961700761e-01
RINT28153 nd6123 nd6124 4.298149835847e-01
RINT28154 nd6124 nd6125 2.654372658145e-01
RINT28155 nd6125 nd6126 1.680354650659e-01
RINT28156 nd6126 nd6127 2.913644572433e+00
RINT28157 nd6127 nd6128 2.866536769726e+00
RINT28158 nd6128 nd6129 2.072195255224e-01
RINT28159 nd6129 nd6130 2.072195255224e-01
RINT28160 nd6130 nd6131 2.072195255224e-01
RINT28161 nd6131 nd6132 2.072195255224e-01
RINT28162 nd6132 nd6133 2.072195255224e-01
RINT28163 nd6133 nd6134 2.072195255224e-01
RINT28164 nd6134 nd6135 2.072195255224e-01
RINT28165 nd6135 nd6136 2.072195255224e-01
RINT28166 nd6136 nd6137 2.072195255224e-01
RINT28167 nd6138 nd6139 1.914284617627e-01
RINT28168 nd6139 nd6140 1.740035002137e-01
RINT28169 nd6140 nd6141 5.881581083666e+00
RINT28170 nd6141 nd6142 5.981136757300e+00
RINT28171 nd6142 nd6143 3.668883239623e-01
RINT28172 nd6143 nd6144 3.606618004430e-01
RINT28173 nd6144 nd6145 1.976741618838e-01
RINT28174 nd6145 nd6146 8.656063970739e-02
RINT28175 nd6146 nd6147 1.760179307529e-01
RINT28176 nd6147 nd6148 2.136011054157e-01
RINT28177 nd6148 nd6149 2.136011054157e-01
RINT28178 nd6149 nd6150 2.136011054157e-01
RINT28179 nd6150 nd6151 2.136011054157e-01
RINT28180 nd6151 nd6152 2.136011054157e-01
RINT28181 nd6152 nd6153 2.136011054157e-01
RINT28182 nd6153 nd6154 2.884961700761e-01
RINT28183 nd6154 nd6155 4.298149835847e-01
RINT28184 nd6155 nd6156 2.654372658145e-01
RINT28185 nd6156 nd6157 1.680354650659e-01
RINT28186 nd6157 nd6158 2.913644572433e+00
RINT28187 nd6158 nd6159 2.866536769726e+00
RINT28188 nd6159 nd6160 2.072195255224e-01
RINT28189 nd6160 nd6161 2.072195255224e-01
RINT28190 nd6161 nd6162 2.072195255224e-01
RINT28191 nd6162 nd6163 2.072195255224e-01
RINT28192 nd6163 nd6164 2.072195255224e-01
RINT28193 nd6164 nd6165 2.072195255224e-01
RINT28194 nd6165 nd6166 2.072195255224e-01
RINT28195 nd6166 nd6167 2.072195255224e-01
RINT28196 nd6167 nd6168 2.072195255224e-01
RINT28197 nd6169 nd6170 1.832876633312e+00
RINT28198 nd6170 nd6171 1.666037258616e+00
RINT28199 nd6171 nd6172 5.631457535579e+01
RINT28200 nd6172 nd6173 5.726779446562e+01
RINT28201 nd6173 nd6174 3.512858170793e+00
RINT28202 nd6174 nd6175 3.453240863313e+00
RINT28203 nd6175 nd6176 9.993586560904e+00
RINT28204 nd6176 nd6177 5.786876290473e+01
RINT28205 nd6177 nd6178 7.853617822785e+01
RINT28206 nd6178 nd6179 5.786876290473e+01
RINT28207 nd6179 nd6180 5.786876290473e+01
RINT28208 nd6180 nd6181 5.786876290473e+01
RINT28209 nd6181 nd6182 5.786876290473e+01
RINT28210 nd6182 nd6183 5.786876290473e+01
RINT28211 nd6183 nd6184 5.786876290473e+01
RINT28212 nd6184 nd6185 1.591390979880e+02
RINT28213 nd6185 nd6186 2.604094330713e+02
RINT28214 nd6186 nd6187 1.303705308206e+02
RINT28215 nd6187 nd6188 1.608894908578e+00
RINT28216 nd6188 nd6189 2.789737223720e+01
RINT28217 nd6189 nd6190 2.744632754910e+01
RINT28218 nd6190 nd6191 1.984071871019e+00
RINT28219 nd6191 nd6192 1.984071871019e+00
RINT28220 nd6192 nd6193 1.984071871019e+00
RINT28221 nd6193 nd6194 1.984071871019e+00
RINT28222 nd6194 nd6195 1.984071871019e+00
RINT28223 nd6195 nd6196 1.984071871019e+00
RINT28224 nd6196 nd6197 1.984071871019e+00
RINT28225 nd6197 nd6198 1.984071871019e+00
RINT28226 nd6198 nd6199 1.984071871019e+00
RINT28227 nd6200 nd6201 1.914284617627e-01
RINT28228 nd6201 nd6202 1.740035002137e-01
RINT28229 nd6202 nd6203 5.881581083666e+00
RINT28230 nd6203 nd6204 5.981136757300e+00
RINT28231 nd6204 nd6205 3.668883239623e-01
RINT28232 nd6205 nd6206 3.606618004430e-01
RINT28233 nd6206 nd6207 1.976741618838e-01
RINT28234 nd6207 nd6208 8.656063970739e-02
RINT28235 nd6208 nd6209 1.760179307529e-01
RINT28236 nd6209 nd6210 2.136011054157e-01
RINT28237 nd6210 nd6211 2.136011054157e-01
RINT28238 nd6211 nd6212 2.136011054157e-01
RINT28239 nd6212 nd6213 2.136011054157e-01
RINT28240 nd6213 nd6214 2.136011054157e-01
RINT28241 nd6214 nd6215 2.136011054157e-01
RINT28242 nd6215 nd6216 2.884961700761e-01
RINT28243 nd6216 nd6217 4.298149835847e-01
RINT28244 nd6217 nd6218 2.654372658145e-01
RINT28245 nd6218 nd6219 1.680354650659e-01
RINT28246 nd6219 nd6220 2.913644572433e+00
RINT28247 nd6220 nd6221 2.866536769726e+00
RINT28248 nd6221 nd6222 2.072195255224e-01
RINT28249 nd6222 nd6223 2.072195255224e-01
RINT28250 nd6223 nd6224 2.072195255224e-01
RINT28251 nd6224 nd6225 2.072195255224e-01
RINT28252 nd6225 nd6226 2.072195255224e-01
RINT28253 nd6226 nd6227 2.072195255224e-01
RINT28254 nd6227 nd6228 2.072195255224e-01
RINT28255 nd6228 nd6229 2.072195255224e-01
RINT28256 nd6229 nd6230 2.072195255224e-01
RINT28257 nd6231 nd6232 1.914284617627e-01
RINT28258 nd6232 nd6233 1.740035002137e-01
RINT28259 nd6233 nd6234 5.881581083666e+00
RINT28260 nd6234 nd6235 5.981136757300e+00
RINT28261 nd6235 nd6236 3.668883239623e-01
RINT28262 nd6236 nd6237 3.606618004430e-01
RINT28263 nd6237 nd6238 1.976741618838e-01
RINT28264 nd6238 nd6239 8.656063970738e-02
RINT28265 nd6239 nd6240 1.760179307529e-01
RINT28266 nd6240 nd6241 2.136011054157e-01
RINT28267 nd6241 nd6242 2.136011054157e-01
RINT28268 nd6242 nd6243 2.136011054157e-01
RINT28269 nd6243 nd6244 2.136011054157e-01
RINT28270 nd6244 nd6245 2.136011054157e-01
RINT28271 nd6245 nd6246 2.136011054157e-01
RINT28272 nd6246 nd6247 2.884961700761e-01
RINT28273 nd6247 nd6248 4.298149835847e-01
RINT28274 nd6248 nd6249 2.654372658145e-01
RINT28275 nd6249 nd6250 1.680354650659e-01
RINT28276 nd6250 nd6251 2.913644572433e+00
RINT28277 nd6251 nd6252 2.866536769726e+00
RINT28278 nd6252 nd6253 2.072195255224e-01
RINT28279 nd6253 nd6254 2.072195255224e-01
RINT28280 nd6254 nd6255 2.072195255224e-01
RINT28281 nd6255 nd6256 2.072195255224e-01
RINT28282 nd6256 nd6257 2.072195255224e-01
RINT28283 nd6257 nd6258 2.072195255224e-01
RINT28284 nd6258 nd6259 2.072195255224e-01
RINT28285 nd6259 nd6260 2.072195255224e-01
RINT28286 nd6260 nd6261 2.072195255224e-01
RINT28287 nd6262 nd6263 1.914284617627e-01
RINT28288 nd6263 nd6264 1.740035002137e-01
RINT28289 nd6264 nd6265 5.881581083666e+00
RINT28290 nd6265 nd6266 5.981136757300e+00
RINT28291 nd6266 nd6267 3.668883239623e-01
RINT28292 nd6267 nd6268 3.606618004430e-01
RINT28293 nd6268 nd6269 1.976741618838e-01
RINT28294 nd6269 nd6270 8.656063970739e-02
RINT28295 nd6270 nd6271 1.760179307529e-01
RINT28296 nd6271 nd6272 2.136011054157e-01
RINT28297 nd6272 nd6273 2.136011054157e-01
RINT28298 nd6273 nd6274 2.136011054157e-01
RINT28299 nd6274 nd6275 2.136011054157e-01
RINT28300 nd6275 nd6276 2.136011054157e-01
RINT28301 nd6276 nd6277 2.136011054157e-01
RINT28302 nd6277 nd6278 2.884961700761e-01
RINT28303 nd6278 nd6279 4.298149835847e-01
RINT28304 nd6279 nd6280 2.654372658145e-01
RINT28305 nd6280 nd6281 1.680354650659e-01
RINT28306 nd6281 nd6282 2.913644572433e+00
RINT28307 nd6282 nd6283 2.866536769726e+00
RINT28308 nd6283 nd6284 2.072195255224e-01
RINT28309 nd6284 nd6285 2.072195255224e-01
RINT28310 nd6285 nd6286 2.072195255224e-01
RINT28311 nd6286 nd6287 2.072195255224e-01
RINT28312 nd6287 nd6288 2.072195255224e-01
RINT28313 nd6288 nd6289 2.072195255224e-01
RINT28314 nd6289 nd6290 2.072195255224e-01
RINT28315 nd6290 nd6291 2.072195255224e-01
RINT28316 nd6291 nd6292 2.072195255224e-01
RINT28317 nd6293 nd6294 1.914284617627e-01
RINT28318 nd6294 nd6295 1.740035002137e-01
RINT28319 nd6295 nd6296 5.881581083666e+00
RINT28320 nd6296 nd6297 5.981136757300e+00
RINT28321 nd6297 nd6298 3.668883239623e-01
RINT28322 nd6298 nd6299 3.606618004430e-01
RINT28323 nd6299 nd6300 1.976741618838e-01
RINT28324 nd6300 nd6301 8.656063970739e-02
RINT28325 nd6301 nd6302 1.760179307529e-01
RINT28326 nd6302 nd6303 2.136011054157e-01
RINT28327 nd6303 nd6304 2.136011054157e-01
RINT28328 nd6304 nd6305 2.136011054157e-01
RINT28329 nd6305 nd6306 2.136011054157e-01
RINT28330 nd6306 nd6307 2.136011054157e-01
RINT28331 nd6307 nd6308 2.136011054157e-01
RINT28332 nd6308 nd6309 2.884961700761e-01
RINT28333 nd6309 nd6310 4.298149835847e-01
RINT28334 nd6310 nd6311 2.654372658145e-01
RINT28335 nd6311 nd6312 1.680354650659e-01
RINT28336 nd6312 nd6313 2.913644572433e+00
RINT28337 nd6313 nd6314 2.866536769726e+00
RINT28338 nd6314 nd6315 2.072195255224e-01
RINT28339 nd6315 nd6316 2.072195255224e-01
RINT28340 nd6316 nd6317 2.072195255224e-01
RINT28341 nd6317 nd6318 2.072195255224e-01
RINT28342 nd6318 nd6319 2.072195255224e-01
RINT28343 nd6319 nd6320 2.072195255224e-01
RINT28344 nd6320 nd6321 2.072195255224e-01
RINT28345 nd6321 nd6322 2.072195255224e-01
RINT28346 nd6322 nd6323 2.072195255224e-01
RINT28347 nd6324 nd6325 1.914284617627e-01
RINT28348 nd6325 nd6326 1.740035002137e-01
RINT28349 nd6326 nd6327 5.881581083666e+00
RINT28350 nd6327 nd6328 5.981136757300e+00
RINT28351 nd6328 nd6329 3.668883239623e-01
RINT28352 nd6329 nd6330 3.606618004430e-01
RINT28353 nd6330 nd6331 1.976741618838e-01
RINT28354 nd6331 nd6332 8.656063970738e-02
RINT28355 nd6332 nd6333 1.760179307529e-01
RINT28356 nd6333 nd6334 2.136011054157e-01
RINT28357 nd6334 nd6335 2.136011054157e-01
RINT28358 nd6335 nd6336 2.136011054157e-01
RINT28359 nd6336 nd6337 2.136011054157e-01
RINT28360 nd6337 nd6338 2.136011054157e-01
RINT28361 nd6338 nd6339 2.136011054157e-01
RINT28362 nd6339 nd6340 2.884961700761e-01
RINT28363 nd6340 nd6341 4.298149835847e-01
RINT28364 nd6341 nd6342 2.654372658145e-01
RINT28365 nd6342 nd6343 1.680354650659e-01
RINT28366 nd6343 nd6344 2.913644572433e+00
RINT28367 nd6344 nd6345 2.866536769726e+00
RINT28368 nd6345 nd6346 2.072195255224e-01
RINT28369 nd6346 nd6347 2.072195255224e-01
RINT28370 nd6347 nd6348 2.072195255224e-01
RINT28371 nd6348 nd6349 2.072195255224e-01
RINT28372 nd6349 nd6350 2.072195255224e-01
RINT28373 nd6350 nd6351 2.072195255224e-01
RINT28374 nd6351 nd6352 2.072195255224e-01
RINT28375 nd6352 nd6353 2.072195255224e-01
RINT28376 nd6353 nd6354 2.072195255224e-01
RINT28377 nd6355 nd6356 1.914284617627e-01
RINT28378 nd6356 nd6357 1.740035002137e-01
RINT28379 nd6357 nd6358 5.881581083666e+00
RINT28380 nd6358 nd6359 5.981136757300e+00
RINT28381 nd6359 nd6360 3.668883239623e-01
RINT28382 nd6360 nd6361 3.606618004430e-01
RINT28383 nd6361 nd6362 1.976741618838e-01
RINT28384 nd6362 nd6363 8.656063970739e-02
RINT28385 nd6363 nd6364 1.760179307529e-01
RINT28386 nd6364 nd6365 2.136011054157e-01
RINT28387 nd6365 nd6366 2.136011054157e-01
RINT28388 nd6366 nd6367 2.136011054157e-01
RINT28389 nd6367 nd6368 2.136011054157e-01
RINT28390 nd6368 nd6369 2.136011054157e-01
RINT28391 nd6369 nd6370 2.136011054157e-01
RINT28392 nd6370 nd6371 2.884961700761e-01
RINT28393 nd6371 nd6372 4.298149835847e-01
RINT28394 nd6372 nd6373 2.654372658145e-01
RINT28395 nd6373 nd6374 1.680354650659e-01
RINT28396 nd6374 nd6375 2.913644572433e+00
RINT28397 nd6375 nd6376 2.866536769726e+00
RINT28398 nd6376 nd6377 2.072195255224e-01
RINT28399 nd6377 nd6378 2.072195255224e-01
RINT28400 nd6378 nd6379 2.072195255224e-01
RINT28401 nd6379 nd6380 2.072195255224e-01
RINT28402 nd6380 nd6381 2.072195255224e-01
RINT28403 nd6381 nd6382 2.072195255224e-01
RINT28404 nd6382 nd6383 2.072195255224e-01
RINT28405 nd6383 nd6384 2.072195255224e-01
RINT28406 nd6384 nd6385 2.072195255224e-01
RINT28407 nd6386 nd6387 1.832876633312e+00
RINT28408 nd6387 nd6388 1.666037258616e+00
RINT28409 nd6388 nd6389 5.631457535579e+01
RINT28410 nd6389 nd6390 5.726779446562e+01
RINT28411 nd6390 nd6391 3.512858170793e+00
RINT28412 nd6391 nd6392 3.453240863313e+00
RINT28413 nd6392 nd6393 9.993586560904e+00
RINT28414 nd6393 nd6394 5.786876290473e+01
RINT28415 nd6394 nd6395 7.853617822785e+01
RINT28416 nd6395 nd6396 5.786876290473e+01
RINT28417 nd6396 nd6397 5.786876290473e+01
RINT28418 nd6397 nd6398 5.786876290473e+01
RINT28419 nd6398 nd6399 5.786876290473e+01
RINT28420 nd6399 nd6400 5.786876290473e+01
RINT28421 nd6400 nd6401 5.786876290473e+01
RINT28422 nd6401 nd6402 1.591390979880e+02
RINT28423 nd6402 nd6403 2.604094330713e+02
RINT28424 nd6403 nd6404 1.303705308206e+02
RINT28425 nd6404 nd6405 1.608894908578e+00
RINT28426 nd6405 nd6406 2.789737223720e+01
RINT28427 nd6406 nd6407 2.744632754910e+01
RINT28428 nd6407 nd6408 1.984071871019e+00
RINT28429 nd6408 nd6409 1.984071871019e+00
RINT28430 nd6409 nd6410 1.984071871019e+00
RINT28431 nd6410 nd6411 1.984071871019e+00
RINT28432 nd6411 nd6412 1.984071871019e+00
RINT28433 nd6412 nd6413 1.984071871019e+00
RINT28434 nd6413 nd6414 1.984071871019e+00
RINT28435 nd6414 nd6415 1.984071871019e+00
RINT28436 nd6415 nd6416 1.984071871019e+00
RINT28437 nd6417 nd6418 2.493313941068e-01
RINT28438 nd6418 nd6419 2.266357619356e-01
RINT28439 nd6419 nd6420 7.660631014006e+00
RINT28440 nd6420 nd6421 7.790300106417e+00
RINT28441 nd6421 nd6422 4.778640357485e-01
RINT28442 nd6422 nd6423 4.697541247393e-01
RINT28443 nd6423 nd6424 2.520135011038e-01
RINT28444 nd6424 nd6425 1.199550711388e-01
RINT28445 nd6425 nd6426 1.627961679741e-01
RINT28446 nd6426 nd6427 1.199550711388e-01
RINT28447 nd6427 nd6428 1.199550711388e-01
RINT28448 nd6428 nd6429 1.199550711388e-01
RINT28449 nd6429 nd6430 1.199550711388e-01
RINT28450 nd6430 nd6431 1.199550711388e-01
RINT28451 nd6431 nd6432 1.199550711388e-01
RINT28452 nd6432 nd6433 3.298764456317e-01
RINT28453 nd6433 nd6434 5.397978201245e-01
RINT28454 nd6434 nd6435 2.924550963786e-01
RINT28455 nd6435 nd6436 2.188625263897e-01
RINT28456 nd6436 nd6437 3.794958474237e+00
RINT28457 nd6437 nd6438 3.733601589195e+00
RINT28458 nd6438 nd6439 2.698989100623e-01
RINT28459 nd6439 nd6440 2.698989100623e-01
RINT28460 nd6440 nd6441 2.698989100623e-01
RINT28461 nd6441 nd6442 2.698989100623e-01
RINT28462 nd6442 nd6443 2.698989100623e-01
RINT28463 nd6443 nd6444 2.698989100623e-01
RINT28464 nd6444 nd6445 2.698989100623e-01
RINT28465 nd6445 nd6446 2.698989100623e-01
RINT28466 nd6446 nd6447 2.698989100623e-01
RINT28467 nd6448 nd6449 2.493313941068e-01
RINT28468 nd6449 nd6450 2.266357619356e-01
RINT28469 nd6450 nd6451 7.660631014006e+00
RINT28470 nd6451 nd6452 7.790300106417e+00
RINT28471 nd6452 nd6453 4.778640357485e-01
RINT28472 nd6453 nd6454 4.697541247393e-01
RINT28473 nd6454 nd6455 2.520135011038e-01
RINT28474 nd6455 nd6456 1.199550711388e-01
RINT28475 nd6456 nd6457 1.627961679741e-01
RINT28476 nd6457 nd6458 1.199550711388e-01
RINT28477 nd6458 nd6459 1.199550711388e-01
RINT28478 nd6459 nd6460 1.199550711388e-01
RINT28479 nd6460 nd6461 1.199550711388e-01
RINT28480 nd6461 nd6462 1.199550711388e-01
RINT28481 nd6462 nd6463 1.199550711388e-01
RINT28482 nd6463 nd6464 3.298764456317e-01
RINT28483 nd6464 nd6465 5.397978201245e-01
RINT28484 nd6465 nd6466 2.924550963786e-01
RINT28485 nd6466 nd6467 2.188625263897e-01
RINT28486 nd6467 nd6468 3.794958474237e+00
RINT28487 nd6468 nd6469 3.733601589195e+00
RINT28488 nd6469 nd6470 2.698989100623e-01
RINT28489 nd6470 nd6471 2.698989100623e-01
RINT28490 nd6471 nd6472 2.698989100623e-01
RINT28491 nd6472 nd6473 2.698989100623e-01
RINT28492 nd6473 nd6474 2.698989100623e-01
RINT28493 nd6474 nd6475 2.698989100623e-01
RINT28494 nd6475 nd6476 2.698989100623e-01
RINT28495 nd6476 nd6477 2.698989100623e-01
RINT28496 nd6477 nd6478 2.698989100623e-01
RINT28497 nd6479 nd6480 2.493313941068e-01
RINT28498 nd6480 nd6481 2.266357619356e-01
RINT28499 nd6481 nd6482 7.660631014006e+00
RINT28500 nd6482 nd6483 7.790300106417e+00
RINT28501 nd6483 nd6484 4.778640357485e-01
RINT28502 nd6484 nd6485 4.697541247393e-01
RINT28503 nd6485 nd6486 2.520135011038e-01
RINT28504 nd6486 nd6487 1.199550711388e-01
RINT28505 nd6487 nd6488 1.627961679741e-01
RINT28506 nd6488 nd6489 1.199550711388e-01
RINT28507 nd6489 nd6490 1.199550711388e-01
RINT28508 nd6490 nd6491 1.199550711388e-01
RINT28509 nd6491 nd6492 1.199550711388e-01
RINT28510 nd6492 nd6493 1.199550711388e-01
RINT28511 nd6493 nd6494 1.199550711388e-01
RINT28512 nd6494 nd6495 3.298764456317e-01
RINT28513 nd6495 nd6496 5.397978201245e-01
RINT28514 nd6496 nd6497 2.924550963786e-01
RINT28515 nd6497 nd6498 2.188625263897e-01
RINT28516 nd6498 nd6499 3.794958474237e+00
RINT28517 nd6499 nd6500 3.733601589195e+00
RINT28518 nd6500 nd6501 2.698989100623e-01
RINT28519 nd6501 nd6502 2.698989100623e-01
RINT28520 nd6502 nd6503 2.698989100623e-01
RINT28521 nd6503 nd6504 2.698989100623e-01
RINT28522 nd6504 nd6505 2.698989100623e-01
RINT28523 nd6505 nd6506 2.698989100623e-01
RINT28524 nd6506 nd6507 2.698989100623e-01
RINT28525 nd6507 nd6508 2.698989100623e-01
RINT28526 nd6508 nd6509 2.698989100623e-01
RINT28527 nd6510 nd6511 2.493313941068e-01
RINT28528 nd6511 nd6512 2.266357619356e-01
RINT28529 nd6512 nd6513 7.660631014006e+00
RINT28530 nd6513 nd6514 7.790300106417e+00
RINT28531 nd6514 nd6515 4.778640357485e-01
RINT28532 nd6515 nd6516 4.697541247393e-01
RINT28533 nd6516 nd6517 2.520135011038e-01
RINT28534 nd6517 nd6518 1.199550711388e-01
RINT28535 nd6518 nd6519 1.627961679741e-01
RINT28536 nd6519 nd6520 1.199550711388e-01
RINT28537 nd6520 nd6521 1.199550711388e-01
RINT28538 nd6521 nd6522 1.199550711388e-01
RINT28539 nd6522 nd6523 1.199550711388e-01
RINT28540 nd6523 nd6524 1.199550711388e-01
RINT28541 nd6524 nd6525 1.199550711388e-01
RINT28542 nd6525 nd6526 3.298764456317e-01
RINT28543 nd6526 nd6527 5.397978201245e-01
RINT28544 nd6527 nd6528 2.924550963786e-01
RINT28545 nd6528 nd6529 2.188625263897e-01
RINT28546 nd6529 nd6530 3.794958474237e+00
RINT28547 nd6530 nd6531 3.733601589195e+00
RINT28548 nd6531 nd6532 2.698989100623e-01
RINT28549 nd6532 nd6533 2.698989100623e-01
RINT28550 nd6533 nd6534 2.698989100623e-01
RINT28551 nd6534 nd6535 2.698989100623e-01
RINT28552 nd6535 nd6536 2.698989100623e-01
RINT28553 nd6536 nd6537 2.698989100623e-01
RINT28554 nd6537 nd6538 2.698989100623e-01
RINT28555 nd6538 nd6539 2.698989100623e-01
RINT28556 nd6539 nd6540 2.698989100623e-01
RINT28557 nd6541 nd6542 2.493313941068e-01
RINT28558 nd6542 nd6543 2.266357619356e-01
RINT28559 nd6543 nd6544 7.660631014006e+00
RINT28560 nd6544 nd6545 7.790300106417e+00
RINT28561 nd6545 nd6546 4.778640357485e-01
RINT28562 nd6546 nd6547 4.697541247393e-01
RINT28563 nd6547 nd6548 2.520135011038e-01
RINT28564 nd6548 nd6549 1.199550711388e-01
RINT28565 nd6549 nd6550 1.627961679741e-01
RINT28566 nd6550 nd6551 1.199550711388e-01
RINT28567 nd6551 nd6552 1.199550711388e-01
RINT28568 nd6552 nd6553 1.199550711388e-01
RINT28569 nd6553 nd6554 1.199550711388e-01
RINT28570 nd6554 nd6555 1.199550711388e-01
RINT28571 nd6555 nd6556 1.199550711388e-01
RINT28572 nd6556 nd6557 3.298764456317e-01
RINT28573 nd6557 nd6558 5.397978201245e-01
RINT28574 nd6558 nd6559 2.924550963786e-01
RINT28575 nd6559 nd6560 2.188625263897e-01
RINT28576 nd6560 nd6561 3.794958474237e+00
RINT28577 nd6561 nd6562 3.733601589195e+00
RINT28578 nd6562 nd6563 2.698989100623e-01
RINT28579 nd6563 nd6564 2.698989100623e-01
RINT28580 nd6564 nd6565 2.698989100623e-01
RINT28581 nd6565 nd6566 2.698989100623e-01
RINT28582 nd6566 nd6567 2.698989100623e-01
RINT28583 nd6567 nd6568 2.698989100623e-01
RINT28584 nd6568 nd6569 2.698989100623e-01
RINT28585 nd6569 nd6570 2.698989100623e-01
RINT28586 nd6570 nd6571 2.698989100623e-01
RINT28587 nd6572 nd6573 2.493313941068e-01
RINT28588 nd6573 nd6574 2.266357619356e-01
RINT28589 nd6574 nd6575 7.660631014006e+00
RINT28590 nd6575 nd6576 7.790300106417e+00
RINT28591 nd6576 nd6577 4.778640357485e-01
RINT28592 nd6577 nd6578 4.697541247393e-01
RINT28593 nd6578 nd6579 2.520135011038e-01
RINT28594 nd6579 nd6580 1.199550711388e-01
RINT28595 nd6580 nd6581 1.627961679741e-01
RINT28596 nd6581 nd6582 1.199550711388e-01
RINT28597 nd6582 nd6583 1.199550711388e-01
RINT28598 nd6583 nd6584 1.199550711388e-01
RINT28599 nd6584 nd6585 1.199550711388e-01
RINT28600 nd6585 nd6586 1.199550711388e-01
RINT28601 nd6586 nd6587 1.199550711388e-01
RINT28602 nd6587 nd6588 3.298764456317e-01
RINT28603 nd6588 nd6589 5.397978201245e-01
RINT28604 nd6589 nd6590 2.924550963786e-01
RINT28605 nd6590 nd6591 2.188625263897e-01
RINT28606 nd6591 nd6592 3.794958474237e+00
RINT28607 nd6592 nd6593 3.733601589195e+00
RINT28608 nd6593 nd6594 2.698989100623e-01
RINT28609 nd6594 nd6595 2.698989100623e-01
RINT28610 nd6595 nd6596 2.698989100623e-01
RINT28611 nd6596 nd6597 2.698989100623e-01
RINT28612 nd6597 nd6598 2.698989100623e-01
RINT28613 nd6598 nd6599 2.698989100623e-01
RINT28614 nd6599 nd6600 2.698989100623e-01
RINT28615 nd6600 nd6601 2.698989100623e-01
RINT28616 nd6601 nd6602 2.698989100623e-01
RINT28617 nd6603 nd6604 1.832876633312e+00
RINT28618 nd6604 nd6605 1.666037258616e+00
RINT28619 nd6605 nd6606 5.631457535580e+01
RINT28620 nd6606 nd6607 5.726779446562e+01
RINT28621 nd6607 nd6608 3.512858170793e+00
RINT28622 nd6608 nd6609 3.453240863313e+00
RINT28623 nd6609 nd6610 9.993586560904e+00
RINT28624 nd6610 nd6611 5.786876290473e+01
RINT28625 nd6611 nd6612 7.853617822785e+01
RINT28626 nd6612 nd6613 5.786876290473e+01
RINT28627 nd6613 nd6614 5.786876290473e+01
RINT28628 nd6614 nd6615 5.786876290473e+01
RINT28629 nd6615 nd6616 5.786876290473e+01
RINT28630 nd6616 nd6617 5.786876290473e+01
RINT28631 nd6617 nd6618 5.786876290473e+01
RINT28632 nd6618 nd6619 1.591390979880e+02
RINT28633 nd6619 nd6620 2.604094330713e+02
RINT28634 nd6620 nd6621 1.303705308206e+02
RINT28635 nd6621 nd6622 1.608894908578e+00
RINT28636 nd6622 nd6623 2.789737223720e+01
RINT28637 nd6623 nd6624 2.744632754910e+01
RINT28638 nd6624 nd6625 1.984071871019e+00
RINT28639 nd6625 nd6626 1.984071871019e+00
RINT28640 nd6626 nd6627 1.984071871019e+00
RINT28641 nd6627 nd6628 1.984071871019e+00
RINT28642 nd6628 nd6629 1.984071871019e+00
RINT28643 nd6629 nd6630 1.984071871019e+00
RINT28644 nd6630 nd6631 1.984071871019e+00
RINT28645 nd6631 nd6632 1.984071871019e+00
RINT28646 nd6632 nd6633 1.984071871019e+00
RINT28647 nd6634 nd6635 1.914284617627e-01
RINT28648 nd6635 nd6636 1.740035002137e-01
RINT28649 nd6636 nd6637 5.881581083666e+00
RINT28650 nd6637 nd6638 5.981136757300e+00
RINT28651 nd6638 nd6639 3.668883239623e-01
RINT28652 nd6639 nd6640 3.606618004430e-01
RINT28653 nd6640 nd6641 1.976741618838e-01
RINT28654 nd6641 nd6642 8.656063970739e-02
RINT28655 nd6642 nd6643 1.760179307529e-01
RINT28656 nd6643 nd6644 2.136011054157e-01
RINT28657 nd6644 nd6645 2.136011054157e-01
RINT28658 nd6645 nd6646 2.136011054157e-01
RINT28659 nd6646 nd6647 2.136011054157e-01
RINT28660 nd6647 nd6648 2.136011054157e-01
RINT28661 nd6648 nd6649 2.136011054157e-01
RINT28662 nd6649 nd6650 2.884961700761e-01
RINT28663 nd6650 nd6651 4.298149835847e-01
RINT28664 nd6651 nd6652 2.654372658145e-01
RINT28665 nd6652 nd6653 1.680354650659e-01
RINT28666 nd6653 nd6654 2.913644572433e+00
RINT28667 nd6654 nd6655 2.866536769726e+00
RINT28668 nd6655 nd6656 2.072195255224e-01
RINT28669 nd6656 nd6657 2.072195255224e-01
RINT28670 nd6657 nd6658 2.072195255224e-01
RINT28671 nd6658 nd6659 2.072195255224e-01
RINT28672 nd6659 nd6660 2.072195255224e-01
RINT28673 nd6660 nd6661 2.072195255224e-01
RINT28674 nd6661 nd6662 2.072195255224e-01
RINT28675 nd6662 nd6663 2.072195255224e-01
RINT28676 nd6663 nd6664 2.072195255224e-01
RINT28677 nd6665 nd6666 1.914284617627e-01
RINT28678 nd6666 nd6667 1.740035002137e-01
RINT28679 nd6667 nd6668 5.881581083666e+00
RINT28680 nd6668 nd6669 5.981136757300e+00
RINT28681 nd6669 nd6670 3.668883239623e-01
RINT28682 nd6670 nd6671 3.606618004430e-01
RINT28683 nd6671 nd6672 1.976741618838e-01
RINT28684 nd6672 nd6673 8.656063970739e-02
RINT28685 nd6673 nd6674 1.760179307529e-01
RINT28686 nd6674 nd6675 2.136011054157e-01
RINT28687 nd6675 nd6676 2.136011054157e-01
RINT28688 nd6676 nd6677 2.136011054157e-01
RINT28689 nd6677 nd6678 2.136011054157e-01
RINT28690 nd6678 nd6679 2.136011054157e-01
RINT28691 nd6679 nd6680 2.136011054157e-01
RINT28692 nd6680 nd6681 2.884961700761e-01
RINT28693 nd6681 nd6682 4.298149835847e-01
RINT28694 nd6682 nd6683 2.654372658145e-01
RINT28695 nd6683 nd6684 1.680354650659e-01
RINT28696 nd6684 nd6685 2.913644572433e+00
RINT28697 nd6685 nd6686 2.866536769726e+00
RINT28698 nd6686 nd6687 2.072195255224e-01
RINT28699 nd6687 nd6688 2.072195255224e-01
RINT28700 nd6688 nd6689 2.072195255224e-01
RINT28701 nd6689 nd6690 2.072195255224e-01
RINT28702 nd6690 nd6691 2.072195255224e-01
RINT28703 nd6691 nd6692 2.072195255224e-01
RINT28704 nd6692 nd6693 2.072195255224e-01
RINT28705 nd6693 nd6694 2.072195255224e-01
RINT28706 nd6694 nd6695 2.072195255224e-01
RINT28707 nd6696 nd6697 1.914284617627e-01
RINT28708 nd6697 nd6698 1.740035002137e-01
RINT28709 nd6698 nd6699 5.881581083666e+00
RINT28710 nd6699 nd6700 5.981136757300e+00
RINT28711 nd6700 nd6701 3.668883239623e-01
RINT28712 nd6701 nd6702 3.606618004430e-01
RINT28713 nd6702 nd6703 1.976741618838e-01
RINT28714 nd6703 nd6704 8.656063970739e-02
RINT28715 nd6704 nd6705 1.760179307529e-01
RINT28716 nd6705 nd6706 2.136011054157e-01
RINT28717 nd6706 nd6707 2.136011054157e-01
RINT28718 nd6707 nd6708 2.136011054157e-01
RINT28719 nd6708 nd6709 2.136011054157e-01
RINT28720 nd6709 nd6710 2.136011054157e-01
RINT28721 nd6710 nd6711 2.136011054157e-01
RINT28722 nd6711 nd6712 2.884961700761e-01
RINT28723 nd6712 nd6713 4.298149835847e-01
RINT28724 nd6713 nd6714 2.654372658145e-01
RINT28725 nd6714 nd6715 1.680354650659e-01
RINT28726 nd6715 nd6716 2.913644572433e+00
RINT28727 nd6716 nd6717 2.866536769726e+00
RINT28728 nd6717 nd6718 2.072195255224e-01
RINT28729 nd6718 nd6719 2.072195255224e-01
RINT28730 nd6719 nd6720 2.072195255224e-01
RINT28731 nd6720 nd6721 2.072195255224e-01
RINT28732 nd6721 nd6722 2.072195255224e-01
RINT28733 nd6722 nd6723 2.072195255224e-01
RINT28734 nd6723 nd6724 2.072195255224e-01
RINT28735 nd6724 nd6725 2.072195255224e-01
RINT28736 nd6725 nd6726 2.072195255224e-01
RINT28737 nd6727 nd6728 1.914284617627e-01
RINT28738 nd6728 nd6729 1.740035002137e-01
RINT28739 nd6729 nd6730 5.881581083666e+00
RINT28740 nd6730 nd6731 5.981136757300e+00
RINT28741 nd6731 nd6732 3.668883239623e-01
RINT28742 nd6732 nd6733 3.606618004430e-01
RINT28743 nd6733 nd6734 1.976741618838e-01
RINT28744 nd6734 nd6735 8.656063970739e-02
RINT28745 nd6735 nd6736 1.760179307529e-01
RINT28746 nd6736 nd6737 2.136011054157e-01
RINT28747 nd6737 nd6738 2.136011054157e-01
RINT28748 nd6738 nd6739 2.136011054157e-01
RINT28749 nd6739 nd6740 2.136011054157e-01
RINT28750 nd6740 nd6741 2.136011054157e-01
RINT28751 nd6741 nd6742 2.136011054157e-01
RINT28752 nd6742 nd6743 2.884961700761e-01
RINT28753 nd6743 nd6744 4.298149835847e-01
RINT28754 nd6744 nd6745 2.654372658145e-01
RINT28755 nd6745 nd6746 1.680354650659e-01
RINT28756 nd6746 nd6747 2.913644572433e+00
RINT28757 nd6747 nd6748 2.866536769726e+00
RINT28758 nd6748 nd6749 2.072195255224e-01
RINT28759 nd6749 nd6750 2.072195255224e-01
RINT28760 nd6750 nd6751 2.072195255224e-01
RINT28761 nd6751 nd6752 2.072195255224e-01
RINT28762 nd6752 nd6753 2.072195255224e-01
RINT28763 nd6753 nd6754 2.072195255224e-01
RINT28764 nd6754 nd6755 2.072195255224e-01
RINT28765 nd6755 nd6756 2.072195255224e-01
RINT28766 nd6756 nd6757 2.072195255224e-01
RINT28767 nd6758 nd6759 1.914284617627e-01
RINT28768 nd6759 nd6760 1.740035002137e-01
RINT28769 nd6760 nd6761 5.881581083666e+00
RINT28770 nd6761 nd6762 5.981136757300e+00
RINT28771 nd6762 nd6763 3.668883239623e-01
RINT28772 nd6763 nd6764 3.606618004430e-01
RINT28773 nd6764 nd6765 1.976741618838e-01
RINT28774 nd6765 nd6766 8.656063970739e-02
RINT28775 nd6766 nd6767 1.760179307529e-01
RINT28776 nd6767 nd6768 2.136011054157e-01
RINT28777 nd6768 nd6769 2.136011054157e-01
RINT28778 nd6769 nd6770 2.136011054157e-01
RINT28779 nd6770 nd6771 2.136011054157e-01
RINT28780 nd6771 nd6772 2.136011054157e-01
RINT28781 nd6772 nd6773 2.136011054157e-01
RINT28782 nd6773 nd6774 2.884961700761e-01
RINT28783 nd6774 nd6775 4.298149835847e-01
RINT28784 nd6775 nd6776 2.654372658145e-01
RINT28785 nd6776 nd6777 1.680354650659e-01
RINT28786 nd6777 nd6778 2.913644572433e+00
RINT28787 nd6778 nd6779 2.866536769726e+00
RINT28788 nd6779 nd6780 2.072195255224e-01
RINT28789 nd6780 nd6781 2.072195255224e-01
RINT28790 nd6781 nd6782 2.072195255224e-01
RINT28791 nd6782 nd6783 2.072195255224e-01
RINT28792 nd6783 nd6784 2.072195255224e-01
RINT28793 nd6784 nd6785 2.072195255224e-01
RINT28794 nd6785 nd6786 2.072195255224e-01
RINT28795 nd6786 nd6787 2.072195255224e-01
RINT28796 nd6787 nd6788 2.072195255224e-01
RINT28797 nd6789 nd6790 1.914284617627e-01
RINT28798 nd6790 nd6791 1.740035002137e-01
RINT28799 nd6791 nd6792 5.881581083666e+00
RINT28800 nd6792 nd6793 5.981136757300e+00
RINT28801 nd6793 nd6794 3.668883239623e-01
RINT28802 nd6794 nd6795 3.606618004430e-01
RINT28803 nd6795 nd6796 1.976741618838e-01
RINT28804 nd6796 nd6797 8.656063970739e-02
RINT28805 nd6797 nd6798 1.760179307529e-01
RINT28806 nd6798 nd6799 2.136011054157e-01
RINT28807 nd6799 nd6800 2.136011054157e-01
RINT28808 nd6800 nd6801 2.136011054157e-01
RINT28809 nd6801 nd6802 2.136011054157e-01
RINT28810 nd6802 nd6803 2.136011054157e-01
RINT28811 nd6803 nd6804 2.136011054157e-01
RINT28812 nd6804 nd6805 2.884961700761e-01
RINT28813 nd6805 nd6806 4.298149835847e-01
RINT28814 nd6806 nd6807 2.654372658145e-01
RINT28815 nd6807 nd6808 1.680354650659e-01
RINT28816 nd6808 nd6809 2.913644572433e+00
RINT28817 nd6809 nd6810 2.866536769726e+00
RINT28818 nd6810 nd6811 2.072195255224e-01
RINT28819 nd6811 nd6812 2.072195255224e-01
RINT28820 nd6812 nd6813 2.072195255224e-01
RINT28821 nd6813 nd6814 2.072195255224e-01
RINT28822 nd6814 nd6815 2.072195255224e-01
RINT28823 nd6815 nd6816 2.072195255224e-01
RINT28824 nd6816 nd6817 2.072195255224e-01
RINT28825 nd6817 nd6818 2.072195255224e-01
RINT28826 nd6818 nd6819 2.072195255224e-01
RINT28827 nd6820 nd6821 1.832876633312e+00
RINT28828 nd6821 nd6822 1.666037258616e+00
RINT28829 nd6822 nd6823 5.631457535579e+01
RINT28830 nd6823 nd6824 5.726779446562e+01
RINT28831 nd6824 nd6825 3.512858170793e+00
RINT28832 nd6825 nd6826 3.453240863313e+00
RINT28833 nd6826 nd6827 9.993586560904e+00
RINT28834 nd6827 nd6828 5.786876290473e+01
RINT28835 nd6828 nd6829 7.853617822785e+01
RINT28836 nd6829 nd6830 5.786876290473e+01
RINT28837 nd6830 nd6831 5.786876290473e+01
RINT28838 nd6831 nd6832 5.786876290473e+01
RINT28839 nd6832 nd6833 5.786876290473e+01
RINT28840 nd6833 nd6834 5.786876290473e+01
RINT28841 nd6834 nd6835 5.786876290473e+01
RINT28842 nd6835 nd6836 1.591390979880e+02
RINT28843 nd6836 nd6837 2.604094330713e+02
RINT28844 nd6837 nd6838 1.303705308206e+02
RINT28845 nd6838 nd6839 1.608894908578e+00
RINT28846 nd6839 nd6840 2.789737223720e+01
RINT28847 nd6840 nd6841 2.744632754910e+01
RINT28848 nd6841 nd6842 1.984071871019e+00
RINT28849 nd6842 nd6843 1.984071871019e+00
RINT28850 nd6843 nd6844 1.984071871019e+00
RINT28851 nd6844 nd6845 1.984071871019e+00
RINT28852 nd6845 nd6846 1.984071871019e+00
RINT28853 nd6846 nd6847 1.984071871019e+00
RINT28854 nd6847 nd6848 1.984071871019e+00
RINT28855 nd6848 nd6849 1.984071871019e+00
RINT28856 nd6849 nd6850 1.984071871019e+00
RINT28857 nd6851 nd6852 1.914284617627e-01
RINT28858 nd6852 nd6853 1.740035002137e-01
RINT28859 nd6853 nd6854 5.881581083666e+00
RINT28860 nd6854 nd6855 5.981136757300e+00
RINT28861 nd6855 nd6856 3.668883239623e-01
RINT28862 nd6856 nd6857 3.606618004430e-01
RINT28863 nd6857 nd6858 1.976741618838e-01
RINT28864 nd6858 nd6859 8.656063970739e-02
RINT28865 nd6859 nd6860 1.760179307529e-01
RINT28866 nd6860 nd6861 2.136011054157e-01
RINT28867 nd6861 nd6862 2.136011054157e-01
RINT28868 nd6862 nd6863 2.136011054157e-01
RINT28869 nd6863 nd6864 2.136011054157e-01
RINT28870 nd6864 nd6865 2.136011054157e-01
RINT28871 nd6865 nd6866 2.136011054157e-01
RINT28872 nd6866 nd6867 2.884961700761e-01
RINT28873 nd6867 nd6868 4.298149835847e-01
RINT28874 nd6868 nd6869 2.654372658145e-01
RINT28875 nd6869 nd6870 1.680354650659e-01
RINT28876 nd6870 nd6871 2.913644572433e+00
RINT28877 nd6871 nd6872 2.866536769726e+00
RINT28878 nd6872 nd6873 2.072195255224e-01
RINT28879 nd6873 nd6874 2.072195255224e-01
RINT28880 nd6874 nd6875 2.072195255224e-01
RINT28881 nd6875 nd6876 2.072195255224e-01
RINT28882 nd6876 nd6877 2.072195255224e-01
RINT28883 nd6877 nd6878 2.072195255224e-01
RINT28884 nd6878 nd6879 2.072195255224e-01
RINT28885 nd6879 nd6880 2.072195255224e-01
RINT28886 nd6880 nd6881 2.072195255224e-01
RINT28887 nd6882 nd6883 1.914284617627e-01
RINT28888 nd6883 nd6884 1.740035002137e-01
RINT28889 nd6884 nd6885 5.881581083666e+00
RINT28890 nd6885 nd6886 5.981136757300e+00
RINT28891 nd6886 nd6887 3.668883239623e-01
RINT28892 nd6887 nd6888 3.606618004430e-01
RINT28893 nd6888 nd6889 1.976741618838e-01
RINT28894 nd6889 nd6890 8.656063970738e-02
RINT28895 nd6890 nd6891 1.760179307529e-01
RINT28896 nd6891 nd6892 2.136011054157e-01
RINT28897 nd6892 nd6893 2.136011054157e-01
RINT28898 nd6893 nd6894 2.136011054157e-01
RINT28899 nd6894 nd6895 2.136011054157e-01
RINT28900 nd6895 nd6896 2.136011054157e-01
RINT28901 nd6896 nd6897 2.136011054157e-01
RINT28902 nd6897 nd6898 2.884961700761e-01
RINT28903 nd6898 nd6899 4.298149835847e-01
RINT28904 nd6899 nd6900 2.654372658145e-01
RINT28905 nd6900 nd6901 1.680354650659e-01
RINT28906 nd6901 nd6902 2.913644572433e+00
RINT28907 nd6902 nd6903 2.866536769726e+00
RINT28908 nd6903 nd6904 2.072195255224e-01
RINT28909 nd6904 nd6905 2.072195255224e-01
RINT28910 nd6905 nd6906 2.072195255224e-01
RINT28911 nd6906 nd6907 2.072195255224e-01
RINT28912 nd6907 nd6908 2.072195255224e-01
RINT28913 nd6908 nd6909 2.072195255224e-01
RINT28914 nd6909 nd6910 2.072195255224e-01
RINT28915 nd6910 nd6911 2.072195255224e-01
RINT28916 nd6911 nd6912 2.072195255224e-01
RINT28917 nd6913 nd6914 1.914284617627e-01
RINT28918 nd6914 nd6915 1.740035002137e-01
RINT28919 nd6915 nd6916 5.881581083666e+00
RINT28920 nd6916 nd6917 5.981136757300e+00
RINT28921 nd6917 nd6918 3.668883239623e-01
RINT28922 nd6918 nd6919 3.606618004430e-01
RINT28923 nd6919 nd6920 1.976741618838e-01
RINT28924 nd6920 nd6921 8.656063970739e-02
RINT28925 nd6921 nd6922 1.760179307529e-01
RINT28926 nd6922 nd6923 2.136011054157e-01
RINT28927 nd6923 nd6924 2.136011054157e-01
RINT28928 nd6924 nd6925 2.136011054157e-01
RINT28929 nd6925 nd6926 2.136011054157e-01
RINT28930 nd6926 nd6927 2.136011054157e-01
RINT28931 nd6927 nd6928 2.136011054157e-01
RINT28932 nd6928 nd6929 2.884961700761e-01
RINT28933 nd6929 nd6930 4.298149835847e-01
RINT28934 nd6930 nd6931 2.654372658145e-01
RINT28935 nd6931 nd6932 1.680354650659e-01
RINT28936 nd6932 nd6933 2.913644572433e+00
RINT28937 nd6933 nd6934 2.866536769726e+00
RINT28938 nd6934 nd6935 2.072195255224e-01
RINT28939 nd6935 nd6936 2.072195255224e-01
RINT28940 nd6936 nd6937 2.072195255224e-01
RINT28941 nd6937 nd6938 2.072195255224e-01
RINT28942 nd6938 nd6939 2.072195255224e-01
RINT28943 nd6939 nd6940 2.072195255224e-01
RINT28944 nd6940 nd6941 2.072195255224e-01
RINT28945 nd6941 nd6942 2.072195255224e-01
RINT28946 nd6942 nd6943 2.072195255224e-01
RINT28947 nd6944 nd6945 1.914284617627e-01
RINT28948 nd6945 nd6946 1.740035002137e-01
RINT28949 nd6946 nd6947 5.881581083666e+00
RINT28950 nd6947 nd6948 5.981136757300e+00
RINT28951 nd6948 nd6949 3.668883239623e-01
RINT28952 nd6949 nd6950 3.606618004430e-01
RINT28953 nd6950 nd6951 1.976741618838e-01
RINT28954 nd6951 nd6952 8.656063970739e-02
RINT28955 nd6952 nd6953 1.760179307529e-01
RINT28956 nd6953 nd6954 2.136011054157e-01
RINT28957 nd6954 nd6955 2.136011054157e-01
RINT28958 nd6955 nd6956 2.136011054157e-01
RINT28959 nd6956 nd6957 2.136011054157e-01
RINT28960 nd6957 nd6958 2.136011054157e-01
RINT28961 nd6958 nd6959 2.136011054157e-01
RINT28962 nd6959 nd6960 2.884961700761e-01
RINT28963 nd6960 nd6961 4.298149835847e-01
RINT28964 nd6961 nd6962 2.654372658145e-01
RINT28965 nd6962 nd6963 1.680354650659e-01
RINT28966 nd6963 nd6964 2.913644572433e+00
RINT28967 nd6964 nd6965 2.866536769726e+00
RINT28968 nd6965 nd6966 2.072195255224e-01
RINT28969 nd6966 nd6967 2.072195255224e-01
RINT28970 nd6967 nd6968 2.072195255224e-01
RINT28971 nd6968 nd6969 2.072195255224e-01
RINT28972 nd6969 nd6970 2.072195255224e-01
RINT28973 nd6970 nd6971 2.072195255224e-01
RINT28974 nd6971 nd6972 2.072195255224e-01
RINT28975 nd6972 nd6973 2.072195255224e-01
RINT28976 nd6973 nd6974 2.072195255224e-01
RINT28977 nd6975 nd6976 1.914284617627e-01
RINT28978 nd6976 nd6977 1.740035002137e-01
RINT28979 nd6977 nd6978 5.881581083666e+00
RINT28980 nd6978 nd6979 5.981136757300e+00
RINT28981 nd6979 nd6980 3.668883239623e-01
RINT28982 nd6980 nd6981 3.606618004430e-01
RINT28983 nd6981 nd6982 1.976741618838e-01
RINT28984 nd6982 nd6983 8.656063970738e-02
RINT28985 nd6983 nd6984 1.760179307529e-01
RINT28986 nd6984 nd6985 2.136011054157e-01
RINT28987 nd6985 nd6986 2.136011054157e-01
RINT28988 nd6986 nd6987 2.136011054157e-01
RINT28989 nd6987 nd6988 2.136011054157e-01
RINT28990 nd6988 nd6989 2.136011054157e-01
RINT28991 nd6989 nd6990 2.136011054157e-01
RINT28992 nd6990 nd6991 2.884961700761e-01
RINT28993 nd6991 nd6992 4.298149835847e-01
RINT28994 nd6992 nd6993 2.654372658145e-01
RINT28995 nd6993 nd6994 1.680354650659e-01
RINT28996 nd6994 nd6995 2.913644572433e+00
RINT28997 nd6995 nd6996 2.866536769726e+00
RINT28998 nd6996 nd6997 2.072195255224e-01
RINT28999 nd6997 nd6998 2.072195255224e-01
RINT29000 nd6998 nd6999 2.072195255224e-01
RINT29001 nd6999 nd7000 2.072195255224e-01
RINT29002 nd7000 nd7001 2.072195255224e-01
RINT29003 nd7001 nd7002 2.072195255224e-01
RINT29004 nd7002 nd7003 2.072195255224e-01
RINT29005 nd7003 nd7004 2.072195255224e-01
RINT29006 nd7004 nd7005 2.072195255224e-01
RINT29007 nd7006 nd7007 1.914284617627e-01
RINT29008 nd7007 nd7008 1.740035002137e-01
RINT29009 nd7008 nd7009 5.881581083666e+00
RINT29010 nd7009 nd7010 5.981136757300e+00
RINT29011 nd7010 nd7011 3.668883239623e-01
RINT29012 nd7011 nd7012 3.606618004430e-01
RINT29013 nd7012 nd7013 1.976741618838e-01
RINT29014 nd7013 nd7014 8.656063970739e-02
RINT29015 nd7014 nd7015 1.760179307529e-01
RINT29016 nd7015 nd7016 2.136011054157e-01
RINT29017 nd7016 nd7017 2.136011054157e-01
RINT29018 nd7017 nd7018 2.136011054157e-01
RINT29019 nd7018 nd7019 2.136011054157e-01
RINT29020 nd7019 nd7020 2.136011054157e-01
RINT29021 nd7020 nd7021 2.136011054157e-01
RINT29022 nd7021 nd7022 2.884961700761e-01
RINT29023 nd7022 nd7023 4.298149835847e-01
RINT29024 nd7023 nd7024 2.654372658145e-01
RINT29025 nd7024 nd7025 1.680354650659e-01
RINT29026 nd7025 nd7026 2.913644572433e+00
RINT29027 nd7026 nd7027 2.866536769726e+00
RINT29028 nd7027 nd7028 2.072195255224e-01
RINT29029 nd7028 nd7029 2.072195255224e-01
RINT29030 nd7029 nd7030 2.072195255224e-01
RINT29031 nd7030 nd7031 2.072195255224e-01
RINT29032 nd7031 nd7032 2.072195255224e-01
RINT29033 nd7032 nd7033 2.072195255224e-01
RINT29034 nd7033 nd7034 2.072195255224e-01
RINT29035 nd7034 nd7035 2.072195255224e-01
RINT29036 nd7035 nd7036 2.072195255224e-01
RINT29037 nd7037 nd7038 1.832876633312e+00
RINT29038 nd7038 nd7039 1.666037258616e+00
RINT29039 nd7039 nd7040 5.631457535579e+01
RINT29040 nd7040 nd7041 5.726779446562e+01
RINT29041 nd7041 nd7042 3.512858170793e+00
RINT29042 nd7042 nd7043 3.453240863313e+00
RINT29043 nd7043 nd7044 9.993586560904e+00
RINT29044 nd7044 nd7045 5.786876290473e+01
RINT29045 nd7045 nd7046 7.853617822785e+01
RINT29046 nd7046 nd7047 5.786876290473e+01
RINT29047 nd7047 nd7048 5.786876290473e+01
RINT29048 nd7048 nd7049 5.786876290473e+01
RINT29049 nd7049 nd7050 5.786876290473e+01
RINT29050 nd7050 nd7051 5.786876290473e+01
RINT29051 nd7051 nd7052 5.786876290473e+01
RINT29052 nd7052 nd7053 1.591390979880e+02
RINT29053 nd7053 nd7054 2.604094330713e+02
RINT29054 nd7054 nd7055 1.303705308206e+02
RINT29055 nd7055 nd7056 1.608894908578e+00
RINT29056 nd7056 nd7057 2.789737223720e+01
RINT29057 nd7057 nd7058 2.744632754910e+01
RINT29058 nd7058 nd7059 1.984071871019e+00
RINT29059 nd7059 nd7060 1.984071871019e+00
RINT29060 nd7060 nd7061 1.984071871019e+00
RINT29061 nd7061 nd7062 1.984071871019e+00
RINT29062 nd7062 nd7063 1.984071871019e+00
RINT29063 nd7063 nd7064 1.984071871019e+00
RINT29064 nd7064 nd7065 1.984071871019e+00
RINT29065 nd7065 nd7066 1.984071871019e+00
RINT29066 nd7066 nd7067 1.984071871019e+00
RINT29067 nd7068 nd7069 2.493313941068e-01
RINT29068 nd7069 nd7070 2.266357619356e-01
RINT29069 nd7070 nd7071 7.660631014006e+00
RINT29070 nd7071 nd7072 7.790300106417e+00
RINT29071 nd7072 nd7073 4.778640357485e-01
RINT29072 nd7073 nd7074 4.697541247393e-01
RINT29073 nd7074 nd7075 2.520135011038e-01
RINT29074 nd7075 nd7076 1.199550711388e-01
RINT29075 nd7076 nd7077 1.627961679741e-01
RINT29076 nd7077 nd7078 1.199550711388e-01
RINT29077 nd7078 nd7079 1.199550711388e-01
RINT29078 nd7079 nd7080 1.199550711388e-01
RINT29079 nd7080 nd7081 1.199550711388e-01
RINT29080 nd7081 nd7082 1.199550711388e-01
RINT29081 nd7082 nd7083 1.199550711388e-01
RINT29082 nd7083 nd7084 3.298764456317e-01
RINT29083 nd7084 nd7085 5.397978201245e-01
RINT29084 nd7085 nd7086 2.924550963786e-01
RINT29085 nd7086 nd7087 2.188625263897e-01
RINT29086 nd7087 nd7088 3.794958474237e+00
RINT29087 nd7088 nd7089 3.733601589195e+00
RINT29088 nd7089 nd7090 2.698989100623e-01
RINT29089 nd7090 nd7091 2.698989100623e-01
RINT29090 nd7091 nd7092 2.698989100623e-01
RINT29091 nd7092 nd7093 2.698989100623e-01
RINT29092 nd7093 nd7094 2.698989100623e-01
RINT29093 nd7094 nd7095 2.698989100623e-01
RINT29094 nd7095 nd7096 2.698989100623e-01
RINT29095 nd7096 nd7097 2.698989100623e-01
RINT29096 nd7097 nd7098 2.698989100623e-01
RINT29097 nd7099 nd7100 2.493313941068e-01
RINT29098 nd7100 nd7101 2.266357619356e-01
RINT29099 nd7101 nd7102 7.660631014006e+00
RINT29100 nd7102 nd7103 7.790300106417e+00
RINT29101 nd7103 nd7104 4.778640357485e-01
RINT29102 nd7104 nd7105 4.697541247393e-01
RINT29103 nd7105 nd7106 2.520135011038e-01
RINT29104 nd7106 nd7107 1.199550711388e-01
RINT29105 nd7107 nd7108 1.627961679741e-01
RINT29106 nd7108 nd7109 1.199550711388e-01
RINT29107 nd7109 nd7110 1.199550711388e-01
RINT29108 nd7110 nd7111 1.199550711388e-01
RINT29109 nd7111 nd7112 1.199550711388e-01
RINT29110 nd7112 nd7113 1.199550711388e-01
RINT29111 nd7113 nd7114 1.199550711388e-01
RINT29112 nd7114 nd7115 3.298764456317e-01
RINT29113 nd7115 nd7116 5.397978201245e-01
RINT29114 nd7116 nd7117 2.924550963786e-01
RINT29115 nd7117 nd7118 2.188625263897e-01
RINT29116 nd7118 nd7119 3.794958474237e+00
RINT29117 nd7119 nd7120 3.733601589195e+00
RINT29118 nd7120 nd7121 2.698989100623e-01
RINT29119 nd7121 nd7122 2.698989100623e-01
RINT29120 nd7122 nd7123 2.698989100623e-01
RINT29121 nd7123 nd7124 2.698989100623e-01
RINT29122 nd7124 nd7125 2.698989100623e-01
RINT29123 nd7125 nd7126 2.698989100623e-01
RINT29124 nd7126 nd7127 2.698989100623e-01
RINT29125 nd7127 nd7128 2.698989100623e-01
RINT29126 nd7128 nd7129 2.698989100623e-01
RINT29127 nd7130 nd7131 2.493313941068e-01
RINT29128 nd7131 nd7132 2.266357619356e-01
RINT29129 nd7132 nd7133 7.660631014006e+00
RINT29130 nd7133 nd7134 7.790300106417e+00
RINT29131 nd7134 nd7135 4.778640357485e-01
RINT29132 nd7135 nd7136 4.697541247393e-01
RINT29133 nd7136 nd7137 2.520135011038e-01
RINT29134 nd7137 nd7138 1.199550711388e-01
RINT29135 nd7138 nd7139 1.627961679741e-01
RINT29136 nd7139 nd7140 1.199550711388e-01
RINT29137 nd7140 nd7141 1.199550711388e-01
RINT29138 nd7141 nd7142 1.199550711388e-01
RINT29139 nd7142 nd7143 1.199550711388e-01
RINT29140 nd7143 nd7144 1.199550711388e-01
RINT29141 nd7144 nd7145 1.199550711388e-01
RINT29142 nd7145 nd7146 3.298764456317e-01
RINT29143 nd7146 nd7147 5.397978201245e-01
RINT29144 nd7147 nd7148 2.924550963786e-01
RINT29145 nd7148 nd7149 2.188625263897e-01
RINT29146 nd7149 nd7150 3.794958474237e+00
RINT29147 nd7150 nd7151 3.733601589195e+00
RINT29148 nd7151 nd7152 2.698989100623e-01
RINT29149 nd7152 nd7153 2.698989100623e-01
RINT29150 nd7153 nd7154 2.698989100623e-01
RINT29151 nd7154 nd7155 2.698989100623e-01
RINT29152 nd7155 nd7156 2.698989100623e-01
RINT29153 nd7156 nd7157 2.698989100623e-01
RINT29154 nd7157 nd7158 2.698989100623e-01
RINT29155 nd7158 nd7159 2.698989100623e-01
RINT29156 nd7159 nd7160 2.698989100623e-01
RINT29157 nd7161 nd7162 2.356247123801e+00
RINT29158 nd7162 nd7163 2.141767442179e+00
RINT29159 nd7163 nd7164 7.239497399800e+01
RINT29160 nd7164 nd7165 7.362038095942e+01
RINT29161 nd7165 nd7166 4.515940577133e+00
RINT29162 nd7166 nd7167 4.439299789244e+00
RINT29163 nd7167 nd7168 2.381593738975e+00
RINT29164 nd7168 nd7169 1.133606910468e+00
RINT29165 nd7169 nd7170 1.538466521349e+00
RINT29166 nd7170 nd7171 1.133606910468e+00
RINT29167 nd7171 nd7172 1.133606910468e+00
RINT29168 nd7172 nd7173 1.133606910468e+00
RINT29169 nd7173 nd7174 1.133606910468e+00
RINT29170 nd7174 nd7175 1.133606910468e+00
RINT29171 nd7175 nd7176 1.133606910468e+00
RINT29172 nd7176 nd7177 3.117419003786e+00
RINT29173 nd7177 nd7178 5.101231097105e+00
RINT29174 nd7178 nd7179 2.763777430240e+00
RINT29175 nd7179 nd7180 2.068308325796e+00
RINT29176 nd7180 nd7181 3.586335375814e+01
RINT29177 nd7181 nd7182 3.528351508831e+01
RINT29178 nd7182 nd7183 2.550615548552e+00
RINT29179 nd7183 nd7184 2.550615548552e+00
RINT29180 nd7184 nd7185 2.550615548552e+00
RINT29181 nd7185 nd7186 2.550615548552e+00
RINT29182 nd7186 nd7187 2.550615548552e+00
RINT29183 nd7187 nd7188 2.550615548552e+00
RINT29184 nd7188 nd7189 2.550615548552e+00
RINT29185 nd7189 nd7190 2.550615548552e+00
RINT29186 nd7190 nd7191 2.550615548552e+00
RINT29187 nd7192 nd7193 2.356247123801e+00
RINT29188 nd7193 nd7194 2.141767442179e+00
RINT29189 nd7194 nd7195 7.239497399800e+01
RINT29190 nd7195 nd7196 7.362038095942e+01
RINT29191 nd7196 nd7197 4.515940577133e+00
RINT29192 nd7197 nd7198 4.439299789244e+00
RINT29193 nd7198 nd7199 2.381593738975e+00
RINT29194 nd7199 nd7200 1.133606910468e+00
RINT29195 nd7200 nd7201 1.538466521349e+00
RINT29196 nd7201 nd7202 1.133606910468e+00
RINT29197 nd7202 nd7203 1.133606910468e+00
RINT29198 nd7203 nd7204 1.133606910468e+00
RINT29199 nd7204 nd7205 1.133606910468e+00
RINT29200 nd7205 nd7206 1.133606910468e+00
RINT29201 nd7206 nd7207 1.133606910468e+00
RINT29202 nd7207 nd7208 3.117419003786e+00
RINT29203 nd7208 nd7209 5.101231097105e+00
RINT29204 nd7209 nd7210 2.763777430240e+00
RINT29205 nd7210 nd7211 2.068308325796e+00
RINT29206 nd7211 nd7212 3.586335375814e+01
RINT29207 nd7212 nd7213 3.528351508831e+01
RINT29208 nd7213 nd7214 2.550615548552e+00
RINT29209 nd7214 nd7215 2.550615548552e+00
RINT29210 nd7215 nd7216 2.550615548552e+00
RINT29211 nd7216 nd7217 2.550615548552e+00
RINT29212 nd7217 nd7218 2.550615548552e+00
RINT29213 nd7218 nd7219 2.550615548552e+00
RINT29214 nd7219 nd7220 2.550615548552e+00
RINT29215 nd7220 nd7221 2.550615548552e+00
RINT29216 nd7221 nd7222 2.550615548552e+00
RINT29217 nd7223 nd7224 2.356247123801e+00
RINT29218 nd7224 nd7225 2.141767442179e+00
RINT29219 nd7225 nd7226 7.239497399800e+01
RINT29220 nd7226 nd7227 7.362038095942e+01
RINT29221 nd7227 nd7228 4.515940577133e+00
RINT29222 nd7228 nd7229 4.439299789244e+00
RINT29223 nd7229 nd7230 2.381593738975e+00
RINT29224 nd7230 nd7231 1.133606910468e+00
RINT29225 nd7231 nd7232 1.538466521349e+00
RINT29226 nd7232 nd7233 1.133606910468e+00
RINT29227 nd7233 nd7234 1.133606910468e+00
RINT29228 nd7234 nd7235 1.133606910468e+00
RINT29229 nd7235 nd7236 1.133606910468e+00
RINT29230 nd7236 nd7237 1.133606910468e+00
RINT29231 nd7237 nd7238 1.133606910468e+00
RINT29232 nd7238 nd7239 3.117419003786e+00
RINT29233 nd7239 nd7240 5.101231097105e+00
RINT29234 nd7240 nd7241 2.763777430240e+00
RINT29235 nd7241 nd7242 2.068308325796e+00
RINT29236 nd7242 nd7243 3.586335375814e+01
RINT29237 nd7243 nd7244 3.528351508831e+01
RINT29238 nd7244 nd7245 2.550615548552e+00
RINT29239 nd7245 nd7246 2.550615548552e+00
RINT29240 nd7246 nd7247 2.550615548552e+00
RINT29241 nd7247 nd7248 2.550615548552e+00
RINT29242 nd7248 nd7249 2.550615548552e+00
RINT29243 nd7249 nd7250 2.550615548552e+00
RINT29244 nd7250 nd7251 2.550615548552e+00
RINT29245 nd7251 nd7252 2.550615548552e+00
RINT29246 nd7252 nd7253 2.550615548552e+00
RINT29247 nd7254 nd7255 1.732116531491e+01
RINT29248 nd7255 nd7256 1.574448942870e+01
RINT29249 nd7256 nd7257 5.321875196883e+02
RINT29250 nd7257 nd7258 5.411956904962e+02
RINT29251 nd7258 nd7259 3.319743183927e+01
RINT29252 nd7259 nd7260 3.263403263403e+01
RINT29253 nd7260 nd7261 9.444201631702e+01
RINT29254 nd7261 nd7262 5.468750000000e+02
RINT29255 nd7262 nd7263 7.421875000000e+02
RINT29256 nd7263 nd7264 5.468750000000e+02
RINT29257 nd7264 nd7265 5.468750000000e+02
RINT29258 nd7265 nd7266 5.468750000000e+02
RINT29259 nd7266 nd7267 5.468750000000e+02
RINT29260 nd7267 nd7268 5.468750000000e+02
RINT29261 nd7268 nd7269 5.468750000000e+02
RINT29262 nd7269 nd7270 1.503906250000e+03
RINT29263 nd7270 nd7271 2.460937500000e+03
RINT29264 nd7271 nd7272 1.232035738519e+03
RINT29265 nd7272 nd7273 1.520447922098e+01
RINT29266 nd7273 nd7274 2.636374907017e+02
RINT29267 nd7274 nd7275 2.593750000000e+02
RINT29268 nd7275 nd7276 1.875000000000e+01
RINT29269 nd7276 nd7277 1.875000000000e+01
RINT29270 nd7277 nd7278 1.875000000000e+01
RINT29271 nd7278 nd7279 1.875000000000e+01
RINT29272 nd7279 nd7280 1.875000000000e+01
RINT29273 nd7280 nd7281 1.875000000000e+01
RINT29274 nd7281 nd7282 1.875000000000e+01
RINT29275 nd7282 nd7283 1.875000000000e+01
RINT29276 nd7283 nd7284 1.875000000000e+01
RINT29277 nd7285 nd7286 1.809049213629e+00
RINT29278 nd7286 nd7287 1.644378752938e+00
RINT29279 nd7287 nd7288 5.558248515568e+01
RINT29280 nd7288 nd7289 5.652331240488e+01
RINT29281 nd7289 nd7290 3.467190969629e+00
RINT29282 nd7290 nd7291 3.408348687909e+00
RINT29283 nd7291 nd7292 9.863669807754e+00
RINT29284 nd7292 nd7293 5.711646824659e+01
RINT29285 nd7293 nd7294 7.751520690609e+01
RINT29286 nd7294 nd7295 5.711646824659e+01
RINT29287 nd7295 nd7296 5.711646824659e+01
RINT29288 nd7296 nd7297 5.711646824659e+01
RINT29289 nd7297 nd7298 5.711646824659e+01
RINT29290 nd7298 nd7299 5.711646824659e+01
RINT29291 nd7299 nd7300 5.711646824659e+01
RINT29292 nd7300 nd7301 1.570702876781e+02
RINT29293 nd7301 nd7302 2.570241071097e+02
RINT29294 nd7302 nd7303 1.286757122520e+02
RINT29295 nd7303 nd7304 1.587979254183e+00
RINT29296 nd7304 nd7305 2.753470604119e+01
RINT29297 nd7305 nd7306 2.708952493981e+01
RINT29298 nd7306 nd7307 1.958278911312e+00
RINT29299 nd7307 nd7308 1.958278911312e+00
RINT29300 nd7308 nd7309 1.958278911312e+00
RINT29301 nd7309 nd7310 1.958278911312e+00
RINT29302 nd7310 nd7311 1.958278911312e+00
RINT29303 nd7311 nd7312 1.958278911312e+00
RINT29304 nd7312 nd7313 1.958278911312e+00
RINT29305 nd7313 nd7314 1.958278911312e+00
RINT29306 nd7314 nd7315 1.958278911312e+00
RINT29307 nd7316 nd7317 1.809049213629e+00
RINT29308 nd7317 nd7318 1.644378752938e+00
RINT29309 nd7318 nd7319 5.558248515568e+01
RINT29310 nd7319 nd7320 5.652331240488e+01
RINT29311 nd7320 nd7321 3.467190969629e+00
RINT29312 nd7321 nd7322 3.408348687909e+00
RINT29313 nd7322 nd7323 9.863669807754e+00
RINT29314 nd7323 nd7324 5.711646824659e+01
RINT29315 nd7324 nd7325 7.751520690609e+01
RINT29316 nd7325 nd7326 5.711646824659e+01
RINT29317 nd7326 nd7327 5.711646824659e+01
RINT29318 nd7327 nd7328 5.711646824659e+01
RINT29319 nd7328 nd7329 5.711646824659e+01
RINT29320 nd7329 nd7330 5.711646824659e+01
RINT29321 nd7330 nd7331 5.711646824659e+01
RINT29322 nd7331 nd7332 1.570702876781e+02
RINT29323 nd7332 nd7333 2.570241071097e+02
RINT29324 nd7333 nd7334 1.286757122520e+02
RINT29325 nd7334 nd7335 1.587979254183e+00
RINT29326 nd7335 nd7336 2.753470604119e+01
RINT29327 nd7336 nd7337 2.708952493981e+01
RINT29328 nd7337 nd7338 1.958278911312e+00
RINT29329 nd7338 nd7339 1.958278911312e+00
RINT29330 nd7339 nd7340 1.958278911312e+00
RINT29331 nd7340 nd7341 1.958278911312e+00
RINT29332 nd7341 nd7342 1.958278911312e+00
RINT29333 nd7342 nd7343 1.958278911312e+00
RINT29334 nd7343 nd7344 1.958278911312e+00
RINT29335 nd7344 nd7345 1.958278911312e+00
RINT29336 nd7345 nd7346 1.958278911312e+00
RINT29337 nd7347 nd7348 1.809049213629e+00
RINT29338 nd7348 nd7349 1.644378752938e+00
RINT29339 nd7349 nd7350 5.558248515568e+01
RINT29340 nd7350 nd7351 5.652331240488e+01
RINT29341 nd7351 nd7352 3.467190969629e+00
RINT29342 nd7352 nd7353 3.408348687909e+00
RINT29343 nd7353 nd7354 9.863669807754e+00
RINT29344 nd7354 nd7355 5.711646824659e+01
RINT29345 nd7355 nd7356 7.751520690609e+01
RINT29346 nd7356 nd7357 5.711646824659e+01
RINT29347 nd7357 nd7358 5.711646824659e+01
RINT29348 nd7358 nd7359 5.711646824659e+01
RINT29349 nd7359 nd7360 5.711646824659e+01
RINT29350 nd7360 nd7361 5.711646824659e+01
RINT29351 nd7361 nd7362 5.711646824659e+01
RINT29352 nd7362 nd7363 1.570702876781e+02
RINT29353 nd7363 nd7364 2.570241071097e+02
RINT29354 nd7364 nd7365 1.286757122520e+02
RINT29355 nd7365 nd7366 1.587979254183e+00
RINT29356 nd7366 nd7367 2.753470604119e+01
RINT29357 nd7367 nd7368 2.708952493981e+01
RINT29358 nd7368 nd7369 1.958278911312e+00
RINT29359 nd7369 nd7370 1.958278911312e+00
RINT29360 nd7370 nd7371 1.958278911312e+00
RINT29361 nd7371 nd7372 1.958278911312e+00
RINT29362 nd7372 nd7373 1.958278911312e+00
RINT29363 nd7373 nd7374 1.958278911312e+00
RINT29364 nd7374 nd7375 1.958278911312e+00
RINT29365 nd7375 nd7376 1.958278911312e+00
RINT29366 nd7376 nd7377 1.958278911312e+00
RINT29367 nd7378 nd7379 1.809049213629e+00
RINT29368 nd7379 nd7380 1.644378752938e+00
RINT29369 nd7380 nd7381 5.558248515568e+01
RINT29370 nd7381 nd7382 5.652331240488e+01
RINT29371 nd7382 nd7383 3.467190969629e+00
RINT29372 nd7383 nd7384 3.408348687909e+00
RINT29373 nd7384 nd7385 9.863669807754e+00
RINT29374 nd7385 nd7386 5.711646824659e+01
RINT29375 nd7386 nd7387 7.751520690609e+01
RINT29376 nd7387 nd7388 5.711646824659e+01
RINT29377 nd7388 nd7389 5.711646824659e+01
RINT29378 nd7389 nd7390 5.711646824659e+01
RINT29379 nd7390 nd7391 5.711646824659e+01
RINT29380 nd7391 nd7392 5.711646824659e+01
RINT29381 nd7392 nd7393 5.711646824659e+01
RINT29382 nd7393 nd7394 1.570702876781e+02
RINT29383 nd7394 nd7395 2.570241071097e+02
RINT29384 nd7395 nd7396 1.286757122520e+02
RINT29385 nd7396 nd7397 1.587979254183e+00
RINT29386 nd7397 nd7398 2.753470604119e+01
RINT29387 nd7398 nd7399 2.708952493981e+01
RINT29388 nd7399 nd7400 1.958278911312e+00
RINT29389 nd7400 nd7401 1.958278911312e+00
RINT29390 nd7401 nd7402 1.958278911312e+00
RINT29391 nd7402 nd7403 1.958278911312e+00
RINT29392 nd7403 nd7404 1.958278911312e+00
RINT29393 nd7404 nd7405 1.958278911312e+00
RINT29394 nd7405 nd7406 1.958278911312e+00
RINT29395 nd7406 nd7407 1.958278911312e+00
RINT29396 nd7407 nd7408 1.958278911312e+00
RINT29397 nd7409 nd7410 1.809049213629e+00
RINT29398 nd7410 nd7411 1.644378752938e+00
RINT29399 nd7411 nd7412 5.558248515568e+01
RINT29400 nd7412 nd7413 5.652331240488e+01
RINT29401 nd7413 nd7414 3.467190969629e+00
RINT29402 nd7414 nd7415 3.408348687909e+00
RINT29403 nd7415 nd7416 9.863669807754e+00
RINT29404 nd7416 nd7417 5.711646824659e+01
RINT29405 nd7417 nd7418 7.751520690609e+01
RINT29406 nd7418 nd7419 5.711646824659e+01
RINT29407 nd7419 nd7420 5.711646824659e+01
RINT29408 nd7420 nd7421 5.711646824659e+01
RINT29409 nd7421 nd7422 5.711646824659e+01
RINT29410 nd7422 nd7423 5.711646824659e+01
RINT29411 nd7423 nd7424 5.711646824659e+01
RINT29412 nd7424 nd7425 1.570702876781e+02
RINT29413 nd7425 nd7426 2.570241071097e+02
RINT29414 nd7426 nd7427 1.286757122520e+02
RINT29415 nd7427 nd7428 1.587979254183e+00
RINT29416 nd7428 nd7429 2.753470604119e+01
RINT29417 nd7429 nd7430 2.708952493981e+01
RINT29418 nd7430 nd7431 1.958278911312e+00
RINT29419 nd7431 nd7432 1.958278911312e+00
RINT29420 nd7432 nd7433 1.958278911312e+00
RINT29421 nd7433 nd7434 1.958278911312e+00
RINT29422 nd7434 nd7435 1.958278911312e+00
RINT29423 nd7435 nd7436 1.958278911312e+00
RINT29424 nd7436 nd7437 1.958278911312e+00
RINT29425 nd7437 nd7438 1.958278911312e+00
RINT29426 nd7438 nd7439 1.958278911312e+00
RINT29427 nd7440 nd7441 1.809049213629e+00
RINT29428 nd7441 nd7442 1.644378752938e+00
RINT29429 nd7442 nd7443 5.558248515568e+01
RINT29430 nd7443 nd7444 5.652331240488e+01
RINT29431 nd7444 nd7445 3.467190969629e+00
RINT29432 nd7445 nd7446 3.408348687909e+00
RINT29433 nd7446 nd7447 9.863669807754e+00
RINT29434 nd7447 nd7448 5.711646824659e+01
RINT29435 nd7448 nd7449 7.751520690609e+01
RINT29436 nd7449 nd7450 5.711646824659e+01
RINT29437 nd7450 nd7451 5.711646824659e+01
RINT29438 nd7451 nd7452 5.711646824659e+01
RINT29439 nd7452 nd7453 5.711646824659e+01
RINT29440 nd7453 nd7454 5.711646824659e+01
RINT29441 nd7454 nd7455 5.711646824659e+01
RINT29442 nd7455 nd7456 1.570702876781e+02
RINT29443 nd7456 nd7457 2.570241071097e+02
RINT29444 nd7457 nd7458 1.286757122520e+02
RINT29445 nd7458 nd7459 1.587979254183e+00
RINT29446 nd7459 nd7460 2.753470604119e+01
RINT29447 nd7460 nd7461 2.708952493981e+01
RINT29448 nd7461 nd7462 1.958278911312e+00
RINT29449 nd7462 nd7463 1.958278911312e+00
RINT29450 nd7463 nd7464 1.958278911312e+00
RINT29451 nd7464 nd7465 1.958278911312e+00
RINT29452 nd7465 nd7466 1.958278911312e+00
RINT29453 nd7466 nd7467 1.958278911312e+00
RINT29454 nd7467 nd7468 1.958278911312e+00
RINT29455 nd7468 nd7469 1.958278911312e+00
RINT29456 nd7469 nd7470 1.958278911312e+00
RINT29457 nd7471 nd7472 1.732116531491e+01
RINT29458 nd7472 nd7473 1.574448942870e+01
RINT29459 nd7473 nd7474 5.321875196883e+02
RINT29460 nd7474 nd7475 5.411956904962e+02
RINT29461 nd7475 nd7476 3.319743183927e+01
RINT29462 nd7476 nd7477 3.263403263403e+01
RINT29463 nd7477 nd7478 9.444201631702e+01
RINT29464 nd7478 nd7479 5.468750000000e+02
RINT29465 nd7479 nd7480 7.421875000000e+02
RINT29466 nd7480 nd7481 5.468750000000e+02
RINT29467 nd7481 nd7482 5.468750000000e+02
RINT29468 nd7482 nd7483 5.468750000000e+02
RINT29469 nd7483 nd7484 5.468750000000e+02
RINT29470 nd7484 nd7485 5.468750000000e+02
RINT29471 nd7485 nd7486 5.468750000000e+02
RINT29472 nd7486 nd7487 1.503906250000e+03
RINT29473 nd7487 nd7488 2.460937500000e+03
RINT29474 nd7488 nd7489 1.232035738519e+03
RINT29475 nd7489 nd7490 1.520447922098e+01
RINT29476 nd7490 nd7491 2.636374907017e+02
RINT29477 nd7491 nd7492 2.593750000000e+02
RINT29478 nd7492 nd7493 1.875000000000e+01
RINT29479 nd7493 nd7494 1.875000000000e+01
RINT29480 nd7494 nd7495 1.875000000000e+01
RINT29481 nd7495 nd7496 1.875000000000e+01
RINT29482 nd7496 nd7497 1.875000000000e+01
RINT29483 nd7497 nd7498 1.875000000000e+01
RINT29484 nd7498 nd7499 1.875000000000e+01
RINT29485 nd7499 nd7500 1.875000000000e+01
RINT29486 nd7500 nd7501 1.875000000000e+01
RINT29487 nd7502 nd7503 1.809049213629e+00
RINT29488 nd7503 nd7504 1.644378752938e+00
RINT29489 nd7504 nd7505 5.558248515568e+01
RINT29490 nd7505 nd7506 5.652331240488e+01
RINT29491 nd7506 nd7507 3.467190969629e+00
RINT29492 nd7507 nd7508 3.408348687909e+00
RINT29493 nd7508 nd7509 9.863669807754e+00
RINT29494 nd7509 nd7510 5.711646824659e+01
RINT29495 nd7510 nd7511 7.751520690609e+01
RINT29496 nd7511 nd7512 5.711646824659e+01
RINT29497 nd7512 nd7513 5.711646824659e+01
RINT29498 nd7513 nd7514 5.711646824659e+01
RINT29499 nd7514 nd7515 5.711646824659e+01
RINT29500 nd7515 nd7516 5.711646824659e+01
RINT29501 nd7516 nd7517 5.711646824659e+01
RINT29502 nd7517 nd7518 1.570702876781e+02
RINT29503 nd7518 nd7519 2.570241071097e+02
RINT29504 nd7519 nd7520 1.286757122520e+02
RINT29505 nd7520 nd7521 1.587979254183e+00
RINT29506 nd7521 nd7522 2.753470604119e+01
RINT29507 nd7522 nd7523 2.708952493981e+01
RINT29508 nd7523 nd7524 1.958278911312e+00
RINT29509 nd7524 nd7525 1.958278911312e+00
RINT29510 nd7525 nd7526 1.958278911312e+00
RINT29511 nd7526 nd7527 1.958278911312e+00
RINT29512 nd7527 nd7528 1.958278911312e+00
RINT29513 nd7528 nd7529 1.958278911312e+00
RINT29514 nd7529 nd7530 1.958278911312e+00
RINT29515 nd7530 nd7531 1.958278911312e+00
RINT29516 nd7531 nd7532 1.958278911312e+00
RINT29517 nd7533 nd7534 1.809049213629e+00
RINT29518 nd7534 nd7535 1.644378752938e+00
RINT29519 nd7535 nd7536 5.558248515568e+01
RINT29520 nd7536 nd7537 5.652331240488e+01
RINT29521 nd7537 nd7538 3.467190969629e+00
RINT29522 nd7538 nd7539 3.408348687909e+00
RINT29523 nd7539 nd7540 9.863669807754e+00
RINT29524 nd7540 nd7541 5.711646824659e+01
RINT29525 nd7541 nd7542 7.751520690609e+01
RINT29526 nd7542 nd7543 5.711646824659e+01
RINT29527 nd7543 nd7544 5.711646824659e+01
RINT29528 nd7544 nd7545 5.711646824659e+01
RINT29529 nd7545 nd7546 5.711646824659e+01
RINT29530 nd7546 nd7547 5.711646824659e+01
RINT29531 nd7547 nd7548 5.711646824659e+01
RINT29532 nd7548 nd7549 1.570702876781e+02
RINT29533 nd7549 nd7550 2.570241071097e+02
RINT29534 nd7550 nd7551 1.286757122520e+02
RINT29535 nd7551 nd7552 1.587979254183e+00
RINT29536 nd7552 nd7553 2.753470604119e+01
RINT29537 nd7553 nd7554 2.708952493981e+01
RINT29538 nd7554 nd7555 1.958278911312e+00
RINT29539 nd7555 nd7556 1.958278911312e+00
RINT29540 nd7556 nd7557 1.958278911312e+00
RINT29541 nd7557 nd7558 1.958278911312e+00
RINT29542 nd7558 nd7559 1.958278911312e+00
RINT29543 nd7559 nd7560 1.958278911312e+00
RINT29544 nd7560 nd7561 1.958278911312e+00
RINT29545 nd7561 nd7562 1.958278911312e+00
RINT29546 nd7562 nd7563 1.958278911312e+00
RINT29547 nd7564 nd7565 1.809049213629e+00
RINT29548 nd7565 nd7566 1.644378752938e+00
RINT29549 nd7566 nd7567 5.558248515568e+01
RINT29550 nd7567 nd7568 5.652331240488e+01
RINT29551 nd7568 nd7569 3.467190969629e+00
RINT29552 nd7569 nd7570 3.408348687909e+00
RINT29553 nd7570 nd7571 9.863669807754e+00
RINT29554 nd7571 nd7572 5.711646824659e+01
RINT29555 nd7572 nd7573 7.751520690609e+01
RINT29556 nd7573 nd7574 5.711646824659e+01
RINT29557 nd7574 nd7575 5.711646824659e+01
RINT29558 nd7575 nd7576 5.711646824659e+01
RINT29559 nd7576 nd7577 5.711646824659e+01
RINT29560 nd7577 nd7578 5.711646824659e+01
RINT29561 nd7578 nd7579 5.711646824659e+01
RINT29562 nd7579 nd7580 1.570702876781e+02
RINT29563 nd7580 nd7581 2.570241071097e+02
RINT29564 nd7581 nd7582 1.286757122520e+02
RINT29565 nd7582 nd7583 1.587979254183e+00
RINT29566 nd7583 nd7584 2.753470604119e+01
RINT29567 nd7584 nd7585 2.708952493981e+01
RINT29568 nd7585 nd7586 1.958278911312e+00
RINT29569 nd7586 nd7587 1.958278911312e+00
RINT29570 nd7587 nd7588 1.958278911312e+00
RINT29571 nd7588 nd7589 1.958278911312e+00
RINT29572 nd7589 nd7590 1.958278911312e+00
RINT29573 nd7590 nd7591 1.958278911312e+00
RINT29574 nd7591 nd7592 1.958278911312e+00
RINT29575 nd7592 nd7593 1.958278911312e+00
RINT29576 nd7593 nd7594 1.958278911312e+00
RINT29577 nd7595 nd7596 1.809049213629e+00
RINT29578 nd7596 nd7597 1.644378752938e+00
RINT29579 nd7597 nd7598 5.558248515568e+01
RINT29580 nd7598 nd7599 5.652331240488e+01
RINT29581 nd7599 nd7600 3.467190969629e+00
RINT29582 nd7600 nd7601 3.408348687909e+00
RINT29583 nd7601 nd7602 9.863669807754e+00
RINT29584 nd7602 nd7603 5.711646824659e+01
RINT29585 nd7603 nd7604 7.751520690609e+01
RINT29586 nd7604 nd7605 5.711646824659e+01
RINT29587 nd7605 nd7606 5.711646824659e+01
RINT29588 nd7606 nd7607 5.711646824659e+01
RINT29589 nd7607 nd7608 5.711646824659e+01
RINT29590 nd7608 nd7609 5.711646824659e+01
RINT29591 nd7609 nd7610 5.711646824659e+01
RINT29592 nd7610 nd7611 1.570702876781e+02
RINT29593 nd7611 nd7612 2.570241071097e+02
RINT29594 nd7612 nd7613 1.286757122520e+02
RINT29595 nd7613 nd7614 1.587979254183e+00
RINT29596 nd7614 nd7615 2.753470604119e+01
RINT29597 nd7615 nd7616 2.708952493981e+01
RINT29598 nd7616 nd7617 1.958278911312e+00
RINT29599 nd7617 nd7618 1.958278911312e+00
RINT29600 nd7618 nd7619 1.958278911312e+00
RINT29601 nd7619 nd7620 1.958278911312e+00
RINT29602 nd7620 nd7621 1.958278911312e+00
RINT29603 nd7621 nd7622 1.958278911312e+00
RINT29604 nd7622 nd7623 1.958278911312e+00
RINT29605 nd7623 nd7624 1.958278911312e+00
RINT29606 nd7624 nd7625 1.958278911312e+00
RINT29607 nd7626 nd7627 1.809049213629e+00
RINT29608 nd7627 nd7628 1.644378752938e+00
RINT29609 nd7628 nd7629 5.558248515568e+01
RINT29610 nd7629 nd7630 5.652331240488e+01
RINT29611 nd7630 nd7631 3.467190969629e+00
RINT29612 nd7631 nd7632 3.408348687909e+00
RINT29613 nd7632 nd7633 9.863669807754e+00
RINT29614 nd7633 nd7634 5.711646824659e+01
RINT29615 nd7634 nd7635 7.751520690609e+01
RINT29616 nd7635 nd7636 5.711646824659e+01
RINT29617 nd7636 nd7637 5.711646824659e+01
RINT29618 nd7637 nd7638 5.711646824659e+01
RINT29619 nd7638 nd7639 5.711646824659e+01
RINT29620 nd7639 nd7640 5.711646824659e+01
RINT29621 nd7640 nd7641 5.711646824659e+01
RINT29622 nd7641 nd7642 1.570702876781e+02
RINT29623 nd7642 nd7643 2.570241071097e+02
RINT29624 nd7643 nd7644 1.286757122520e+02
RINT29625 nd7644 nd7645 1.587979254183e+00
RINT29626 nd7645 nd7646 2.753470604119e+01
RINT29627 nd7646 nd7647 2.708952493981e+01
RINT29628 nd7647 nd7648 1.958278911312e+00
RINT29629 nd7648 nd7649 1.958278911312e+00
RINT29630 nd7649 nd7650 1.958278911312e+00
RINT29631 nd7650 nd7651 1.958278911312e+00
RINT29632 nd7651 nd7652 1.958278911312e+00
RINT29633 nd7652 nd7653 1.958278911312e+00
RINT29634 nd7653 nd7654 1.958278911312e+00
RINT29635 nd7654 nd7655 1.958278911312e+00
RINT29636 nd7655 nd7656 1.958278911312e+00
RINT29637 nd7657 nd7658 1.809049213629e+00
RINT29638 nd7658 nd7659 1.644378752938e+00
RINT29639 nd7659 nd7660 5.558248515568e+01
RINT29640 nd7660 nd7661 5.652331240488e+01
RINT29641 nd7661 nd7662 3.467190969629e+00
RINT29642 nd7662 nd7663 3.408348687909e+00
RINT29643 nd7663 nd7664 9.863669807754e+00
RINT29644 nd7664 nd7665 5.711646824659e+01
RINT29645 nd7665 nd7666 7.751520690609e+01
RINT29646 nd7666 nd7667 5.711646824659e+01
RINT29647 nd7667 nd7668 5.711646824659e+01
RINT29648 nd7668 nd7669 5.711646824659e+01
RINT29649 nd7669 nd7670 5.711646824659e+01
RINT29650 nd7670 nd7671 5.711646824659e+01
RINT29651 nd7671 nd7672 5.711646824659e+01
RINT29652 nd7672 nd7673 1.570702876781e+02
RINT29653 nd7673 nd7674 2.570241071097e+02
RINT29654 nd7674 nd7675 1.286757122520e+02
RINT29655 nd7675 nd7676 1.587979254183e+00
RINT29656 nd7676 nd7677 2.753470604119e+01
RINT29657 nd7677 nd7678 2.708952493981e+01
RINT29658 nd7678 nd7679 1.958278911312e+00
RINT29659 nd7679 nd7680 1.958278911312e+00
RINT29660 nd7680 nd7681 1.958278911312e+00
RINT29661 nd7681 nd7682 1.958278911312e+00
RINT29662 nd7682 nd7683 1.958278911312e+00
RINT29663 nd7683 nd7684 1.958278911312e+00
RINT29664 nd7684 nd7685 1.958278911312e+00
RINT29665 nd7685 nd7686 1.958278911312e+00
RINT29666 nd7686 nd7687 1.958278911312e+00
RINT29667 nd7688 nd7689 1.732116531491e+01
RINT29668 nd7689 nd7690 1.574448942870e+01
RINT29669 nd7690 nd7691 5.321875196883e+02
RINT29670 nd7691 nd7692 5.411956904962e+02
RINT29671 nd7692 nd7693 3.319743183927e+01
RINT29672 nd7693 nd7694 3.263403263403e+01
RINT29673 nd7694 nd7695 9.444201631702e+01
RINT29674 nd7695 nd7696 5.468750000000e+02
RINT29675 nd7696 nd7697 7.421875000000e+02
RINT29676 nd7697 nd7698 5.468750000000e+02
RINT29677 nd7698 nd7699 5.468750000000e+02
RINT29678 nd7699 nd7700 5.468750000000e+02
RINT29679 nd7700 nd7701 5.468750000000e+02
RINT29680 nd7701 nd7702 5.468750000000e+02
RINT29681 nd7702 nd7703 5.468750000000e+02
RINT29682 nd7703 nd7704 1.503906250000e+03
RINT29683 nd7704 nd7705 2.460937500000e+03
RINT29684 nd7705 nd7706 1.232035738519e+03
RINT29685 nd7706 nd7707 1.520447922098e+01
RINT29686 nd7707 nd7708 2.636374907017e+02
RINT29687 nd7708 nd7709 2.593750000000e+02
RINT29688 nd7709 nd7710 1.875000000000e+01
RINT29689 nd7710 nd7711 1.875000000000e+01
RINT29690 nd7711 nd7712 1.875000000000e+01
RINT29691 nd7712 nd7713 1.875000000000e+01
RINT29692 nd7713 nd7714 1.875000000000e+01
RINT29693 nd7714 nd7715 1.875000000000e+01
RINT29694 nd7715 nd7716 1.875000000000e+01
RINT29695 nd7716 nd7717 1.875000000000e+01
RINT29696 nd7717 nd7718 1.875000000000e+01
RINT29697 nd7719 nd7720 2.356247123801e+00
RINT29698 nd7720 nd7721 2.141767442179e+00
RINT29699 nd7721 nd7722 7.239497399800e+01
RINT29700 nd7722 nd7723 7.362038095942e+01
RINT29701 nd7723 nd7724 4.515940577133e+00
RINT29702 nd7724 nd7725 4.439299789244e+00
RINT29703 nd7725 nd7726 2.381593738975e+00
RINT29704 nd7726 nd7727 1.133606910468e+00
RINT29705 nd7727 nd7728 1.538466521349e+00
RINT29706 nd7728 nd7729 1.133606910468e+00
RINT29707 nd7729 nd7730 1.133606910468e+00
RINT29708 nd7730 nd7731 1.133606910468e+00
RINT29709 nd7731 nd7732 1.133606910468e+00
RINT29710 nd7732 nd7733 1.133606910468e+00
RINT29711 nd7733 nd7734 1.133606910468e+00
RINT29712 nd7734 nd7735 3.117419003786e+00
RINT29713 nd7735 nd7736 5.101231097105e+00
RINT29714 nd7736 nd7737 2.763777430240e+00
RINT29715 nd7737 nd7738 2.068308325796e+00
RINT29716 nd7738 nd7739 3.586335375814e+01
RINT29717 nd7739 nd7740 3.528351508831e+01
RINT29718 nd7740 nd7741 2.550615548552e+00
RINT29719 nd7741 nd7742 2.550615548552e+00
RINT29720 nd7742 nd7743 2.550615548552e+00
RINT29721 nd7743 nd7744 2.550615548552e+00
RINT29722 nd7744 nd7745 2.550615548552e+00
RINT29723 nd7745 nd7746 2.550615548552e+00
RINT29724 nd7746 nd7747 2.550615548552e+00
RINT29725 nd7747 nd7748 2.550615548552e+00
RINT29726 nd7748 nd7749 2.550615548552e+00
RINT29727 nd7750 nd7751 2.356247123801e+00
RINT29728 nd7751 nd7752 2.141767442179e+00
RINT29729 nd7752 nd7753 7.239497399800e+01
RINT29730 nd7753 nd7754 7.362038095942e+01
RINT29731 nd7754 nd7755 4.515940577133e+00
RINT29732 nd7755 nd7756 4.439299789244e+00
RINT29733 nd7756 nd7757 2.381593738975e+00
RINT29734 nd7757 nd7758 1.133606910468e+00
RINT29735 nd7758 nd7759 1.538466521349e+00
RINT29736 nd7759 nd7760 1.133606910468e+00
RINT29737 nd7760 nd7761 1.133606910468e+00
RINT29738 nd7761 nd7762 1.133606910468e+00
RINT29739 nd7762 nd7763 1.133606910468e+00
RINT29740 nd7763 nd7764 1.133606910468e+00
RINT29741 nd7764 nd7765 1.133606910468e+00
RINT29742 nd7765 nd7766 3.117419003786e+00
RINT29743 nd7766 nd7767 5.101231097105e+00
RINT29744 nd7767 nd7768 2.763777430240e+00
RINT29745 nd7768 nd7769 2.068308325796e+00
RINT29746 nd7769 nd7770 3.586335375814e+01
RINT29747 nd7770 nd7771 3.528351508831e+01
RINT29748 nd7771 nd7772 2.550615548552e+00
RINT29749 nd7772 nd7773 2.550615548552e+00
RINT29750 nd7773 nd7774 2.550615548552e+00
RINT29751 nd7774 nd7775 2.550615548552e+00
RINT29752 nd7775 nd7776 2.550615548552e+00
RINT29753 nd7776 nd7777 2.550615548552e+00
RINT29754 nd7777 nd7778 2.550615548552e+00
RINT29755 nd7778 nd7779 2.550615548552e+00
RINT29756 nd7779 nd7780 2.550615548552e+00
RINT29757 nd7781 nd7782 2.356247123801e+00
RINT29758 nd7782 nd7783 2.141767442179e+00
RINT29759 nd7783 nd7784 7.239497399800e+01
RINT29760 nd7784 nd7785 7.362038095942e+01
RINT29761 nd7785 nd7786 4.515940577133e+00
RINT29762 nd7786 nd7787 4.439299789244e+00
RINT29763 nd7787 nd7788 2.381593738975e+00
RINT29764 nd7788 nd7789 1.133606910468e+00
RINT29765 nd7789 nd7790 1.538466521349e+00
RINT29766 nd7790 nd7791 1.133606910468e+00
RINT29767 nd7791 nd7792 1.133606910468e+00
RINT29768 nd7792 nd7793 1.133606910468e+00
RINT29769 nd7793 nd7794 1.133606910468e+00
RINT29770 nd7794 nd7795 1.133606910468e+00
RINT29771 nd7795 nd7796 1.133606910468e+00
RINT29772 nd7796 nd7797 3.117419003786e+00
RINT29773 nd7797 nd7798 5.101231097105e+00
RINT29774 nd7798 nd7799 2.763777430240e+00
RINT29775 nd7799 nd7800 2.068308325796e+00
RINT29776 nd7800 nd7801 3.586335375814e+01
RINT29777 nd7801 nd7802 3.528351508831e+01
RINT29778 nd7802 nd7803 2.550615548552e+00
RINT29779 nd7803 nd7804 2.550615548552e+00
RINT29780 nd7804 nd7805 2.550615548552e+00
RINT29781 nd7805 nd7806 2.550615548552e+00
RINT29782 nd7806 nd7807 2.550615548552e+00
RINT29783 nd7807 nd7808 2.550615548552e+00
RINT29784 nd7808 nd7809 2.550615548552e+00
RINT29785 nd7809 nd7810 2.550615548552e+00
RINT29786 nd7810 nd7811 2.550615548552e+00
RINT29787 nd7812 nd7813 2.493313941068e-01
RINT29788 nd7813 nd7814 2.266357619356e-01
RINT29789 nd7814 nd7815 7.660631014006e+00
RINT29790 nd7815 nd7816 7.790300106417e+00
RINT29791 nd7816 nd7817 4.778640357485e-01
RINT29792 nd7817 nd7818 4.697541247393e-01
RINT29793 nd7818 nd7819 2.520135011038e-01
RINT29794 nd7819 nd7820 1.199550711388e-01
RINT29795 nd7820 nd7821 1.627961679741e-01
RINT29796 nd7821 nd7822 1.199550711388e-01
RINT29797 nd7822 nd7823 1.199550711388e-01
RINT29798 nd7823 nd7824 1.199550711388e-01
RINT29799 nd7824 nd7825 1.199550711388e-01
RINT29800 nd7825 nd7826 1.199550711388e-01
RINT29801 nd7826 nd7827 1.199550711388e-01
RINT29802 nd7827 nd7828 3.298764456317e-01
RINT29803 nd7828 nd7829 5.397978201245e-01
RINT29804 nd7829 nd7830 2.924550963786e-01
RINT29805 nd7830 nd7831 2.188625263897e-01
RINT29806 nd7831 nd7832 3.794958474237e+00
RINT29807 nd7832 nd7833 3.733601589195e+00
RINT29808 nd7833 nd7834 2.698989100623e-01
RINT29809 nd7834 nd7835 2.698989100623e-01
RINT29810 nd7835 nd7836 2.698989100623e-01
RINT29811 nd7836 nd7837 2.698989100623e-01
RINT29812 nd7837 nd7838 2.698989100623e-01
RINT29813 nd7838 nd7839 2.698989100623e-01
RINT29814 nd7839 nd7840 2.698989100623e-01
RINT29815 nd7840 nd7841 2.698989100623e-01
RINT29816 nd7841 nd7842 2.698989100623e-01
RINT29817 nd7843 nd7844 2.493313941068e-01
RINT29818 nd7844 nd7845 2.266357619356e-01
RINT29819 nd7845 nd7846 7.660631014006e+00
RINT29820 nd7846 nd7847 7.790300106417e+00
RINT29821 nd7847 nd7848 4.778640357485e-01
RINT29822 nd7848 nd7849 4.697541247393e-01
RINT29823 nd7849 nd7850 2.520135011038e-01
RINT29824 nd7850 nd7851 1.199550711388e-01
RINT29825 nd7851 nd7852 1.627961679741e-01
RINT29826 nd7852 nd7853 1.199550711388e-01
RINT29827 nd7853 nd7854 1.199550711388e-01
RINT29828 nd7854 nd7855 1.199550711388e-01
RINT29829 nd7855 nd7856 1.199550711388e-01
RINT29830 nd7856 nd7857 1.199550711388e-01
RINT29831 nd7857 nd7858 1.199550711388e-01
RINT29832 nd7858 nd7859 3.298764456317e-01
RINT29833 nd7859 nd7860 5.397978201245e-01
RINT29834 nd7860 nd7861 2.924550963786e-01
RINT29835 nd7861 nd7862 2.188625263897e-01
RINT29836 nd7862 nd7863 3.794958474237e+00
RINT29837 nd7863 nd7864 3.733601589195e+00
RINT29838 nd7864 nd7865 2.698989100623e-01
RINT29839 nd7865 nd7866 2.698989100623e-01
RINT29840 nd7866 nd7867 2.698989100623e-01
RINT29841 nd7867 nd7868 2.698989100623e-01
RINT29842 nd7868 nd7869 2.698989100623e-01
RINT29843 nd7869 nd7870 2.698989100623e-01
RINT29844 nd7870 nd7871 2.698989100623e-01
RINT29845 nd7871 nd7872 2.698989100623e-01
RINT29846 nd7872 nd7873 2.698989100623e-01
RINT29847 nd7874 nd7875 2.493313941068e-01
RINT29848 nd7875 nd7876 2.266357619356e-01
RINT29849 nd7876 nd7877 7.660631014006e+00
RINT29850 nd7877 nd7878 7.790300106417e+00
RINT29851 nd7878 nd7879 4.778640357485e-01
RINT29852 nd7879 nd7880 4.697541247393e-01
RINT29853 nd7880 nd7881 2.520135011038e-01
RINT29854 nd7881 nd7882 1.199550711388e-01
RINT29855 nd7882 nd7883 1.627961679741e-01
RINT29856 nd7883 nd7884 1.199550711388e-01
RINT29857 nd7884 nd7885 1.199550711388e-01
RINT29858 nd7885 nd7886 1.199550711388e-01
RINT29859 nd7886 nd7887 1.199550711388e-01
RINT29860 nd7887 nd7888 1.199550711388e-01
RINT29861 nd7888 nd7889 1.199550711388e-01
RINT29862 nd7889 nd7890 3.298764456317e-01
RINT29863 nd7890 nd7891 5.397978201245e-01
RINT29864 nd7891 nd7892 2.924550963786e-01
RINT29865 nd7892 nd7893 2.188625263897e-01
RINT29866 nd7893 nd7894 3.794958474237e+00
RINT29867 nd7894 nd7895 3.733601589195e+00
RINT29868 nd7895 nd7896 2.698989100623e-01
RINT29869 nd7896 nd7897 2.698989100623e-01
RINT29870 nd7897 nd7898 2.698989100623e-01
RINT29871 nd7898 nd7899 2.698989100623e-01
RINT29872 nd7899 nd7900 2.698989100623e-01
RINT29873 nd7900 nd7901 2.698989100623e-01
RINT29874 nd7901 nd7902 2.698989100623e-01
RINT29875 nd7902 nd7903 2.698989100623e-01
RINT29876 nd7903 nd7904 2.698989100623e-01
RINT29877 nd7905 nd7906 1.832876633312e+00
RINT29878 nd7906 nd7907 1.666037258616e+00
RINT29879 nd7907 nd7908 5.631457535580e+01
RINT29880 nd7908 nd7909 5.726779446562e+01
RINT29881 nd7909 nd7910 3.512858170793e+00
RINT29882 nd7910 nd7911 3.453240863313e+00
RINT29883 nd7911 nd7912 9.993586560904e+00
RINT29884 nd7912 nd7913 5.786876290473e+01
RINT29885 nd7913 nd7914 7.853617822785e+01
RINT29886 nd7914 nd7915 5.786876290473e+01
RINT29887 nd7915 nd7916 5.786876290473e+01
RINT29888 nd7916 nd7917 5.786876290473e+01
RINT29889 nd7917 nd7918 5.786876290473e+01
RINT29890 nd7918 nd7919 5.786876290473e+01
RINT29891 nd7919 nd7920 5.786876290473e+01
RINT29892 nd7920 nd7921 1.591390979880e+02
RINT29893 nd7921 nd7922 2.604094330713e+02
RINT29894 nd7922 nd7923 1.303705308206e+02
RINT29895 nd7923 nd7924 1.608894908578e+00
RINT29896 nd7924 nd7925 2.789737223720e+01
RINT29897 nd7925 nd7926 2.744632754910e+01
RINT29898 nd7926 nd7927 1.984071871019e+00
RINT29899 nd7927 nd7928 1.984071871019e+00
RINT29900 nd7928 nd7929 1.984071871019e+00
RINT29901 nd7929 nd7930 1.984071871019e+00
RINT29902 nd7930 nd7931 1.984071871019e+00
RINT29903 nd7931 nd7932 1.984071871019e+00
RINT29904 nd7932 nd7933 1.984071871019e+00
RINT29905 nd7933 nd7934 1.984071871019e+00
RINT29906 nd7934 nd7935 1.984071871019e+00
RINT29907 nd7936 nd7937 1.914284617627e-01
RINT29908 nd7937 nd7938 1.740035002137e-01
RINT29909 nd7938 nd7939 5.881581083666e+00
RINT29910 nd7939 nd7940 5.981136757300e+00
RINT29911 nd7940 nd7941 3.668883239623e-01
RINT29912 nd7941 nd7942 3.606618004430e-01
RINT29913 nd7942 nd7943 1.976741618838e-01
RINT29914 nd7943 nd7944 8.656063970739e-02
RINT29915 nd7944 nd7945 1.760179307529e-01
RINT29916 nd7945 nd7946 2.136011054157e-01
RINT29917 nd7946 nd7947 2.136011054157e-01
RINT29918 nd7947 nd7948 2.136011054157e-01
RINT29919 nd7948 nd7949 2.136011054157e-01
RINT29920 nd7949 nd7950 2.136011054157e-01
RINT29921 nd7950 nd7951 2.136011054157e-01
RINT29922 nd7951 nd7952 2.884961700761e-01
RINT29923 nd7952 nd7953 4.298149835847e-01
RINT29924 nd7953 nd7954 2.654372658145e-01
RINT29925 nd7954 nd7955 1.680354650659e-01
RINT29926 nd7955 nd7956 2.913644572433e+00
RINT29927 nd7956 nd7957 2.866536769726e+00
RINT29928 nd7957 nd7958 2.072195255224e-01
RINT29929 nd7958 nd7959 2.072195255224e-01
RINT29930 nd7959 nd7960 2.072195255224e-01
RINT29931 nd7960 nd7961 2.072195255224e-01
RINT29932 nd7961 nd7962 2.072195255224e-01
RINT29933 nd7962 nd7963 2.072195255224e-01
RINT29934 nd7963 nd7964 2.072195255224e-01
RINT29935 nd7964 nd7965 2.072195255224e-01
RINT29936 nd7965 nd7966 2.072195255224e-01
RINT29937 nd7967 nd7968 1.914284617627e-01
RINT29938 nd7968 nd7969 1.740035002137e-01
RINT29939 nd7969 nd7970 5.881581083666e+00
RINT29940 nd7970 nd7971 5.981136757300e+00
RINT29941 nd7971 nd7972 3.668883239623e-01
RINT29942 nd7972 nd7973 3.606618004430e-01
RINT29943 nd7973 nd7974 1.976741618838e-01
RINT29944 nd7974 nd7975 8.656063970739e-02
RINT29945 nd7975 nd7976 1.760179307529e-01
RINT29946 nd7976 nd7977 2.136011054157e-01
RINT29947 nd7977 nd7978 2.136011054157e-01
RINT29948 nd7978 nd7979 2.136011054157e-01
RINT29949 nd7979 nd7980 2.136011054157e-01
RINT29950 nd7980 nd7981 2.136011054157e-01
RINT29951 nd7981 nd7982 2.136011054157e-01
RINT29952 nd7982 nd7983 2.884961700761e-01
RINT29953 nd7983 nd7984 4.298149835847e-01
RINT29954 nd7984 nd7985 2.654372658145e-01
RINT29955 nd7985 nd7986 1.680354650659e-01
RINT29956 nd7986 nd7987 2.913644572433e+00
RINT29957 nd7987 nd7988 2.866536769726e+00
RINT29958 nd7988 nd7989 2.072195255224e-01
RINT29959 nd7989 nd7990 2.072195255224e-01
RINT29960 nd7990 nd7991 2.072195255224e-01
RINT29961 nd7991 nd7992 2.072195255224e-01
RINT29962 nd7992 nd7993 2.072195255224e-01
RINT29963 nd7993 nd7994 2.072195255224e-01
RINT29964 nd7994 nd7995 2.072195255224e-01
RINT29965 nd7995 nd7996 2.072195255224e-01
RINT29966 nd7996 nd7997 2.072195255224e-01
RINT29967 nd7998 nd7999 1.914284617627e-01
RINT29968 nd7999 nd8000 1.740035002137e-01
RINT29969 nd8000 nd8001 5.881581083666e+00
RINT29970 nd8001 nd8002 5.981136757300e+00
RINT29971 nd8002 nd8003 3.668883239623e-01
RINT29972 nd8003 nd8004 3.606618004430e-01
RINT29973 nd8004 nd8005 1.976741618838e-01
RINT29974 nd8005 nd8006 8.656063970739e-02
RINT29975 nd8006 nd8007 1.760179307529e-01
RINT29976 nd8007 nd8008 2.136011054157e-01
RINT29977 nd8008 nd8009 2.136011054157e-01
RINT29978 nd8009 nd8010 2.136011054157e-01
RINT29979 nd8010 nd8011 2.136011054157e-01
RINT29980 nd8011 nd8012 2.136011054157e-01
RINT29981 nd8012 nd8013 2.136011054157e-01
RINT29982 nd8013 nd8014 2.884961700761e-01
RINT29983 nd8014 nd8015 4.298149835847e-01
RINT29984 nd8015 nd8016 2.654372658145e-01
RINT29985 nd8016 nd8017 1.680354650659e-01
RINT29986 nd8017 nd8018 2.913644572433e+00
RINT29987 nd8018 nd8019 2.866536769726e+00
RINT29988 nd8019 nd8020 2.072195255224e-01
RINT29989 nd8020 nd8021 2.072195255224e-01
RINT29990 nd8021 nd8022 2.072195255224e-01
RINT29991 nd8022 nd8023 2.072195255224e-01
RINT29992 nd8023 nd8024 2.072195255224e-01
RINT29993 nd8024 nd8025 2.072195255224e-01
RINT29994 nd8025 nd8026 2.072195255224e-01
RINT29995 nd8026 nd8027 2.072195255224e-01
RINT29996 nd8027 nd8028 2.072195255224e-01
RINT29997 nd8029 nd8030 1.914284617627e-01
RINT29998 nd8030 nd8031 1.740035002137e-01
RINT29999 nd8031 nd8032 5.881581083666e+00
RINT30000 nd8032 nd8033 5.981136757300e+00
RINT30001 nd8033 nd8034 3.668883239623e-01
RINT30002 nd8034 nd8035 3.606618004430e-01
RINT30003 nd8035 nd8036 1.976741618838e-01
RINT30004 nd8036 nd8037 8.656063970739e-02
RINT30005 nd8037 nd8038 1.760179307529e-01
RINT30006 nd8038 nd8039 2.136011054157e-01
RINT30007 nd8039 nd8040 2.136011054157e-01
RINT30008 nd8040 nd8041 2.136011054157e-01
RINT30009 nd8041 nd8042 2.136011054157e-01
RINT30010 nd8042 nd8043 2.136011054157e-01
RINT30011 nd8043 nd8044 2.136011054157e-01
RINT30012 nd8044 nd8045 2.884961700761e-01
RINT30013 nd8045 nd8046 4.298149835847e-01
RINT30014 nd8046 nd8047 2.654372658145e-01
RINT30015 nd8047 nd8048 1.680354650659e-01
RINT30016 nd8048 nd8049 2.913644572433e+00
RINT30017 nd8049 nd8050 2.866536769726e+00
RINT30018 nd8050 nd8051 2.072195255224e-01
RINT30019 nd8051 nd8052 2.072195255224e-01
RINT30020 nd8052 nd8053 2.072195255224e-01
RINT30021 nd8053 nd8054 2.072195255224e-01
RINT30022 nd8054 nd8055 2.072195255224e-01
RINT30023 nd8055 nd8056 2.072195255224e-01
RINT30024 nd8056 nd8057 2.072195255224e-01
RINT30025 nd8057 nd8058 2.072195255224e-01
RINT30026 nd8058 nd8059 2.072195255224e-01
RINT30027 nd8060 nd8061 1.914284617627e-01
RINT30028 nd8061 nd8062 1.740035002137e-01
RINT30029 nd8062 nd8063 5.881581083666e+00
RINT30030 nd8063 nd8064 5.981136757300e+00
RINT30031 nd8064 nd8065 3.668883239623e-01
RINT30032 nd8065 nd8066 3.606618004430e-01
RINT30033 nd8066 nd8067 1.976741618838e-01
RINT30034 nd8067 nd8068 8.656063970739e-02
RINT30035 nd8068 nd8069 1.760179307529e-01
RINT30036 nd8069 nd8070 2.136011054157e-01
RINT30037 nd8070 nd8071 2.136011054157e-01
RINT30038 nd8071 nd8072 2.136011054157e-01
RINT30039 nd8072 nd8073 2.136011054157e-01
RINT30040 nd8073 nd8074 2.136011054157e-01
RINT30041 nd8074 nd8075 2.136011054157e-01
RINT30042 nd8075 nd8076 2.884961700761e-01
RINT30043 nd8076 nd8077 4.298149835847e-01
RINT30044 nd8077 nd8078 2.654372658145e-01
RINT30045 nd8078 nd8079 1.680354650659e-01
RINT30046 nd8079 nd8080 2.913644572433e+00
RINT30047 nd8080 nd8081 2.866536769726e+00
RINT30048 nd8081 nd8082 2.072195255224e-01
RINT30049 nd8082 nd8083 2.072195255224e-01
RINT30050 nd8083 nd8084 2.072195255224e-01
RINT30051 nd8084 nd8085 2.072195255224e-01
RINT30052 nd8085 nd8086 2.072195255224e-01
RINT30053 nd8086 nd8087 2.072195255224e-01
RINT30054 nd8087 nd8088 2.072195255224e-01
RINT30055 nd8088 nd8089 2.072195255224e-01
RINT30056 nd8089 nd8090 2.072195255224e-01
RINT30057 nd8091 nd8092 1.914284617627e-01
RINT30058 nd8092 nd8093 1.740035002137e-01
RINT30059 nd8093 nd8094 5.881581083666e+00
RINT30060 nd8094 nd8095 5.981136757300e+00
RINT30061 nd8095 nd8096 3.668883239623e-01
RINT30062 nd8096 nd8097 3.606618004430e-01
RINT30063 nd8097 nd8098 1.976741618838e-01
RINT30064 nd8098 nd8099 8.656063970739e-02
RINT30065 nd8099 nd8100 1.760179307529e-01
RINT30066 nd8100 nd8101 2.136011054157e-01
RINT30067 nd8101 nd8102 2.136011054157e-01
RINT30068 nd8102 nd8103 2.136011054157e-01
RINT30069 nd8103 nd8104 2.136011054157e-01
RINT30070 nd8104 nd8105 2.136011054157e-01
RINT30071 nd8105 nd8106 2.136011054157e-01
RINT30072 nd8106 nd8107 2.884961700761e-01
RINT30073 nd8107 nd8108 4.298149835847e-01
RINT30074 nd8108 nd8109 2.654372658145e-01
RINT30075 nd8109 nd8110 1.680354650659e-01
RINT30076 nd8110 nd8111 2.913644572433e+00
RINT30077 nd8111 nd8112 2.866536769726e+00
RINT30078 nd8112 nd8113 2.072195255224e-01
RINT30079 nd8113 nd8114 2.072195255224e-01
RINT30080 nd8114 nd8115 2.072195255224e-01
RINT30081 nd8115 nd8116 2.072195255224e-01
RINT30082 nd8116 nd8117 2.072195255224e-01
RINT30083 nd8117 nd8118 2.072195255224e-01
RINT30084 nd8118 nd8119 2.072195255224e-01
RINT30085 nd8119 nd8120 2.072195255224e-01
RINT30086 nd8120 nd8121 2.072195255224e-01
RINT30087 nd8122 nd8123 1.832876633312e+00
RINT30088 nd8123 nd8124 1.666037258616e+00
RINT30089 nd8124 nd8125 5.631457535579e+01
RINT30090 nd8125 nd8126 5.726779446562e+01
RINT30091 nd8126 nd8127 3.512858170793e+00
RINT30092 nd8127 nd8128 3.453240863313e+00
RINT30093 nd8128 nd8129 9.993586560904e+00
RINT30094 nd8129 nd8130 5.786876290473e+01
RINT30095 nd8130 nd8131 7.853617822785e+01
RINT30096 nd8131 nd8132 5.786876290473e+01
RINT30097 nd8132 nd8133 5.786876290473e+01
RINT30098 nd8133 nd8134 5.786876290473e+01
RINT30099 nd8134 nd8135 5.786876290473e+01
RINT30100 nd8135 nd8136 5.786876290473e+01
RINT30101 nd8136 nd8137 5.786876290473e+01
RINT30102 nd8137 nd8138 1.591390979880e+02
RINT30103 nd8138 nd8139 2.604094330713e+02
RINT30104 nd8139 nd8140 1.303705308206e+02
RINT30105 nd8140 nd8141 1.608894908578e+00
RINT30106 nd8141 nd8142 2.789737223720e+01
RINT30107 nd8142 nd8143 2.744632754910e+01
RINT30108 nd8143 nd8144 1.984071871019e+00
RINT30109 nd8144 nd8145 1.984071871019e+00
RINT30110 nd8145 nd8146 1.984071871019e+00
RINT30111 nd8146 nd8147 1.984071871019e+00
RINT30112 nd8147 nd8148 1.984071871019e+00
RINT30113 nd8148 nd8149 1.984071871019e+00
RINT30114 nd8149 nd8150 1.984071871019e+00
RINT30115 nd8150 nd8151 1.984071871019e+00
RINT30116 nd8151 nd8152 1.984071871019e+00
RINT30117 nd8153 nd8154 1.914284617627e-01
RINT30118 nd8154 nd8155 1.740035002137e-01
RINT30119 nd8155 nd8156 5.881581083666e+00
RINT30120 nd8156 nd8157 5.981136757300e+00
RINT30121 nd8157 nd8158 3.668883239623e-01
RINT30122 nd8158 nd8159 3.606618004430e-01
RINT30123 nd8159 nd8160 1.976741618838e-01
RINT30124 nd8160 nd8161 8.656063970739e-02
RINT30125 nd8161 nd8162 1.760179307529e-01
RINT30126 nd8162 nd8163 2.136011054157e-01
RINT30127 nd8163 nd8164 2.136011054157e-01
RINT30128 nd8164 nd8165 2.136011054157e-01
RINT30129 nd8165 nd8166 2.136011054157e-01
RINT30130 nd8166 nd8167 2.136011054157e-01
RINT30131 nd8167 nd8168 2.136011054157e-01
RINT30132 nd8168 nd8169 2.884961700761e-01
RINT30133 nd8169 nd8170 4.298149835847e-01
RINT30134 nd8170 nd8171 2.654372658145e-01
RINT30135 nd8171 nd8172 1.680354650659e-01
RINT30136 nd8172 nd8173 2.913644572433e+00
RINT30137 nd8173 nd8174 2.866536769726e+00
RINT30138 nd8174 nd8175 2.072195255224e-01
RINT30139 nd8175 nd8176 2.072195255224e-01
RINT30140 nd8176 nd8177 2.072195255224e-01
RINT30141 nd8177 nd8178 2.072195255224e-01
RINT30142 nd8178 nd8179 2.072195255224e-01
RINT30143 nd8179 nd8180 2.072195255224e-01
RINT30144 nd8180 nd8181 2.072195255224e-01
RINT30145 nd8181 nd8182 2.072195255224e-01
RINT30146 nd8182 nd8183 2.072195255224e-01
RINT30147 nd8184 nd8185 1.914284617627e-01
RINT30148 nd8185 nd8186 1.740035002137e-01
RINT30149 nd8186 nd8187 5.881581083666e+00
RINT30150 nd8187 nd8188 5.981136757300e+00
RINT30151 nd8188 nd8189 3.668883239623e-01
RINT30152 nd8189 nd8190 3.606618004430e-01
RINT30153 nd8190 nd8191 1.976741618838e-01
RINT30154 nd8191 nd8192 8.656063970738e-02
RINT30155 nd8192 nd8193 1.760179307529e-01
RINT30156 nd8193 nd8194 2.136011054157e-01
RINT30157 nd8194 nd8195 2.136011054157e-01
RINT30158 nd8195 nd8196 2.136011054157e-01
RINT30159 nd8196 nd8197 2.136011054157e-01
RINT30160 nd8197 nd8198 2.136011054157e-01
RINT30161 nd8198 nd8199 2.136011054157e-01
RINT30162 nd8199 nd8200 2.884961700761e-01
RINT30163 nd8200 nd8201 4.298149835847e-01
RINT30164 nd8201 nd8202 2.654372658145e-01
RINT30165 nd8202 nd8203 1.680354650659e-01
RINT30166 nd8203 nd8204 2.913644572433e+00
RINT30167 nd8204 nd8205 2.866536769726e+00
RINT30168 nd8205 nd8206 2.072195255224e-01
RINT30169 nd8206 nd8207 2.072195255224e-01
RINT30170 nd8207 nd8208 2.072195255224e-01
RINT30171 nd8208 nd8209 2.072195255224e-01
RINT30172 nd8209 nd8210 2.072195255224e-01
RINT30173 nd8210 nd8211 2.072195255224e-01
RINT30174 nd8211 nd8212 2.072195255224e-01
RINT30175 nd8212 nd8213 2.072195255224e-01
RINT30176 nd8213 nd8214 2.072195255224e-01
RINT30177 nd8215 nd8216 1.914284617627e-01
RINT30178 nd8216 nd8217 1.740035002137e-01
RINT30179 nd8217 nd8218 5.881581083666e+00
RINT30180 nd8218 nd8219 5.981136757300e+00
RINT30181 nd8219 nd8220 3.668883239623e-01
RINT30182 nd8220 nd8221 3.606618004430e-01
RINT30183 nd8221 nd8222 1.976741618838e-01
RINT30184 nd8222 nd8223 8.656063970739e-02
RINT30185 nd8223 nd8224 1.760179307529e-01
RINT30186 nd8224 nd8225 2.136011054157e-01
RINT30187 nd8225 nd8226 2.136011054157e-01
RINT30188 nd8226 nd8227 2.136011054157e-01
RINT30189 nd8227 nd8228 2.136011054157e-01
RINT30190 nd8228 nd8229 2.136011054157e-01
RINT30191 nd8229 nd8230 2.136011054157e-01
RINT30192 nd8230 nd8231 2.884961700761e-01
RINT30193 nd8231 nd8232 4.298149835847e-01
RINT30194 nd8232 nd8233 2.654372658145e-01
RINT30195 nd8233 nd8234 1.680354650659e-01
RINT30196 nd8234 nd8235 2.913644572433e+00
RINT30197 nd8235 nd8236 2.866536769726e+00
RINT30198 nd8236 nd8237 2.072195255224e-01
RINT30199 nd8237 nd8238 2.072195255224e-01
RINT30200 nd8238 nd8239 2.072195255224e-01
RINT30201 nd8239 nd8240 2.072195255224e-01
RINT30202 nd8240 nd8241 2.072195255224e-01
RINT30203 nd8241 nd8242 2.072195255224e-01
RINT30204 nd8242 nd8243 2.072195255224e-01
RINT30205 nd8243 nd8244 2.072195255224e-01
RINT30206 nd8244 nd8245 2.072195255224e-01
RINT30207 nd8246 nd8247 1.914284617627e-01
RINT30208 nd8247 nd8248 1.740035002137e-01
RINT30209 nd8248 nd8249 5.881581083666e+00
RINT30210 nd8249 nd8250 5.981136757300e+00
RINT30211 nd8250 nd8251 3.668883239623e-01
RINT30212 nd8251 nd8252 3.606618004430e-01
RINT30213 nd8252 nd8253 1.976741618838e-01
RINT30214 nd8253 nd8254 8.656063970739e-02
RINT30215 nd8254 nd8255 1.760179307529e-01
RINT30216 nd8255 nd8256 2.136011054157e-01
RINT30217 nd8256 nd8257 2.136011054157e-01
RINT30218 nd8257 nd8258 2.136011054157e-01
RINT30219 nd8258 nd8259 2.136011054157e-01
RINT30220 nd8259 nd8260 2.136011054157e-01
RINT30221 nd8260 nd8261 2.136011054157e-01
RINT30222 nd8261 nd8262 2.884961700761e-01
RINT30223 nd8262 nd8263 4.298149835847e-01
RINT30224 nd8263 nd8264 2.654372658145e-01
RINT30225 nd8264 nd8265 1.680354650659e-01
RINT30226 nd8265 nd8266 2.913644572433e+00
RINT30227 nd8266 nd8267 2.866536769726e+00
RINT30228 nd8267 nd8268 2.072195255224e-01
RINT30229 nd8268 nd8269 2.072195255224e-01
RINT30230 nd8269 nd8270 2.072195255224e-01
RINT30231 nd8270 nd8271 2.072195255224e-01
RINT30232 nd8271 nd8272 2.072195255224e-01
RINT30233 nd8272 nd8273 2.072195255224e-01
RINT30234 nd8273 nd8274 2.072195255224e-01
RINT30235 nd8274 nd8275 2.072195255224e-01
RINT30236 nd8275 nd8276 2.072195255224e-01
RINT30237 nd8277 nd8278 1.914284617627e-01
RINT30238 nd8278 nd8279 1.740035002137e-01
RINT30239 nd8279 nd8280 5.881581083666e+00
RINT30240 nd8280 nd8281 5.981136757300e+00
RINT30241 nd8281 nd8282 3.668883239623e-01
RINT30242 nd8282 nd8283 3.606618004430e-01
RINT30243 nd8283 nd8284 1.976741618838e-01
RINT30244 nd8284 nd8285 8.656063970738e-02
RINT30245 nd8285 nd8286 1.760179307529e-01
RINT30246 nd8286 nd8287 2.136011054157e-01
RINT30247 nd8287 nd8288 2.136011054157e-01
RINT30248 nd8288 nd8289 2.136011054157e-01
RINT30249 nd8289 nd8290 2.136011054157e-01
RINT30250 nd8290 nd8291 2.136011054157e-01
RINT30251 nd8291 nd8292 2.136011054157e-01
RINT30252 nd8292 nd8293 2.884961700761e-01
RINT30253 nd8293 nd8294 4.298149835847e-01
RINT30254 nd8294 nd8295 2.654372658145e-01
RINT30255 nd8295 nd8296 1.680354650659e-01
RINT30256 nd8296 nd8297 2.913644572433e+00
RINT30257 nd8297 nd8298 2.866536769726e+00
RINT30258 nd8298 nd8299 2.072195255224e-01
RINT30259 nd8299 nd8300 2.072195255224e-01
RINT30260 nd8300 nd8301 2.072195255224e-01
RINT30261 nd8301 nd8302 2.072195255224e-01
RINT30262 nd8302 nd8303 2.072195255224e-01
RINT30263 nd8303 nd8304 2.072195255224e-01
RINT30264 nd8304 nd8305 2.072195255224e-01
RINT30265 nd8305 nd8306 2.072195255224e-01
RINT30266 nd8306 nd8307 2.072195255224e-01
RINT30267 nd8308 nd8309 1.914284617627e-01
RINT30268 nd8309 nd8310 1.740035002137e-01
RINT30269 nd8310 nd8311 5.881581083666e+00
RINT30270 nd8311 nd8312 5.981136757300e+00
RINT30271 nd8312 nd8313 3.668883239623e-01
RINT30272 nd8313 nd8314 3.606618004430e-01
RINT30273 nd8314 nd8315 1.976741618838e-01
RINT30274 nd8315 nd8316 8.656063970739e-02
RINT30275 nd8316 nd8317 1.760179307529e-01
RINT30276 nd8317 nd8318 2.136011054157e-01
RINT30277 nd8318 nd8319 2.136011054157e-01
RINT30278 nd8319 nd8320 2.136011054157e-01
RINT30279 nd8320 nd8321 2.136011054157e-01
RINT30280 nd8321 nd8322 2.136011054157e-01
RINT30281 nd8322 nd8323 2.136011054157e-01
RINT30282 nd8323 nd8324 2.884961700761e-01
RINT30283 nd8324 nd8325 4.298149835847e-01
RINT30284 nd8325 nd8326 2.654372658145e-01
RINT30285 nd8326 nd8327 1.680354650659e-01
RINT30286 nd8327 nd8328 2.913644572433e+00
RINT30287 nd8328 nd8329 2.866536769726e+00
RINT30288 nd8329 nd8330 2.072195255224e-01
RINT30289 nd8330 nd8331 2.072195255224e-01
RINT30290 nd8331 nd8332 2.072195255224e-01
RINT30291 nd8332 nd8333 2.072195255224e-01
RINT30292 nd8333 nd8334 2.072195255224e-01
RINT30293 nd8334 nd8335 2.072195255224e-01
RINT30294 nd8335 nd8336 2.072195255224e-01
RINT30295 nd8336 nd8337 2.072195255224e-01
RINT30296 nd8337 nd8338 2.072195255224e-01
RINT30297 nd8339 nd8340 1.832876633312e+00
RINT30298 nd8340 nd8341 1.666037258616e+00
RINT30299 nd8341 nd8342 5.631457535579e+01
RINT30300 nd8342 nd8343 5.726779446562e+01
RINT30301 nd8343 nd8344 3.512858170793e+00
RINT30302 nd8344 nd8345 3.453240863313e+00
RINT30303 nd8345 nd8346 9.993586560904e+00
RINT30304 nd8346 nd8347 5.786876290473e+01
RINT30305 nd8347 nd8348 7.853617822785e+01
RINT30306 nd8348 nd8349 5.786876290473e+01
RINT30307 nd8349 nd8350 5.786876290473e+01
RINT30308 nd8350 nd8351 5.786876290473e+01
RINT30309 nd8351 nd8352 5.786876290473e+01
RINT30310 nd8352 nd8353 5.786876290473e+01
RINT30311 nd8353 nd8354 5.786876290473e+01
RINT30312 nd8354 nd8355 1.591390979880e+02
RINT30313 nd8355 nd8356 2.604094330713e+02
RINT30314 nd8356 nd8357 1.303705308206e+02
RINT30315 nd8357 nd8358 1.608894908578e+00
RINT30316 nd8358 nd8359 2.789737223720e+01
RINT30317 nd8359 nd8360 2.744632754910e+01
RINT30318 nd8360 nd8361 1.984071871019e+00
RINT30319 nd8361 nd8362 1.984071871019e+00
RINT30320 nd8362 nd8363 1.984071871019e+00
RINT30321 nd8363 nd8364 1.984071871019e+00
RINT30322 nd8364 nd8365 1.984071871019e+00
RINT30323 nd8365 nd8366 1.984071871019e+00
RINT30324 nd8366 nd8367 1.984071871019e+00
RINT30325 nd8367 nd8368 1.984071871019e+00
RINT30326 nd8368 nd8369 1.984071871019e+00
RINT30327 nd8370 nd8371 2.493313941068e-01
RINT30328 nd8371 nd8372 2.266357619356e-01
RINT30329 nd8372 nd8373 7.660631014006e+00
RINT30330 nd8373 nd8374 7.790300106417e+00
RINT30331 nd8374 nd8375 4.778640357485e-01
RINT30332 nd8375 nd8376 4.697541247393e-01
RINT30333 nd8376 nd8377 2.520135011038e-01
RINT30334 nd8377 nd8378 1.199550711388e-01
RINT30335 nd8378 nd8379 1.627961679741e-01
RINT30336 nd8379 nd8380 1.199550711388e-01
RINT30337 nd8380 nd8381 1.199550711388e-01
RINT30338 nd8381 nd8382 1.199550711388e-01
RINT30339 nd8382 nd8383 1.199550711388e-01
RINT30340 nd8383 nd8384 1.199550711388e-01
RINT30341 nd8384 nd8385 1.199550711388e-01
RINT30342 nd8385 nd8386 3.298764456317e-01
RINT30343 nd8386 nd8387 5.397978201245e-01
RINT30344 nd8387 nd8388 2.924550963786e-01
RINT30345 nd8388 nd8389 2.188625263897e-01
RINT30346 nd8389 nd8390 3.794958474237e+00
RINT30347 nd8390 nd8391 3.733601589195e+00
RINT30348 nd8391 nd8392 2.698989100623e-01
RINT30349 nd8392 nd8393 2.698989100623e-01
RINT30350 nd8393 nd8394 2.698989100623e-01
RINT30351 nd8394 nd8395 2.698989100623e-01
RINT30352 nd8395 nd8396 2.698989100623e-01
RINT30353 nd8396 nd8397 2.698989100623e-01
RINT30354 nd8397 nd8398 2.698989100623e-01
RINT30355 nd8398 nd8399 2.698989100623e-01
RINT30356 nd8399 nd8400 2.698989100623e-01
RINT30357 nd8401 nd8402 2.493313941068e-01
RINT30358 nd8402 nd8403 2.266357619356e-01
RINT30359 nd8403 nd8404 7.660631014006e+00
RINT30360 nd8404 nd8405 7.790300106417e+00
RINT30361 nd8405 nd8406 4.778640357485e-01
RINT30362 nd8406 nd8407 4.697541247393e-01
RINT30363 nd8407 nd8408 2.520135011038e-01
RINT30364 nd8408 nd8409 1.199550711388e-01
RINT30365 nd8409 nd8410 1.627961679741e-01
RINT30366 nd8410 nd8411 1.199550711388e-01
RINT30367 nd8411 nd8412 1.199550711388e-01
RINT30368 nd8412 nd8413 1.199550711388e-01
RINT30369 nd8413 nd8414 1.199550711388e-01
RINT30370 nd8414 nd8415 1.199550711388e-01
RINT30371 nd8415 nd8416 1.199550711388e-01
RINT30372 nd8416 nd8417 3.298764456317e-01
RINT30373 nd8417 nd8418 5.397978201245e-01
RINT30374 nd8418 nd8419 2.924550963786e-01
RINT30375 nd8419 nd8420 2.188625263897e-01
RINT30376 nd8420 nd8421 3.794958474237e+00
RINT30377 nd8421 nd8422 3.733601589195e+00
RINT30378 nd8422 nd8423 2.698989100623e-01
RINT30379 nd8423 nd8424 2.698989100623e-01
RINT30380 nd8424 nd8425 2.698989100623e-01
RINT30381 nd8425 nd8426 2.698989100623e-01
RINT30382 nd8426 nd8427 2.698989100623e-01
RINT30383 nd8427 nd8428 2.698989100623e-01
RINT30384 nd8428 nd8429 2.698989100623e-01
RINT30385 nd8429 nd8430 2.698989100623e-01
RINT30386 nd8430 nd8431 2.698989100623e-01
RINT30387 nd8432 nd8433 2.493313941068e-01
RINT30388 nd8433 nd8434 2.266357619356e-01
RINT30389 nd8434 nd8435 7.660631014006e+00
RINT30390 nd8435 nd8436 7.790300106417e+00
RINT30391 nd8436 nd8437 4.778640357485e-01
RINT30392 nd8437 nd8438 4.697541247393e-01
RINT30393 nd8438 nd8439 2.520135011038e-01
RINT30394 nd8439 nd8440 1.199550711388e-01
RINT30395 nd8440 nd8441 1.627961679741e-01
RINT30396 nd8441 nd8442 1.199550711388e-01
RINT30397 nd8442 nd8443 1.199550711388e-01
RINT30398 nd8443 nd8444 1.199550711388e-01
RINT30399 nd8444 nd8445 1.199550711388e-01
RINT30400 nd8445 nd8446 1.199550711388e-01
RINT30401 nd8446 nd8447 1.199550711388e-01
RINT30402 nd8447 nd8448 3.298764456317e-01
RINT30403 nd8448 nd8449 5.397978201245e-01
RINT30404 nd8449 nd8450 2.924550963786e-01
RINT30405 nd8450 nd8451 2.188625263897e-01
RINT30406 nd8451 nd8452 3.794958474237e+00
RINT30407 nd8452 nd8453 3.733601589195e+00
RINT30408 nd8453 nd8454 2.698989100623e-01
RINT30409 nd8454 nd8455 2.698989100623e-01
RINT30410 nd8455 nd8456 2.698989100623e-01
RINT30411 nd8456 nd8457 2.698989100623e-01
RINT30412 nd8457 nd8458 2.698989100623e-01
RINT30413 nd8458 nd8459 2.698989100623e-01
RINT30414 nd8459 nd8460 2.698989100623e-01
RINT30415 nd8460 nd8461 2.698989100623e-01
RINT30416 nd8461 nd8462 2.698989100623e-01
RINT30417 nd8463 nd8464 2.493313941068e-01
RINT30418 nd8464 nd8465 2.266357619356e-01
RINT30419 nd8465 nd8466 7.660631014006e+00
RINT30420 nd8466 nd8467 7.790300106417e+00
RINT30421 nd8467 nd8468 4.778640357485e-01
RINT30422 nd8468 nd8469 4.697541247393e-01
RINT30423 nd8469 nd8470 2.520135011038e-01
RINT30424 nd8470 nd8471 1.199550711388e-01
RINT30425 nd8471 nd8472 1.627961679741e-01
RINT30426 nd8472 nd8473 1.199550711388e-01
RINT30427 nd8473 nd8474 1.199550711388e-01
RINT30428 nd8474 nd8475 1.199550711388e-01
RINT30429 nd8475 nd8476 1.199550711388e-01
RINT30430 nd8476 nd8477 1.199550711388e-01
RINT30431 nd8477 nd8478 1.199550711388e-01
RINT30432 nd8478 nd8479 3.298764456317e-01
RINT30433 nd8479 nd8480 5.397978201245e-01
RINT30434 nd8480 nd8481 2.924550963786e-01
RINT30435 nd8481 nd8482 2.188625263897e-01
RINT30436 nd8482 nd8483 3.794958474237e+00
RINT30437 nd8483 nd8484 3.733601589195e+00
RINT30438 nd8484 nd8485 2.698989100623e-01
RINT30439 nd8485 nd8486 2.698989100623e-01
RINT30440 nd8486 nd8487 2.698989100623e-01
RINT30441 nd8487 nd8488 2.698989100623e-01
RINT30442 nd8488 nd8489 2.698989100623e-01
RINT30443 nd8489 nd8490 2.698989100623e-01
RINT30444 nd8490 nd8491 2.698989100623e-01
RINT30445 nd8491 nd8492 2.698989100623e-01
RINT30446 nd8492 nd8493 2.698989100623e-01
RINT30447 nd8494 nd8495 2.493313941068e-01
RINT30448 nd8495 nd8496 2.266357619356e-01
RINT30449 nd8496 nd8497 7.660631014006e+00
RINT30450 nd8497 nd8498 7.790300106417e+00
RINT30451 nd8498 nd8499 4.778640357485e-01
RINT30452 nd8499 nd8500 4.697541247393e-01
RINT30453 nd8500 nd8501 2.520135011038e-01
RINT30454 nd8501 nd8502 1.199550711388e-01
RINT30455 nd8502 nd8503 1.627961679741e-01
RINT30456 nd8503 nd8504 1.199550711388e-01
RINT30457 nd8504 nd8505 1.199550711388e-01
RINT30458 nd8505 nd8506 1.199550711388e-01
RINT30459 nd8506 nd8507 1.199550711388e-01
RINT30460 nd8507 nd8508 1.199550711388e-01
RINT30461 nd8508 nd8509 1.199550711388e-01
RINT30462 nd8509 nd8510 3.298764456317e-01
RINT30463 nd8510 nd8511 5.397978201245e-01
RINT30464 nd8511 nd8512 2.924550963786e-01
RINT30465 nd8512 nd8513 2.188625263897e-01
RINT30466 nd8513 nd8514 3.794958474237e+00
RINT30467 nd8514 nd8515 3.733601589195e+00
RINT30468 nd8515 nd8516 2.698989100623e-01
RINT30469 nd8516 nd8517 2.698989100623e-01
RINT30470 nd8517 nd8518 2.698989100623e-01
RINT30471 nd8518 nd8519 2.698989100623e-01
RINT30472 nd8519 nd8520 2.698989100623e-01
RINT30473 nd8520 nd8521 2.698989100623e-01
RINT30474 nd8521 nd8522 2.698989100623e-01
RINT30475 nd8522 nd8523 2.698989100623e-01
RINT30476 nd8523 nd8524 2.698989100623e-01
RINT30477 nd8525 nd8526 2.493313941068e-01
RINT30478 nd8526 nd8527 2.266357619356e-01
RINT30479 nd8527 nd8528 7.660631014006e+00
RINT30480 nd8528 nd8529 7.790300106417e+00
RINT30481 nd8529 nd8530 4.778640357485e-01
RINT30482 nd8530 nd8531 4.697541247393e-01
RINT30483 nd8531 nd8532 2.520135011038e-01
RINT30484 nd8532 nd8533 1.199550711388e-01
RINT30485 nd8533 nd8534 1.627961679741e-01
RINT30486 nd8534 nd8535 1.199550711388e-01
RINT30487 nd8535 nd8536 1.199550711388e-01
RINT30488 nd8536 nd8537 1.199550711388e-01
RINT30489 nd8537 nd8538 1.199550711388e-01
RINT30490 nd8538 nd8539 1.199550711388e-01
RINT30491 nd8539 nd8540 1.199550711388e-01
RINT30492 nd8540 nd8541 3.298764456317e-01
RINT30493 nd8541 nd8542 5.397978201245e-01
RINT30494 nd8542 nd8543 2.924550963786e-01
RINT30495 nd8543 nd8544 2.188625263897e-01
RINT30496 nd8544 nd8545 3.794958474237e+00
RINT30497 nd8545 nd8546 3.733601589195e+00
RINT30498 nd8546 nd8547 2.698989100623e-01
RINT30499 nd8547 nd8548 2.698989100623e-01
RINT30500 nd8548 nd8549 2.698989100623e-01
RINT30501 nd8549 nd8550 2.698989100623e-01
RINT30502 nd8550 nd8551 2.698989100623e-01
RINT30503 nd8551 nd8552 2.698989100623e-01
RINT30504 nd8552 nd8553 2.698989100623e-01
RINT30505 nd8553 nd8554 2.698989100623e-01
RINT30506 nd8554 nd8555 2.698989100623e-01
RINT30507 nd8556 nd8557 1.832876633312e+00
RINT30508 nd8557 nd8558 1.666037258616e+00
RINT30509 nd8558 nd8559 5.631457535580e+01
RINT30510 nd8559 nd8560 5.726779446562e+01
RINT30511 nd8560 nd8561 3.512858170793e+00
RINT30512 nd8561 nd8562 3.453240863313e+00
RINT30513 nd8562 nd8563 9.993586560904e+00
RINT30514 nd8563 nd8564 5.786876290473e+01
RINT30515 nd8564 nd8565 7.853617822785e+01
RINT30516 nd8565 nd8566 5.786876290473e+01
RINT30517 nd8566 nd8567 5.786876290473e+01
RINT30518 nd8567 nd8568 5.786876290473e+01
RINT30519 nd8568 nd8569 5.786876290473e+01
RINT30520 nd8569 nd8570 5.786876290473e+01
RINT30521 nd8570 nd8571 5.786876290473e+01
RINT30522 nd8571 nd8572 1.591390979880e+02
RINT30523 nd8572 nd8573 2.604094330713e+02
RINT30524 nd8573 nd8574 1.303705308206e+02
RINT30525 nd8574 nd8575 1.608894908578e+00
RINT30526 nd8575 nd8576 2.789737223720e+01
RINT30527 nd8576 nd8577 2.744632754910e+01
RINT30528 nd8577 nd8578 1.984071871019e+00
RINT30529 nd8578 nd8579 1.984071871019e+00
RINT30530 nd8579 nd8580 1.984071871019e+00
RINT30531 nd8580 nd8581 1.984071871019e+00
RINT30532 nd8581 nd8582 1.984071871019e+00
RINT30533 nd8582 nd8583 1.984071871019e+00
RINT30534 nd8583 nd8584 1.984071871019e+00
RINT30535 nd8584 nd8585 1.984071871019e+00
RINT30536 nd8585 nd8586 1.984071871019e+00
RINT30537 nd8587 nd8588 1.914284617627e-01
RINT30538 nd8588 nd8589 1.740035002137e-01
RINT30539 nd8589 nd8590 5.881581083666e+00
RINT30540 nd8590 nd8591 5.981136757300e+00
RINT30541 nd8591 nd8592 3.668883239623e-01
RINT30542 nd8592 nd8593 3.606618004430e-01
RINT30543 nd8593 nd8594 1.976741618838e-01
RINT30544 nd8594 nd8595 8.656063970739e-02
RINT30545 nd8595 nd8596 1.760179307529e-01
RINT30546 nd8596 nd8597 2.136011054157e-01
RINT30547 nd8597 nd8598 2.136011054157e-01
RINT30548 nd8598 nd8599 2.136011054157e-01
RINT30549 nd8599 nd8600 2.136011054157e-01
RINT30550 nd8600 nd8601 2.136011054157e-01
RINT30551 nd8601 nd8602 2.136011054157e-01
RINT30552 nd8602 nd8603 2.884961700761e-01
RINT30553 nd8603 nd8604 4.298149835847e-01
RINT30554 nd8604 nd8605 2.654372658145e-01
RINT30555 nd8605 nd8606 1.680354650659e-01
RINT30556 nd8606 nd8607 2.913644572433e+00
RINT30557 nd8607 nd8608 2.866536769726e+00
RINT30558 nd8608 nd8609 2.072195255224e-01
RINT30559 nd8609 nd8610 2.072195255224e-01
RINT30560 nd8610 nd8611 2.072195255224e-01
RINT30561 nd8611 nd8612 2.072195255224e-01
RINT30562 nd8612 nd8613 2.072195255224e-01
RINT30563 nd8613 nd8614 2.072195255224e-01
RINT30564 nd8614 nd8615 2.072195255224e-01
RINT30565 nd8615 nd8616 2.072195255224e-01
RINT30566 nd8616 nd8617 2.072195255224e-01
RINT30567 nd8618 nd8619 1.914284617627e-01
RINT30568 nd8619 nd8620 1.740035002137e-01
RINT30569 nd8620 nd8621 5.881581083666e+00
RINT30570 nd8621 nd8622 5.981136757300e+00
RINT30571 nd8622 nd8623 3.668883239623e-01
RINT30572 nd8623 nd8624 3.606618004430e-01
RINT30573 nd8624 nd8625 1.976741618838e-01
RINT30574 nd8625 nd8626 8.656063970739e-02
RINT30575 nd8626 nd8627 1.760179307529e-01
RINT30576 nd8627 nd8628 2.136011054157e-01
RINT30577 nd8628 nd8629 2.136011054157e-01
RINT30578 nd8629 nd8630 2.136011054157e-01
RINT30579 nd8630 nd8631 2.136011054157e-01
RINT30580 nd8631 nd8632 2.136011054157e-01
RINT30581 nd8632 nd8633 2.136011054157e-01
RINT30582 nd8633 nd8634 2.884961700761e-01
RINT30583 nd8634 nd8635 4.298149835847e-01
RINT30584 nd8635 nd8636 2.654372658145e-01
RINT30585 nd8636 nd8637 1.680354650659e-01
RINT30586 nd8637 nd8638 2.913644572433e+00
RINT30587 nd8638 nd8639 2.866536769726e+00
RINT30588 nd8639 nd8640 2.072195255224e-01
RINT30589 nd8640 nd8641 2.072195255224e-01
RINT30590 nd8641 nd8642 2.072195255224e-01
RINT30591 nd8642 nd8643 2.072195255224e-01
RINT30592 nd8643 nd8644 2.072195255224e-01
RINT30593 nd8644 nd8645 2.072195255224e-01
RINT30594 nd8645 nd8646 2.072195255224e-01
RINT30595 nd8646 nd8647 2.072195255224e-01
RINT30596 nd8647 nd8648 2.072195255224e-01
RINT30597 nd8649 nd8650 1.914284617627e-01
RINT30598 nd8650 nd8651 1.740035002137e-01
RINT30599 nd8651 nd8652 5.881581083666e+00
RINT30600 nd8652 nd8653 5.981136757300e+00
RINT30601 nd8653 nd8654 3.668883239623e-01
RINT30602 nd8654 nd8655 3.606618004430e-01
RINT30603 nd8655 nd8656 1.976741618838e-01
RINT30604 nd8656 nd8657 8.656063970739e-02
RINT30605 nd8657 nd8658 1.760179307529e-01
RINT30606 nd8658 nd8659 2.136011054157e-01
RINT30607 nd8659 nd8660 2.136011054157e-01
RINT30608 nd8660 nd8661 2.136011054157e-01
RINT30609 nd8661 nd8662 2.136011054157e-01
RINT30610 nd8662 nd8663 2.136011054157e-01
RINT30611 nd8663 nd8664 2.136011054157e-01
RINT30612 nd8664 nd8665 2.884961700761e-01
RINT30613 nd8665 nd8666 4.298149835847e-01
RINT30614 nd8666 nd8667 2.654372658145e-01
RINT30615 nd8667 nd8668 1.680354650659e-01
RINT30616 nd8668 nd8669 2.913644572433e+00
RINT30617 nd8669 nd8670 2.866536769726e+00
RINT30618 nd8670 nd8671 2.072195255224e-01
RINT30619 nd8671 nd8672 2.072195255224e-01
RINT30620 nd8672 nd8673 2.072195255224e-01
RINT30621 nd8673 nd8674 2.072195255224e-01
RINT30622 nd8674 nd8675 2.072195255224e-01
RINT30623 nd8675 nd8676 2.072195255224e-01
RINT30624 nd8676 nd8677 2.072195255224e-01
RINT30625 nd8677 nd8678 2.072195255224e-01
RINT30626 nd8678 nd8679 2.072195255224e-01
RINT30627 nd8680 nd8681 1.914284617627e-01
RINT30628 nd8681 nd8682 1.740035002137e-01
RINT30629 nd8682 nd8683 5.881581083666e+00
RINT30630 nd8683 nd8684 5.981136757300e+00
RINT30631 nd8684 nd8685 3.668883239623e-01
RINT30632 nd8685 nd8686 3.606618004430e-01
RINT30633 nd8686 nd8687 1.976741618838e-01
RINT30634 nd8687 nd8688 8.656063970739e-02
RINT30635 nd8688 nd8689 1.760179307529e-01
RINT30636 nd8689 nd8690 2.136011054157e-01
RINT30637 nd8690 nd8691 2.136011054157e-01
RINT30638 nd8691 nd8692 2.136011054157e-01
RINT30639 nd8692 nd8693 2.136011054157e-01
RINT30640 nd8693 nd8694 2.136011054157e-01
RINT30641 nd8694 nd8695 2.136011054157e-01
RINT30642 nd8695 nd8696 2.884961700761e-01
RINT30643 nd8696 nd8697 4.298149835847e-01
RINT30644 nd8697 nd8698 2.654372658145e-01
RINT30645 nd8698 nd8699 1.680354650659e-01
RINT30646 nd8699 nd8700 2.913644572433e+00
RINT30647 nd8700 nd8701 2.866536769726e+00
RINT30648 nd8701 nd8702 2.072195255224e-01
RINT30649 nd8702 nd8703 2.072195255224e-01
RINT30650 nd8703 nd8704 2.072195255224e-01
RINT30651 nd8704 nd8705 2.072195255224e-01
RINT30652 nd8705 nd8706 2.072195255224e-01
RINT30653 nd8706 nd8707 2.072195255224e-01
RINT30654 nd8707 nd8708 2.072195255224e-01
RINT30655 nd8708 nd8709 2.072195255224e-01
RINT30656 nd8709 nd8710 2.072195255224e-01
RINT30657 nd8711 nd8712 1.914284617627e-01
RINT30658 nd8712 nd8713 1.740035002137e-01
RINT30659 nd8713 nd8714 5.881581083666e+00
RINT30660 nd8714 nd8715 5.981136757300e+00
RINT30661 nd8715 nd8716 3.668883239623e-01
RINT30662 nd8716 nd8717 3.606618004430e-01
RINT30663 nd8717 nd8718 1.976741618838e-01
RINT30664 nd8718 nd8719 8.656063970739e-02
RINT30665 nd8719 nd8720 1.760179307529e-01
RINT30666 nd8720 nd8721 2.136011054157e-01
RINT30667 nd8721 nd8722 2.136011054157e-01
RINT30668 nd8722 nd8723 2.136011054157e-01
RINT30669 nd8723 nd8724 2.136011054157e-01
RINT30670 nd8724 nd8725 2.136011054157e-01
RINT30671 nd8725 nd8726 2.136011054157e-01
RINT30672 nd8726 nd8727 2.884961700761e-01
RINT30673 nd8727 nd8728 4.298149835847e-01
RINT30674 nd8728 nd8729 2.654372658145e-01
RINT30675 nd8729 nd8730 1.680354650659e-01
RINT30676 nd8730 nd8731 2.913644572433e+00
RINT30677 nd8731 nd8732 2.866536769726e+00
RINT30678 nd8732 nd8733 2.072195255224e-01
RINT30679 nd8733 nd8734 2.072195255224e-01
RINT30680 nd8734 nd8735 2.072195255224e-01
RINT30681 nd8735 nd8736 2.072195255224e-01
RINT30682 nd8736 nd8737 2.072195255224e-01
RINT30683 nd8737 nd8738 2.072195255224e-01
RINT30684 nd8738 nd8739 2.072195255224e-01
RINT30685 nd8739 nd8740 2.072195255224e-01
RINT30686 nd8740 nd8741 2.072195255224e-01
RINT30687 nd8742 nd8743 1.914284617627e-01
RINT30688 nd8743 nd8744 1.740035002137e-01
RINT30689 nd8744 nd8745 5.881581083666e+00
RINT30690 nd8745 nd8746 5.981136757300e+00
RINT30691 nd8746 nd8747 3.668883239623e-01
RINT30692 nd8747 nd8748 3.606618004430e-01
RINT30693 nd8748 nd8749 1.976741618838e-01
RINT30694 nd8749 nd8750 8.656063970739e-02
RINT30695 nd8750 nd8751 1.760179307529e-01
RINT30696 nd8751 nd8752 2.136011054157e-01
RINT30697 nd8752 nd8753 2.136011054157e-01
RINT30698 nd8753 nd8754 2.136011054157e-01
RINT30699 nd8754 nd8755 2.136011054157e-01
RINT30700 nd8755 nd8756 2.136011054157e-01
RINT30701 nd8756 nd8757 2.136011054157e-01
RINT30702 nd8757 nd8758 2.884961700761e-01
RINT30703 nd8758 nd8759 4.298149835847e-01
RINT30704 nd8759 nd8760 2.654372658145e-01
RINT30705 nd8760 nd8761 1.680354650659e-01
RINT30706 nd8761 nd8762 2.913644572433e+00
RINT30707 nd8762 nd8763 2.866536769726e+00
RINT30708 nd8763 nd8764 2.072195255224e-01
RINT30709 nd8764 nd8765 2.072195255224e-01
RINT30710 nd8765 nd8766 2.072195255224e-01
RINT30711 nd8766 nd8767 2.072195255224e-01
RINT30712 nd8767 nd8768 2.072195255224e-01
RINT30713 nd8768 nd8769 2.072195255224e-01
RINT30714 nd8769 nd8770 2.072195255224e-01
RINT30715 nd8770 nd8771 2.072195255224e-01
RINT30716 nd8771 nd8772 2.072195255224e-01
RINT30717 nd8773 nd8774 1.832876633312e+00
RINT30718 nd8774 nd8775 1.666037258616e+00
RINT30719 nd8775 nd8776 5.631457535579e+01
RINT30720 nd8776 nd8777 5.726779446562e+01
RINT30721 nd8777 nd8778 3.512858170793e+00
RINT30722 nd8778 nd8779 3.453240863313e+00
RINT30723 nd8779 nd8780 9.993586560904e+00
RINT30724 nd8780 nd8781 5.786876290473e+01
RINT30725 nd8781 nd8782 7.853617822785e+01
RINT30726 nd8782 nd8783 5.786876290473e+01
RINT30727 nd8783 nd8784 5.786876290473e+01
RINT30728 nd8784 nd8785 5.786876290473e+01
RINT30729 nd8785 nd8786 5.786876290473e+01
RINT30730 nd8786 nd8787 5.786876290473e+01
RINT30731 nd8787 nd8788 5.786876290473e+01
RINT30732 nd8788 nd8789 1.591390979880e+02
RINT30733 nd8789 nd8790 2.604094330713e+02
RINT30734 nd8790 nd8791 1.303705308206e+02
RINT30735 nd8791 nd8792 1.608894908578e+00
RINT30736 nd8792 nd8793 2.789737223720e+01
RINT30737 nd8793 nd8794 2.744632754910e+01
RINT30738 nd8794 nd8795 1.984071871019e+00
RINT30739 nd8795 nd8796 1.984071871019e+00
RINT30740 nd8796 nd8797 1.984071871019e+00
RINT30741 nd8797 nd8798 1.984071871019e+00
RINT30742 nd8798 nd8799 1.984071871019e+00
RINT30743 nd8799 nd8800 1.984071871019e+00
RINT30744 nd8800 nd8801 1.984071871019e+00
RINT30745 nd8801 nd8802 1.984071871019e+00
RINT30746 nd8802 nd8803 1.984071871019e+00
RINT30747 nd8804 nd8805 1.914284617627e-01
RINT30748 nd8805 nd8806 1.740035002137e-01
RINT30749 nd8806 nd8807 5.881581083666e+00
RINT30750 nd8807 nd8808 5.981136757300e+00
RINT30751 nd8808 nd8809 3.668883239623e-01
RINT30752 nd8809 nd8810 3.606618004430e-01
RINT30753 nd8810 nd8811 1.976741618838e-01
RINT30754 nd8811 nd8812 8.656063970739e-02
RINT30755 nd8812 nd8813 1.760179307529e-01
RINT30756 nd8813 nd8814 2.136011054157e-01
RINT30757 nd8814 nd8815 2.136011054157e-01
RINT30758 nd8815 nd8816 2.136011054157e-01
RINT30759 nd8816 nd8817 2.136011054157e-01
RINT30760 nd8817 nd8818 2.136011054157e-01
RINT30761 nd8818 nd8819 2.136011054157e-01
RINT30762 nd8819 nd8820 2.884961700761e-01
RINT30763 nd8820 nd8821 4.298149835847e-01
RINT30764 nd8821 nd8822 2.654372658145e-01
RINT30765 nd8822 nd8823 1.680354650659e-01
RINT30766 nd8823 nd8824 2.913644572433e+00
RINT30767 nd8824 nd8825 2.866536769726e+00
RINT30768 nd8825 nd8826 2.072195255224e-01
RINT30769 nd8826 nd8827 2.072195255224e-01
RINT30770 nd8827 nd8828 2.072195255224e-01
RINT30771 nd8828 nd8829 2.072195255224e-01
RINT30772 nd8829 nd8830 2.072195255224e-01
RINT30773 nd8830 nd8831 2.072195255224e-01
RINT30774 nd8831 nd8832 2.072195255224e-01
RINT30775 nd8832 nd8833 2.072195255224e-01
RINT30776 nd8833 nd8834 2.072195255224e-01
RINT30777 nd8835 nd8836 1.914284617627e-01
RINT30778 nd8836 nd8837 1.740035002137e-01
RINT30779 nd8837 nd8838 5.881581083666e+00
RINT30780 nd8838 nd8839 5.981136757300e+00
RINT30781 nd8839 nd8840 3.668883239623e-01
RINT30782 nd8840 nd8841 3.606618004430e-01
RINT30783 nd8841 nd8842 1.976741618838e-01
RINT30784 nd8842 nd8843 8.656063970738e-02
RINT30785 nd8843 nd8844 1.760179307529e-01
RINT30786 nd8844 nd8845 2.136011054157e-01
RINT30787 nd8845 nd8846 2.136011054157e-01
RINT30788 nd8846 nd8847 2.136011054157e-01
RINT30789 nd8847 nd8848 2.136011054157e-01
RINT30790 nd8848 nd8849 2.136011054157e-01
RINT30791 nd8849 nd8850 2.136011054157e-01
RINT30792 nd8850 nd8851 2.884961700761e-01
RINT30793 nd8851 nd8852 4.298149835847e-01
RINT30794 nd8852 nd8853 2.654372658145e-01
RINT30795 nd8853 nd8854 1.680354650659e-01
RINT30796 nd8854 nd8855 2.913644572433e+00
RINT30797 nd8855 nd8856 2.866536769726e+00
RINT30798 nd8856 nd8857 2.072195255224e-01
RINT30799 nd8857 nd8858 2.072195255224e-01
RINT30800 nd8858 nd8859 2.072195255224e-01
RINT30801 nd8859 nd8860 2.072195255224e-01
RINT30802 nd8860 nd8861 2.072195255224e-01
RINT30803 nd8861 nd8862 2.072195255224e-01
RINT30804 nd8862 nd8863 2.072195255224e-01
RINT30805 nd8863 nd8864 2.072195255224e-01
RINT30806 nd8864 nd8865 2.072195255224e-01
RINT30807 nd8866 nd8867 1.914284617627e-01
RINT30808 nd8867 nd8868 1.740035002137e-01
RINT30809 nd8868 nd8869 5.881581083666e+00
RINT30810 nd8869 nd8870 5.981136757300e+00
RINT30811 nd8870 nd8871 3.668883239623e-01
RINT30812 nd8871 nd8872 3.606618004430e-01
RINT30813 nd8872 nd8873 1.976741618838e-01
RINT30814 nd8873 nd8874 8.656063970739e-02
RINT30815 nd8874 nd8875 1.760179307529e-01
RINT30816 nd8875 nd8876 2.136011054157e-01
RINT30817 nd8876 nd8877 2.136011054157e-01
RINT30818 nd8877 nd8878 2.136011054157e-01
RINT30819 nd8878 nd8879 2.136011054157e-01
RINT30820 nd8879 nd8880 2.136011054157e-01
RINT30821 nd8880 nd8881 2.136011054157e-01
RINT30822 nd8881 nd8882 2.884961700761e-01
RINT30823 nd8882 nd8883 4.298149835847e-01
RINT30824 nd8883 nd8884 2.654372658145e-01
RINT30825 nd8884 nd8885 1.680354650659e-01
RINT30826 nd8885 nd8886 2.913644572433e+00
RINT30827 nd8886 nd8887 2.866536769726e+00
RINT30828 nd8887 nd8888 2.072195255224e-01
RINT30829 nd8888 nd8889 2.072195255224e-01
RINT30830 nd8889 nd8890 2.072195255224e-01
RINT30831 nd8890 nd8891 2.072195255224e-01
RINT30832 nd8891 nd8892 2.072195255224e-01
RINT30833 nd8892 nd8893 2.072195255224e-01
RINT30834 nd8893 nd8894 2.072195255224e-01
RINT30835 nd8894 nd8895 2.072195255224e-01
RINT30836 nd8895 nd8896 2.072195255224e-01
RINT30837 nd8897 nd8898 1.914284617627e-01
RINT30838 nd8898 nd8899 1.740035002137e-01
RINT30839 nd8899 nd8900 5.881581083666e+00
RINT30840 nd8900 nd8901 5.981136757300e+00
RINT30841 nd8901 nd8902 3.668883239623e-01
RINT30842 nd8902 nd8903 3.606618004430e-01
RINT30843 nd8903 nd8904 1.976741618838e-01
RINT30844 nd8904 nd8905 8.656063970739e-02
RINT30845 nd8905 nd8906 1.760179307529e-01
RINT30846 nd8906 nd8907 2.136011054157e-01
RINT30847 nd8907 nd8908 2.136011054157e-01
RINT30848 nd8908 nd8909 2.136011054157e-01
RINT30849 nd8909 nd8910 2.136011054157e-01
RINT30850 nd8910 nd8911 2.136011054157e-01
RINT30851 nd8911 nd8912 2.136011054157e-01
RINT30852 nd8912 nd8913 2.884961700761e-01
RINT30853 nd8913 nd8914 4.298149835847e-01
RINT30854 nd8914 nd8915 2.654372658145e-01
RINT30855 nd8915 nd8916 1.680354650659e-01
RINT30856 nd8916 nd8917 2.913644572433e+00
RINT30857 nd8917 nd8918 2.866536769726e+00
RINT30858 nd8918 nd8919 2.072195255224e-01
RINT30859 nd8919 nd8920 2.072195255224e-01
RINT30860 nd8920 nd8921 2.072195255224e-01
RINT30861 nd8921 nd8922 2.072195255224e-01
RINT30862 nd8922 nd8923 2.072195255224e-01
RINT30863 nd8923 nd8924 2.072195255224e-01
RINT30864 nd8924 nd8925 2.072195255224e-01
RINT30865 nd8925 nd8926 2.072195255224e-01
RINT30866 nd8926 nd8927 2.072195255224e-01
RINT30867 nd8928 nd8929 1.914284617627e-01
RINT30868 nd8929 nd8930 1.740035002137e-01
RINT30869 nd8930 nd8931 5.881581083666e+00
RINT30870 nd8931 nd8932 5.981136757300e+00
RINT30871 nd8932 nd8933 3.668883239623e-01
RINT30872 nd8933 nd8934 3.606618004430e-01
RINT30873 nd8934 nd8935 1.976741618838e-01
RINT30874 nd8935 nd8936 8.656063970738e-02
RINT30875 nd8936 nd8937 1.760179307529e-01
RINT30876 nd8937 nd8938 2.136011054157e-01
RINT30877 nd8938 nd8939 2.136011054157e-01
RINT30878 nd8939 nd8940 2.136011054157e-01
RINT30879 nd8940 nd8941 2.136011054157e-01
RINT30880 nd8941 nd8942 2.136011054157e-01
RINT30881 nd8942 nd8943 2.136011054157e-01
RINT30882 nd8943 nd8944 2.884961700761e-01
RINT30883 nd8944 nd8945 4.298149835847e-01
RINT30884 nd8945 nd8946 2.654372658145e-01
RINT30885 nd8946 nd8947 1.680354650659e-01
RINT30886 nd8947 nd8948 2.913644572433e+00
RINT30887 nd8948 nd8949 2.866536769726e+00
RINT30888 nd8949 nd8950 2.072195255224e-01
RINT30889 nd8950 nd8951 2.072195255224e-01
RINT30890 nd8951 nd8952 2.072195255224e-01
RINT30891 nd8952 nd8953 2.072195255224e-01
RINT30892 nd8953 nd8954 2.072195255224e-01
RINT30893 nd8954 nd8955 2.072195255224e-01
RINT30894 nd8955 nd8956 2.072195255224e-01
RINT30895 nd8956 nd8957 2.072195255224e-01
RINT30896 nd8957 nd8958 2.072195255224e-01
RINT30897 nd8959 nd8960 1.914284617627e-01
RINT30898 nd8960 nd8961 1.740035002137e-01
RINT30899 nd8961 nd8962 5.881581083666e+00
RINT30900 nd8962 nd8963 5.981136757300e+00
RINT30901 nd8963 nd8964 3.668883239623e-01
RINT30902 nd8964 nd8965 3.606618004430e-01
RINT30903 nd8965 nd8966 1.976741618838e-01
RINT30904 nd8966 nd8967 8.656063970739e-02
RINT30905 nd8967 nd8968 1.760179307529e-01
RINT30906 nd8968 nd8969 2.136011054157e-01
RINT30907 nd8969 nd8970 2.136011054157e-01
RINT30908 nd8970 nd8971 2.136011054157e-01
RINT30909 nd8971 nd8972 2.136011054157e-01
RINT30910 nd8972 nd8973 2.136011054157e-01
RINT30911 nd8973 nd8974 2.136011054157e-01
RINT30912 nd8974 nd8975 2.884961700761e-01
RINT30913 nd8975 nd8976 4.298149835847e-01
RINT30914 nd8976 nd8977 2.654372658145e-01
RINT30915 nd8977 nd8978 1.680354650659e-01
RINT30916 nd8978 nd8979 2.913644572433e+00
RINT30917 nd8979 nd8980 2.866536769726e+00
RINT30918 nd8980 nd8981 2.072195255224e-01
RINT30919 nd8981 nd8982 2.072195255224e-01
RINT30920 nd8982 nd8983 2.072195255224e-01
RINT30921 nd8983 nd8984 2.072195255224e-01
RINT30922 nd8984 nd8985 2.072195255224e-01
RINT30923 nd8985 nd8986 2.072195255224e-01
RINT30924 nd8986 nd8987 2.072195255224e-01
RINT30925 nd8987 nd8988 2.072195255224e-01
RINT30926 nd8988 nd8989 2.072195255224e-01
RINT30927 nd8990 nd8991 1.832876633312e+00
RINT30928 nd8991 nd8992 1.666037258616e+00
RINT30929 nd8992 nd8993 5.631457535579e+01
RINT30930 nd8993 nd8994 5.726779446562e+01
RINT30931 nd8994 nd8995 3.512858170793e+00
RINT30932 nd8995 nd8996 3.453240863313e+00
RINT30933 nd8996 nd8997 9.993586560904e+00
RINT30934 nd8997 nd8998 5.786876290473e+01
RINT30935 nd8998 nd8999 7.853617822785e+01
RINT30936 nd8999 nd9000 5.786876290473e+01
RINT30937 nd9000 nd9001 5.786876290473e+01
RINT30938 nd9001 nd9002 5.786876290473e+01
RINT30939 nd9002 nd9003 5.786876290473e+01
RINT30940 nd9003 nd9004 5.786876290473e+01
RINT30941 nd9004 nd9005 5.786876290473e+01
RINT30942 nd9005 nd9006 1.591390979880e+02
RINT30943 nd9006 nd9007 2.604094330713e+02
RINT30944 nd9007 nd9008 1.303705308206e+02
RINT30945 nd9008 nd9009 1.608894908578e+00
RINT30946 nd9009 nd9010 2.789737223720e+01
RINT30947 nd9010 nd9011 2.744632754910e+01
RINT30948 nd9011 nd9012 1.984071871019e+00
RINT30949 nd9012 nd9013 1.984071871019e+00
RINT30950 nd9013 nd9014 1.984071871019e+00
RINT30951 nd9014 nd9015 1.984071871019e+00
RINT30952 nd9015 nd9016 1.984071871019e+00
RINT30953 nd9016 nd9017 1.984071871019e+00
RINT30954 nd9017 nd9018 1.984071871019e+00
RINT30955 nd9018 nd9019 1.984071871019e+00
RINT30956 nd9019 nd9020 1.984071871019e+00
RINT30957 nd9021 nd9022 2.493313941068e-01
RINT30958 nd9022 nd9023 2.266357619356e-01
RINT30959 nd9023 nd9024 7.660631014006e+00
RINT30960 nd9024 nd9025 7.790300106417e+00
RINT30961 nd9025 nd9026 4.778640357485e-01
RINT30962 nd9026 nd9027 4.697541247393e-01
RINT30963 nd9027 nd9028 2.520135011038e-01
RINT30964 nd9028 nd9029 1.199550711388e-01
RINT30965 nd9029 nd9030 1.627961679741e-01
RINT30966 nd9030 nd9031 1.199550711388e-01
RINT30967 nd9031 nd9032 1.199550711388e-01
RINT30968 nd9032 nd9033 1.199550711388e-01
RINT30969 nd9033 nd9034 1.199550711388e-01
RINT30970 nd9034 nd9035 1.199550711388e-01
RINT30971 nd9035 nd9036 1.199550711388e-01
RINT30972 nd9036 nd9037 3.298764456317e-01
RINT30973 nd9037 nd9038 5.397978201245e-01
RINT30974 nd9038 nd9039 2.924550963786e-01
RINT30975 nd9039 nd9040 2.188625263897e-01
RINT30976 nd9040 nd9041 3.794958474237e+00
RINT30977 nd9041 nd9042 3.733601589195e+00
RINT30978 nd9042 nd9043 2.698989100623e-01
RINT30979 nd9043 nd9044 2.698989100623e-01
RINT30980 nd9044 nd9045 2.698989100623e-01
RINT30981 nd9045 nd9046 2.698989100623e-01
RINT30982 nd9046 nd9047 2.698989100623e-01
RINT30983 nd9047 nd9048 2.698989100623e-01
RINT30984 nd9048 nd9049 2.698989100623e-01
RINT30985 nd9049 nd9050 2.698989100623e-01
RINT30986 nd9050 nd9051 2.698989100623e-01
RINT30987 nd9052 nd9053 2.493313941068e-01
RINT30988 nd9053 nd9054 2.266357619356e-01
RINT30989 nd9054 nd9055 7.660631014006e+00
RINT30990 nd9055 nd9056 7.790300106417e+00
RINT30991 nd9056 nd9057 4.778640357485e-01
RINT30992 nd9057 nd9058 4.697541247393e-01
RINT30993 nd9058 nd9059 2.520135011038e-01
RINT30994 nd9059 nd9060 1.199550711388e-01
RINT30995 nd9060 nd9061 1.627961679741e-01
RINT30996 nd9061 nd9062 1.199550711388e-01
RINT30997 nd9062 nd9063 1.199550711388e-01
RINT30998 nd9063 nd9064 1.199550711388e-01
RINT30999 nd9064 nd9065 1.199550711388e-01
RINT31000 nd9065 nd9066 1.199550711388e-01
RINT31001 nd9066 nd9067 1.199550711388e-01
RINT31002 nd9067 nd9068 3.298764456317e-01
RINT31003 nd9068 nd9069 5.397978201245e-01
RINT31004 nd9069 nd9070 2.924550963786e-01
RINT31005 nd9070 nd9071 2.188625263897e-01
RINT31006 nd9071 nd9072 3.794958474237e+00
RINT31007 nd9072 nd9073 3.733601589195e+00
RINT31008 nd9073 nd9074 2.698989100623e-01
RINT31009 nd9074 nd9075 2.698989100623e-01
RINT31010 nd9075 nd9076 2.698989100623e-01
RINT31011 nd9076 nd9077 2.698989100623e-01
RINT31012 nd9077 nd9078 2.698989100623e-01
RINT31013 nd9078 nd9079 2.698989100623e-01
RINT31014 nd9079 nd9080 2.698989100623e-01
RINT31015 nd9080 nd9081 2.698989100623e-01
RINT31016 nd9081 nd9082 2.698989100623e-01
RINT31017 nd9083 nd9084 2.493313941068e-01
RINT31018 nd9084 nd9085 2.266357619356e-01
RINT31019 nd9085 nd9086 7.660631014006e+00
RINT31020 nd9086 nd9087 7.790300106417e+00
RINT31021 nd9087 nd9088 4.778640357485e-01
RINT31022 nd9088 nd9089 4.697541247393e-01
RINT31023 nd9089 nd9090 2.520135011038e-01
RINT31024 nd9090 nd9091 1.199550711388e-01
RINT31025 nd9091 nd9092 1.627961679741e-01
RINT31026 nd9092 nd9093 1.199550711388e-01
RINT31027 nd9093 nd9094 1.199550711388e-01
RINT31028 nd9094 nd9095 1.199550711388e-01
RINT31029 nd9095 nd9096 1.199550711388e-01
RINT31030 nd9096 nd9097 1.199550711388e-01
RINT31031 nd9097 nd9098 1.199550711388e-01
RINT31032 nd9098 nd9099 3.298764456317e-01
RINT31033 nd9099 nd9100 5.397978201245e-01
RINT31034 nd9100 nd9101 2.924550963786e-01
RINT31035 nd9101 nd9102 2.188625263897e-01
RINT31036 nd9102 nd9103 3.794958474237e+00
RINT31037 nd9103 nd9104 3.733601589195e+00
RINT31038 nd9104 nd9105 2.698989100623e-01
RINT31039 nd9105 nd9106 2.698989100623e-01
RINT31040 nd9106 nd9107 2.698989100623e-01
RINT31041 nd9107 nd9108 2.698989100623e-01
RINT31042 nd9108 nd9109 2.698989100623e-01
RINT31043 nd9109 nd9110 2.698989100623e-01
RINT31044 nd9110 nd9111 2.698989100623e-01
RINT31045 nd9111 nd9112 2.698989100623e-01
RINT31046 nd9112 nd9113 2.698989100623e-01
RINT31047 nd9114 nd9115 2.493313941068e-01
RINT31048 nd9115 nd9116 2.266357619356e-01
RINT31049 nd9116 nd9117 7.660631014006e+00
RINT31050 nd9117 nd9118 7.790300106417e+00
RINT31051 nd9118 nd9119 4.778640357485e-01
RINT31052 nd9119 nd9120 4.697541247393e-01
RINT31053 nd9120 nd9121 2.520135011038e-01
RINT31054 nd9121 nd9122 1.199550711388e-01
RINT31055 nd9122 nd9123 1.627961679741e-01
RINT31056 nd9123 nd9124 1.199550711388e-01
RINT31057 nd9124 nd9125 1.199550711388e-01
RINT31058 nd9125 nd9126 1.199550711388e-01
RINT31059 nd9126 nd9127 1.199550711388e-01
RINT31060 nd9127 nd9128 1.199550711388e-01
RINT31061 nd9128 nd9129 1.199550711388e-01
RINT31062 nd9129 nd9130 3.298764456317e-01
RINT31063 nd9130 nd9131 5.397978201245e-01
RINT31064 nd9131 nd9132 2.924550963786e-01
RINT31065 nd9132 nd9133 2.188625263897e-01
RINT31066 nd9133 nd9134 3.794958474237e+00
RINT31067 nd9134 nd9135 3.733601589195e+00
RINT31068 nd9135 nd9136 2.698989100623e-01
RINT31069 nd9136 nd9137 2.698989100623e-01
RINT31070 nd9137 nd9138 2.698989100623e-01
RINT31071 nd9138 nd9139 2.698989100623e-01
RINT31072 nd9139 nd9140 2.698989100623e-01
RINT31073 nd9140 nd9141 2.698989100623e-01
RINT31074 nd9141 nd9142 2.698989100623e-01
RINT31075 nd9142 nd9143 2.698989100623e-01
RINT31076 nd9143 nd9144 2.698989100623e-01
RINT31077 nd9145 nd9146 2.493313941068e-01
RINT31078 nd9146 nd9147 2.266357619356e-01
RINT31079 nd9147 nd9148 7.660631014006e+00
RINT31080 nd9148 nd9149 7.790300106417e+00
RINT31081 nd9149 nd9150 4.778640357485e-01
RINT31082 nd9150 nd9151 4.697541247393e-01
RINT31083 nd9151 nd9152 2.520135011038e-01
RINT31084 nd9152 nd9153 1.199550711388e-01
RINT31085 nd9153 nd9154 1.627961679741e-01
RINT31086 nd9154 nd9155 1.199550711388e-01
RINT31087 nd9155 nd9156 1.199550711388e-01
RINT31088 nd9156 nd9157 1.199550711388e-01
RINT31089 nd9157 nd9158 1.199550711388e-01
RINT31090 nd9158 nd9159 1.199550711388e-01
RINT31091 nd9159 nd9160 1.199550711388e-01
RINT31092 nd9160 nd9161 3.298764456317e-01
RINT31093 nd9161 nd9162 5.397978201245e-01
RINT31094 nd9162 nd9163 2.924550963786e-01
RINT31095 nd9163 nd9164 2.188625263897e-01
RINT31096 nd9164 nd9165 3.794958474237e+00
RINT31097 nd9165 nd9166 3.733601589195e+00
RINT31098 nd9166 nd9167 2.698989100623e-01
RINT31099 nd9167 nd9168 2.698989100623e-01
RINT31100 nd9168 nd9169 2.698989100623e-01
RINT31101 nd9169 nd9170 2.698989100623e-01
RINT31102 nd9170 nd9171 2.698989100623e-01
RINT31103 nd9171 nd9172 2.698989100623e-01
RINT31104 nd9172 nd9173 2.698989100623e-01
RINT31105 nd9173 nd9174 2.698989100623e-01
RINT31106 nd9174 nd9175 2.698989100623e-01
RINT31107 nd9176 nd9177 2.493313941068e-01
RINT31108 nd9177 nd9178 2.266357619356e-01
RINT31109 nd9178 nd9179 7.660631014006e+00
RINT31110 nd9179 nd9180 7.790300106417e+00
RINT31111 nd9180 nd9181 4.778640357485e-01
RINT31112 nd9181 nd9182 4.697541247393e-01
RINT31113 nd9182 nd9183 2.520135011038e-01
RINT31114 nd9183 nd9184 1.199550711388e-01
RINT31115 nd9184 nd9185 1.627961679741e-01
RINT31116 nd9185 nd9186 1.199550711388e-01
RINT31117 nd9186 nd9187 1.199550711388e-01
RINT31118 nd9187 nd9188 1.199550711388e-01
RINT31119 nd9188 nd9189 1.199550711388e-01
RINT31120 nd9189 nd9190 1.199550711388e-01
RINT31121 nd9190 nd9191 1.199550711388e-01
RINT31122 nd9191 nd9192 3.298764456317e-01
RINT31123 nd9192 nd9193 5.397978201245e-01
RINT31124 nd9193 nd9194 2.924550963786e-01
RINT31125 nd9194 nd9195 2.188625263897e-01
RINT31126 nd9195 nd9196 3.794958474237e+00
RINT31127 nd9196 nd9197 3.733601589195e+00
RINT31128 nd9197 nd9198 2.698989100623e-01
RINT31129 nd9198 nd9199 2.698989100623e-01
RINT31130 nd9199 nd9200 2.698989100623e-01
RINT31131 nd9200 nd9201 2.698989100623e-01
RINT31132 nd9201 nd9202 2.698989100623e-01
RINT31133 nd9202 nd9203 2.698989100623e-01
RINT31134 nd9203 nd9204 2.698989100623e-01
RINT31135 nd9204 nd9205 2.698989100623e-01
RINT31136 nd9205 nd9206 2.698989100623e-01
RINT31137 nd9207 nd9208 1.832876633312e+00
RINT31138 nd9208 nd9209 1.666037258616e+00
RINT31139 nd9209 nd9210 5.631457535580e+01
RINT31140 nd9210 nd9211 5.726779446562e+01
RINT31141 nd9211 nd9212 3.512858170793e+00
RINT31142 nd9212 nd9213 3.453240863313e+00
RINT31143 nd9213 nd9214 9.993586560904e+00
RINT31144 nd9214 nd9215 5.786876290473e+01
RINT31145 nd9215 nd9216 7.853617822785e+01
RINT31146 nd9216 nd9217 5.786876290473e+01
RINT31147 nd9217 nd9218 5.786876290473e+01
RINT31148 nd9218 nd9219 5.786876290473e+01
RINT31149 nd9219 nd9220 5.786876290473e+01
RINT31150 nd9220 nd9221 5.786876290473e+01
RINT31151 nd9221 nd9222 5.786876290473e+01
RINT31152 nd9222 nd9223 1.591390979880e+02
RINT31153 nd9223 nd9224 2.604094330713e+02
RINT31154 nd9224 nd9225 1.303705308206e+02
RINT31155 nd9225 nd9226 1.608894908578e+00
RINT31156 nd9226 nd9227 2.789737223720e+01
RINT31157 nd9227 nd9228 2.744632754910e+01
RINT31158 nd9228 nd9229 1.984071871019e+00
RINT31159 nd9229 nd9230 1.984071871019e+00
RINT31160 nd9230 nd9231 1.984071871019e+00
RINT31161 nd9231 nd9232 1.984071871019e+00
RINT31162 nd9232 nd9233 1.984071871019e+00
RINT31163 nd9233 nd9234 1.984071871019e+00
RINT31164 nd9234 nd9235 1.984071871019e+00
RINT31165 nd9235 nd9236 1.984071871019e+00
RINT31166 nd9236 nd9237 1.984071871019e+00
RINT31167 nd9238 nd9239 1.914284617627e-01
RINT31168 nd9239 nd9240 1.740035002137e-01
RINT31169 nd9240 nd9241 5.881581083666e+00
RINT31170 nd9241 nd9242 5.981136757300e+00
RINT31171 nd9242 nd9243 3.668883239623e-01
RINT31172 nd9243 nd9244 3.606618004430e-01
RINT31173 nd9244 nd9245 1.976741618838e-01
RINT31174 nd9245 nd9246 8.656063970738e-02
RINT31175 nd9246 nd9247 1.760179307529e-01
RINT31176 nd9247 nd9248 2.136011054157e-01
RINT31177 nd9248 nd9249 2.136011054157e-01
RINT31178 nd9249 nd9250 2.136011054157e-01
RINT31179 nd9250 nd9251 2.136011054157e-01
RINT31180 nd9251 nd9252 2.136011054157e-01
RINT31181 nd9252 nd9253 2.136011054157e-01
RINT31182 nd9253 nd9254 2.884961700761e-01
RINT31183 nd9254 nd9255 4.298149835847e-01
RINT31184 nd9255 nd9256 2.654372658145e-01
RINT31185 nd9256 nd9257 1.680354650659e-01
RINT31186 nd9257 nd9258 2.913644572433e+00
RINT31187 nd9258 nd9259 2.866536769726e+00
RINT31188 nd9259 nd9260 2.072195255224e-01
RINT31189 nd9260 nd9261 2.072195255224e-01
RINT31190 nd9261 nd9262 2.072195255224e-01
RINT31191 nd9262 nd9263 2.072195255224e-01
RINT31192 nd9263 nd9264 2.072195255224e-01
RINT31193 nd9264 nd9265 2.072195255224e-01
RINT31194 nd9265 nd9266 2.072195255224e-01
RINT31195 nd9266 nd9267 2.072195255224e-01
RINT31196 nd9267 nd9268 2.072195255224e-01
RINT31197 nd9269 nd9270 1.914284617627e-01
RINT31198 nd9270 nd9271 1.740035002137e-01
RINT31199 nd9271 nd9272 5.881581083666e+00
RINT31200 nd9272 nd9273 5.981136757300e+00
RINT31201 nd9273 nd9274 3.668883239623e-01
RINT31202 nd9274 nd9275 3.606618004430e-01
RINT31203 nd9275 nd9276 1.976741618838e-01
RINT31204 nd9276 nd9277 8.656063970738e-02
RINT31205 nd9277 nd9278 1.760179307529e-01
RINT31206 nd9278 nd9279 2.136011054157e-01
RINT31207 nd9279 nd9280 2.136011054157e-01
RINT31208 nd9280 nd9281 2.136011054157e-01
RINT31209 nd9281 nd9282 2.136011054157e-01
RINT31210 nd9282 nd9283 2.136011054157e-01
RINT31211 nd9283 nd9284 2.136011054157e-01
RINT31212 nd9284 nd9285 2.884961700761e-01
RINT31213 nd9285 nd9286 4.298149835847e-01
RINT31214 nd9286 nd9287 2.654372658145e-01
RINT31215 nd9287 nd9288 1.680354650659e-01
RINT31216 nd9288 nd9289 2.913644572433e+00
RINT31217 nd9289 nd9290 2.866536769726e+00
RINT31218 nd9290 nd9291 2.072195255224e-01
RINT31219 nd9291 nd9292 2.072195255224e-01
RINT31220 nd9292 nd9293 2.072195255224e-01
RINT31221 nd9293 nd9294 2.072195255224e-01
RINT31222 nd9294 nd9295 2.072195255224e-01
RINT31223 nd9295 nd9296 2.072195255224e-01
RINT31224 nd9296 nd9297 2.072195255224e-01
RINT31225 nd9297 nd9298 2.072195255224e-01
RINT31226 nd9298 nd9299 2.072195255224e-01
RINT31227 nd9300 nd9301 1.914284617627e-01
RINT31228 nd9301 nd9302 1.740035002137e-01
RINT31229 nd9302 nd9303 5.881581083666e+00
RINT31230 nd9303 nd9304 5.981136757300e+00
RINT31231 nd9304 nd9305 3.668883239623e-01
RINT31232 nd9305 nd9306 3.606618004430e-01
RINT31233 nd9306 nd9307 1.976741618838e-01
RINT31234 nd9307 nd9308 8.656063970738e-02
RINT31235 nd9308 nd9309 1.760179307529e-01
RINT31236 nd9309 nd9310 2.136011054157e-01
RINT31237 nd9310 nd9311 2.136011054157e-01
RINT31238 nd9311 nd9312 2.136011054157e-01
RINT31239 nd9312 nd9313 2.136011054157e-01
RINT31240 nd9313 nd9314 2.136011054157e-01
RINT31241 nd9314 nd9315 2.136011054157e-01
RINT31242 nd9315 nd9316 2.884961700761e-01
RINT31243 nd9316 nd9317 4.298149835847e-01
RINT31244 nd9317 nd9318 2.654372658145e-01
RINT31245 nd9318 nd9319 1.680354650659e-01
RINT31246 nd9319 nd9320 2.913644572433e+00
RINT31247 nd9320 nd9321 2.866536769726e+00
RINT31248 nd9321 nd9322 2.072195255224e-01
RINT31249 nd9322 nd9323 2.072195255224e-01
RINT31250 nd9323 nd9324 2.072195255224e-01
RINT31251 nd9324 nd9325 2.072195255224e-01
RINT31252 nd9325 nd9326 2.072195255224e-01
RINT31253 nd9326 nd9327 2.072195255224e-01
RINT31254 nd9327 nd9328 2.072195255224e-01
RINT31255 nd9328 nd9329 2.072195255224e-01
RINT31256 nd9329 nd9330 2.072195255224e-01
RINT31257 nd9331 nd9332 1.914284617627e-01
RINT31258 nd9332 nd9333 1.740035002137e-01
RINT31259 nd9333 nd9334 5.881581083666e+00
RINT31260 nd9334 nd9335 5.981136757300e+00
RINT31261 nd9335 nd9336 3.668883239623e-01
RINT31262 nd9336 nd9337 3.606618004430e-01
RINT31263 nd9337 nd9338 1.976741618838e-01
RINT31264 nd9338 nd9339 8.656063970738e-02
RINT31265 nd9339 nd9340 1.760179307529e-01
RINT31266 nd9340 nd9341 2.136011054157e-01
RINT31267 nd9341 nd9342 2.136011054157e-01
RINT31268 nd9342 nd9343 2.136011054157e-01
RINT31269 nd9343 nd9344 2.136011054157e-01
RINT31270 nd9344 nd9345 2.136011054157e-01
RINT31271 nd9345 nd9346 2.136011054157e-01
RINT31272 nd9346 nd9347 2.884961700761e-01
RINT31273 nd9347 nd9348 4.298149835847e-01
RINT31274 nd9348 nd9349 2.654372658145e-01
RINT31275 nd9349 nd9350 1.680354650659e-01
RINT31276 nd9350 nd9351 2.913644572433e+00
RINT31277 nd9351 nd9352 2.866536769726e+00
RINT31278 nd9352 nd9353 2.072195255224e-01
RINT31279 nd9353 nd9354 2.072195255224e-01
RINT31280 nd9354 nd9355 2.072195255224e-01
RINT31281 nd9355 nd9356 2.072195255224e-01
RINT31282 nd9356 nd9357 2.072195255224e-01
RINT31283 nd9357 nd9358 2.072195255224e-01
RINT31284 nd9358 nd9359 2.072195255224e-01
RINT31285 nd9359 nd9360 2.072195255224e-01
RINT31286 nd9360 nd9361 2.072195255224e-01
RINT31287 nd9362 nd9363 1.914284617627e-01
RINT31288 nd9363 nd9364 1.740035002137e-01
RINT31289 nd9364 nd9365 5.881581083666e+00
RINT31290 nd9365 nd9366 5.981136757300e+00
RINT31291 nd9366 nd9367 3.668883239623e-01
RINT31292 nd9367 nd9368 3.606618004430e-01
RINT31293 nd9368 nd9369 1.976741618838e-01
RINT31294 nd9369 nd9370 8.656063970738e-02
RINT31295 nd9370 nd9371 1.760179307529e-01
RINT31296 nd9371 nd9372 2.136011054157e-01
RINT31297 nd9372 nd9373 2.136011054157e-01
RINT31298 nd9373 nd9374 2.136011054157e-01
RINT31299 nd9374 nd9375 2.136011054157e-01
RINT31300 nd9375 nd9376 2.136011054157e-01
RINT31301 nd9376 nd9377 2.136011054157e-01
RINT31302 nd9377 nd9378 2.884961700761e-01
RINT31303 nd9378 nd9379 4.298149835847e-01
RINT31304 nd9379 nd9380 2.654372658145e-01
RINT31305 nd9380 nd9381 1.680354650659e-01
RINT31306 nd9381 nd9382 2.913644572433e+00
RINT31307 nd9382 nd9383 2.866536769726e+00
RINT31308 nd9383 nd9384 2.072195255224e-01
RINT31309 nd9384 nd9385 2.072195255224e-01
RINT31310 nd9385 nd9386 2.072195255224e-01
RINT31311 nd9386 nd9387 2.072195255224e-01
RINT31312 nd9387 nd9388 2.072195255224e-01
RINT31313 nd9388 nd9389 2.072195255224e-01
RINT31314 nd9389 nd9390 2.072195255224e-01
RINT31315 nd9390 nd9391 2.072195255224e-01
RINT31316 nd9391 nd9392 2.072195255224e-01
RINT31317 nd9393 nd9394 1.914284617627e-01
RINT31318 nd9394 nd9395 1.740035002137e-01
RINT31319 nd9395 nd9396 5.881581083666e+00
RINT31320 nd9396 nd9397 5.981136757300e+00
RINT31321 nd9397 nd9398 3.668883239623e-01
RINT31322 nd9398 nd9399 3.606618004430e-01
RINT31323 nd9399 nd9400 1.976741618838e-01
RINT31324 nd9400 nd9401 8.656063970738e-02
RINT31325 nd9401 nd9402 1.760179307529e-01
RINT31326 nd9402 nd9403 2.136011054157e-01
RINT31327 nd9403 nd9404 2.136011054157e-01
RINT31328 nd9404 nd9405 2.136011054157e-01
RINT31329 nd9405 nd9406 2.136011054157e-01
RINT31330 nd9406 nd9407 2.136011054157e-01
RINT31331 nd9407 nd9408 2.136011054157e-01
RINT31332 nd9408 nd9409 2.884961700761e-01
RINT31333 nd9409 nd9410 4.298149835847e-01
RINT31334 nd9410 nd9411 2.654372658145e-01
RINT31335 nd9411 nd9412 1.680354650659e-01
RINT31336 nd9412 nd9413 2.913644572433e+00
RINT31337 nd9413 nd9414 2.866536769726e+00
RINT31338 nd9414 nd9415 2.072195255224e-01
RINT31339 nd9415 nd9416 2.072195255224e-01
RINT31340 nd9416 nd9417 2.072195255224e-01
RINT31341 nd9417 nd9418 2.072195255224e-01
RINT31342 nd9418 nd9419 2.072195255224e-01
RINT31343 nd9419 nd9420 2.072195255224e-01
RINT31344 nd9420 nd9421 2.072195255224e-01
RINT31345 nd9421 nd9422 2.072195255224e-01
RINT31346 nd9422 nd9423 2.072195255224e-01
RINT31347 nd9424 nd9425 1.832876633312e+00
RINT31348 nd9425 nd9426 1.666037258616e+00
RINT31349 nd9426 nd9427 5.631457535579e+01
RINT31350 nd9427 nd9428 5.726779446562e+01
RINT31351 nd9428 nd9429 3.512858170793e+00
RINT31352 nd9429 nd9430 3.453240863313e+00
RINT31353 nd9430 nd9431 9.993586560904e+00
RINT31354 nd9431 nd9432 5.786876290473e+01
RINT31355 nd9432 nd9433 7.853617822785e+01
RINT31356 nd9433 nd9434 5.786876290473e+01
RINT31357 nd9434 nd9435 5.786876290473e+01
RINT31358 nd9435 nd9436 5.786876290473e+01
RINT31359 nd9436 nd9437 5.786876290473e+01
RINT31360 nd9437 nd9438 5.786876290473e+01
RINT31361 nd9438 nd9439 5.786876290473e+01
RINT31362 nd9439 nd9440 1.591390979880e+02
RINT31363 nd9440 nd9441 2.604094330713e+02
RINT31364 nd9441 nd9442 1.303705308206e+02
RINT31365 nd9442 nd9443 1.608894908578e+00
RINT31366 nd9443 nd9444 2.789737223720e+01
RINT31367 nd9444 nd9445 2.744632754910e+01
RINT31368 nd9445 nd9446 1.984071871019e+00
RINT31369 nd9446 nd9447 1.984071871019e+00
RINT31370 nd9447 nd9448 1.984071871019e+00
RINT31371 nd9448 nd9449 1.984071871019e+00
RINT31372 nd9449 nd9450 1.984071871019e+00
RINT31373 nd9450 nd9451 1.984071871019e+00
RINT31374 nd9451 nd9452 1.984071871019e+00
RINT31375 nd9452 nd9453 1.984071871019e+00
RINT31376 nd9453 nd9454 1.984071871019e+00
RINT31377 nd9455 nd9456 1.914284617627e-01
RINT31378 nd9456 nd9457 1.740035002137e-01
RINT31379 nd9457 nd9458 5.881581083666e+00
RINT31380 nd9458 nd9459 5.981136757300e+00
RINT31381 nd9459 nd9460 3.668883239623e-01
RINT31382 nd9460 nd9461 3.606618004430e-01
RINT31383 nd9461 nd9462 1.976741618838e-01
RINT31384 nd9462 nd9463 8.656063970738e-02
RINT31385 nd9463 nd9464 1.760179307529e-01
RINT31386 nd9464 nd9465 2.136011054157e-01
RINT31387 nd9465 nd9466 2.136011054157e-01
RINT31388 nd9466 nd9467 2.136011054157e-01
RINT31389 nd9467 nd9468 2.136011054157e-01
RINT31390 nd9468 nd9469 2.136011054157e-01
RINT31391 nd9469 nd9470 2.136011054157e-01
RINT31392 nd9470 nd9471 2.884961700761e-01
RINT31393 nd9471 nd9472 4.298149835847e-01
RINT31394 nd9472 nd9473 2.654372658145e-01
RINT31395 nd9473 nd9474 1.680354650659e-01
RINT31396 nd9474 nd9475 2.913644572433e+00
RINT31397 nd9475 nd9476 2.866536769726e+00
RINT31398 nd9476 nd9477 2.072195255224e-01
RINT31399 nd9477 nd9478 2.072195255224e-01
RINT31400 nd9478 nd9479 2.072195255224e-01
RINT31401 nd9479 nd9480 2.072195255224e-01
RINT31402 nd9480 nd9481 2.072195255224e-01
RINT31403 nd9481 nd9482 2.072195255224e-01
RINT31404 nd9482 nd9483 2.072195255224e-01
RINT31405 nd9483 nd9484 2.072195255224e-01
RINT31406 nd9484 nd9485 2.072195255224e-01
RINT31407 nd9486 nd9487 1.914284617627e-01
RINT31408 nd9487 nd9488 1.740035002137e-01
RINT31409 nd9488 nd9489 5.881581083666e+00
RINT31410 nd9489 nd9490 5.981136757300e+00
RINT31411 nd9490 nd9491 3.668883239623e-01
RINT31412 nd9491 nd9492 3.606618004430e-01
RINT31413 nd9492 nd9493 1.976741618838e-01
RINT31414 nd9493 nd9494 8.656063970738e-02
RINT31415 nd9494 nd9495 1.760179307529e-01
RINT31416 nd9495 nd9496 2.136011054157e-01
RINT31417 nd9496 nd9497 2.136011054157e-01
RINT31418 nd9497 nd9498 2.136011054157e-01
RINT31419 nd9498 nd9499 2.136011054157e-01
RINT31420 nd9499 nd9500 2.136011054157e-01
RINT31421 nd9500 nd9501 2.136011054157e-01
RINT31422 nd9501 nd9502 2.884961700761e-01
RINT31423 nd9502 nd9503 4.298149835847e-01
RINT31424 nd9503 nd9504 2.654372658145e-01
RINT31425 nd9504 nd9505 1.680354650659e-01
RINT31426 nd9505 nd9506 2.913644572433e+00
RINT31427 nd9506 nd9507 2.866536769726e+00
RINT31428 nd9507 nd9508 2.072195255224e-01
RINT31429 nd9508 nd9509 2.072195255224e-01
RINT31430 nd9509 nd9510 2.072195255224e-01
RINT31431 nd9510 nd9511 2.072195255224e-01
RINT31432 nd9511 nd9512 2.072195255224e-01
RINT31433 nd9512 nd9513 2.072195255224e-01
RINT31434 nd9513 nd9514 2.072195255224e-01
RINT31435 nd9514 nd9515 2.072195255224e-01
RINT31436 nd9515 nd9516 2.072195255224e-01
RINT31437 nd9517 nd9518 1.914284617627e-01
RINT31438 nd9518 nd9519 1.740035002137e-01
RINT31439 nd9519 nd9520 5.881581083666e+00
RINT31440 nd9520 nd9521 5.981136757300e+00
RINT31441 nd9521 nd9522 3.668883239623e-01
RINT31442 nd9522 nd9523 3.606618004430e-01
RINT31443 nd9523 nd9524 1.976741618838e-01
RINT31444 nd9524 nd9525 8.656063970738e-02
RINT31445 nd9525 nd9526 1.760179307529e-01
RINT31446 nd9526 nd9527 2.136011054157e-01
RINT31447 nd9527 nd9528 2.136011054157e-01
RINT31448 nd9528 nd9529 2.136011054157e-01
RINT31449 nd9529 nd9530 2.136011054157e-01
RINT31450 nd9530 nd9531 2.136011054157e-01
RINT31451 nd9531 nd9532 2.136011054157e-01
RINT31452 nd9532 nd9533 2.884961700761e-01
RINT31453 nd9533 nd9534 4.298149835847e-01
RINT31454 nd9534 nd9535 2.654372658145e-01
RINT31455 nd9535 nd9536 1.680354650659e-01
RINT31456 nd9536 nd9537 2.913644572433e+00
RINT31457 nd9537 nd9538 2.866536769726e+00
RINT31458 nd9538 nd9539 2.072195255224e-01
RINT31459 nd9539 nd9540 2.072195255224e-01
RINT31460 nd9540 nd9541 2.072195255224e-01
RINT31461 nd9541 nd9542 2.072195255224e-01
RINT31462 nd9542 nd9543 2.072195255224e-01
RINT31463 nd9543 nd9544 2.072195255224e-01
RINT31464 nd9544 nd9545 2.072195255224e-01
RINT31465 nd9545 nd9546 2.072195255224e-01
RINT31466 nd9546 nd9547 2.072195255224e-01
RINT31467 nd9548 nd9549 1.914284617627e-01
RINT31468 nd9549 nd9550 1.740035002137e-01
RINT31469 nd9550 nd9551 5.881581083666e+00
RINT31470 nd9551 nd9552 5.981136757300e+00
RINT31471 nd9552 nd9553 3.668883239623e-01
RINT31472 nd9553 nd9554 3.606618004430e-01
RINT31473 nd9554 nd9555 1.976741618838e-01
RINT31474 nd9555 nd9556 8.656063970738e-02
RINT31475 nd9556 nd9557 1.760179307529e-01
RINT31476 nd9557 nd9558 2.136011054157e-01
RINT31477 nd9558 nd9559 2.136011054157e-01
RINT31478 nd9559 nd9560 2.136011054157e-01
RINT31479 nd9560 nd9561 2.136011054157e-01
RINT31480 nd9561 nd9562 2.136011054157e-01
RINT31481 nd9562 nd9563 2.136011054157e-01
RINT31482 nd9563 nd9564 2.884961700761e-01
RINT31483 nd9564 nd9565 4.298149835847e-01
RINT31484 nd9565 nd9566 2.654372658145e-01
RINT31485 nd9566 nd9567 1.680354650659e-01
RINT31486 nd9567 nd9568 2.913644572433e+00
RINT31487 nd9568 nd9569 2.866536769726e+00
RINT31488 nd9569 nd9570 2.072195255224e-01
RINT31489 nd9570 nd9571 2.072195255224e-01
RINT31490 nd9571 nd9572 2.072195255224e-01
RINT31491 nd9572 nd9573 2.072195255224e-01
RINT31492 nd9573 nd9574 2.072195255224e-01
RINT31493 nd9574 nd9575 2.072195255224e-01
RINT31494 nd9575 nd9576 2.072195255224e-01
RINT31495 nd9576 nd9577 2.072195255224e-01
RINT31496 nd9577 nd9578 2.072195255224e-01
RINT31497 nd9579 nd9580 1.914284617627e-01
RINT31498 nd9580 nd9581 1.740035002137e-01
RINT31499 nd9581 nd9582 5.881581083666e+00
RINT31500 nd9582 nd9583 5.981136757300e+00
RINT31501 nd9583 nd9584 3.668883239623e-01
RINT31502 nd9584 nd9585 3.606618004430e-01
RINT31503 nd9585 nd9586 1.976741618838e-01
RINT31504 nd9586 nd9587 8.656063970738e-02
RINT31505 nd9587 nd9588 1.760179307529e-01
RINT31506 nd9588 nd9589 2.136011054157e-01
RINT31507 nd9589 nd9590 2.136011054157e-01
RINT31508 nd9590 nd9591 2.136011054157e-01
RINT31509 nd9591 nd9592 2.136011054157e-01
RINT31510 nd9592 nd9593 2.136011054157e-01
RINT31511 nd9593 nd9594 2.136011054157e-01
RINT31512 nd9594 nd9595 2.884961700761e-01
RINT31513 nd9595 nd9596 4.298149835847e-01
RINT31514 nd9596 nd9597 2.654372658145e-01
RINT31515 nd9597 nd9598 1.680354650659e-01
RINT31516 nd9598 nd9599 2.913644572433e+00
RINT31517 nd9599 nd9600 2.866536769726e+00
RINT31518 nd9600 nd9601 2.072195255224e-01
RINT31519 nd9601 nd9602 2.072195255224e-01
RINT31520 nd9602 nd9603 2.072195255224e-01
RINT31521 nd9603 nd9604 2.072195255224e-01
RINT31522 nd9604 nd9605 2.072195255224e-01
RINT31523 nd9605 nd9606 2.072195255224e-01
RINT31524 nd9606 nd9607 2.072195255224e-01
RINT31525 nd9607 nd9608 2.072195255224e-01
RINT31526 nd9608 nd9609 2.072195255224e-01
RINT31527 nd9610 nd9611 1.914284617627e-01
RINT31528 nd9611 nd9612 1.740035002137e-01
RINT31529 nd9612 nd9613 5.881581083666e+00
RINT31530 nd9613 nd9614 5.981136757300e+00
RINT31531 nd9614 nd9615 3.668883239623e-01
RINT31532 nd9615 nd9616 3.606618004430e-01
RINT31533 nd9616 nd9617 1.976741618838e-01
RINT31534 nd9617 nd9618 8.656063970738e-02
RINT31535 nd9618 nd9619 1.760179307529e-01
RINT31536 nd9619 nd9620 2.136011054157e-01
RINT31537 nd9620 nd9621 2.136011054157e-01
RINT31538 nd9621 nd9622 2.136011054157e-01
RINT31539 nd9622 nd9623 2.136011054157e-01
RINT31540 nd9623 nd9624 2.136011054157e-01
RINT31541 nd9624 nd9625 2.136011054157e-01
RINT31542 nd9625 nd9626 2.884961700761e-01
RINT31543 nd9626 nd9627 4.298149835847e-01
RINT31544 nd9627 nd9628 2.654372658145e-01
RINT31545 nd9628 nd9629 1.680354650659e-01
RINT31546 nd9629 nd9630 2.913644572433e+00
RINT31547 nd9630 nd9631 2.866536769726e+00
RINT31548 nd9631 nd9632 2.072195255224e-01
RINT31549 nd9632 nd9633 2.072195255224e-01
RINT31550 nd9633 nd9634 2.072195255224e-01
RINT31551 nd9634 nd9635 2.072195255224e-01
RINT31552 nd9635 nd9636 2.072195255224e-01
RINT31553 nd9636 nd9637 2.072195255224e-01
RINT31554 nd9637 nd9638 2.072195255224e-01
RINT31555 nd9638 nd9639 2.072195255224e-01
RINT31556 nd9639 nd9640 2.072195255224e-01
RINT31557 nd9641 nd9642 1.832876633312e+00
RINT31558 nd9642 nd9643 1.666037258616e+00
RINT31559 nd9643 nd9644 5.631457535579e+01
RINT31560 nd9644 nd9645 5.726779446562e+01
RINT31561 nd9645 nd9646 3.512858170793e+00
RINT31562 nd9646 nd9647 3.453240863313e+00
RINT31563 nd9647 nd9648 9.993586560904e+00
RINT31564 nd9648 nd9649 5.786876290473e+01
RINT31565 nd9649 nd9650 7.853617822785e+01
RINT31566 nd9650 nd9651 5.786876290473e+01
RINT31567 nd9651 nd9652 5.786876290473e+01
RINT31568 nd9652 nd9653 5.786876290473e+01
RINT31569 nd9653 nd9654 5.786876290473e+01
RINT31570 nd9654 nd9655 5.786876290473e+01
RINT31571 nd9655 nd9656 5.786876290473e+01
RINT31572 nd9656 nd9657 1.591390979880e+02
RINT31573 nd9657 nd9658 2.604094330713e+02
RINT31574 nd9658 nd9659 1.303705308206e+02
RINT31575 nd9659 nd9660 1.608894908578e+00
RINT31576 nd9660 nd9661 2.789737223720e+01
RINT31577 nd9661 nd9662 2.744632754910e+01
RINT31578 nd9662 nd9663 1.984071871019e+00
RINT31579 nd9663 nd9664 1.984071871019e+00
RINT31580 nd9664 nd9665 1.984071871019e+00
RINT31581 nd9665 nd9666 1.984071871019e+00
RINT31582 nd9666 nd9667 1.984071871019e+00
RINT31583 nd9667 nd9668 1.984071871019e+00
RINT31584 nd9668 nd9669 1.984071871019e+00
RINT31585 nd9669 nd9670 1.984071871019e+00
RINT31586 nd9670 nd9671 1.984071871019e+00
RINT31587 nd9672 nd9673 2.493313941068e-01
RINT31588 nd9673 nd9674 2.266357619356e-01
RINT31589 nd9674 nd9675 7.660631014006e+00
RINT31590 nd9675 nd9676 7.790300106417e+00
RINT31591 nd9676 nd9677 4.778640357485e-01
RINT31592 nd9677 nd9678 4.697541247393e-01
RINT31593 nd9678 nd9679 2.520135011038e-01
RINT31594 nd9679 nd9680 1.199550711388e-01
RINT31595 nd9680 nd9681 1.627961679741e-01
RINT31596 nd9681 nd9682 1.199550711388e-01
RINT31597 nd9682 nd9683 1.199550711388e-01
RINT31598 nd9683 nd9684 1.199550711388e-01
RINT31599 nd9684 nd9685 1.199550711388e-01
RINT31600 nd9685 nd9686 1.199550711388e-01
RINT31601 nd9686 nd9687 1.199550711388e-01
RINT31602 nd9687 nd9688 3.298764456317e-01
RINT31603 nd9688 nd9689 5.397978201245e-01
RINT31604 nd9689 nd9690 2.924550963786e-01
RINT31605 nd9690 nd9691 2.188625263897e-01
RINT31606 nd9691 nd9692 3.794958474237e+00
RINT31607 nd9692 nd9693 3.733601589195e+00
RINT31608 nd9693 nd9694 2.698989100623e-01
RINT31609 nd9694 nd9695 2.698989100623e-01
RINT31610 nd9695 nd9696 2.698989100623e-01
RINT31611 nd9696 nd9697 2.698989100623e-01
RINT31612 nd9697 nd9698 2.698989100623e-01
RINT31613 nd9698 nd9699 2.698989100623e-01
RINT31614 nd9699 nd9700 2.698989100623e-01
RINT31615 nd9700 nd9701 2.698989100623e-01
RINT31616 nd9701 nd9702 2.698989100623e-01
RINT31617 nd9703 nd9704 2.493313941068e-01
RINT31618 nd9704 nd9705 2.266357619356e-01
RINT31619 nd9705 nd9706 7.660631014006e+00
RINT31620 nd9706 nd9707 7.790300106417e+00
RINT31621 nd9707 nd9708 4.778640357485e-01
RINT31622 nd9708 nd9709 4.697541247393e-01
RINT31623 nd9709 nd9710 2.520135011038e-01
RINT31624 nd9710 nd9711 1.199550711388e-01
RINT31625 nd9711 nd9712 1.627961679741e-01
RINT31626 nd9712 nd9713 1.199550711388e-01
RINT31627 nd9713 nd9714 1.199550711388e-01
RINT31628 nd9714 nd9715 1.199550711388e-01
RINT31629 nd9715 nd9716 1.199550711388e-01
RINT31630 nd9716 nd9717 1.199550711388e-01
RINT31631 nd9717 nd9718 1.199550711388e-01
RINT31632 nd9718 nd9719 3.298764456317e-01
RINT31633 nd9719 nd9720 5.397978201245e-01
RINT31634 nd9720 nd9721 2.924550963786e-01
RINT31635 nd9721 nd9722 2.188625263897e-01
RINT31636 nd9722 nd9723 3.794958474237e+00
RINT31637 nd9723 nd9724 3.733601589195e+00
RINT31638 nd9724 nd9725 2.698989100623e-01
RINT31639 nd9725 nd9726 2.698989100623e-01
RINT31640 nd9726 nd9727 2.698989100623e-01
RINT31641 nd9727 nd9728 2.698989100623e-01
RINT31642 nd9728 nd9729 2.698989100623e-01
RINT31643 nd9729 nd9730 2.698989100623e-01
RINT31644 nd9730 nd9731 2.698989100623e-01
RINT31645 nd9731 nd9732 2.698989100623e-01
RINT31646 nd9732 nd9733 2.698989100623e-01
RINT31647 nd9734 nd9735 2.493313941068e-01
RINT31648 nd9735 nd9736 2.266357619356e-01
RINT31649 nd9736 nd9737 7.660631014006e+00
RINT31650 nd9737 nd9738 7.790300106417e+00
RINT31651 nd9738 nd9739 4.778640357485e-01
RINT31652 nd9739 nd9740 4.697541247393e-01
RINT31653 nd9740 nd9741 2.520135011038e-01
RINT31654 nd9741 nd9742 1.199550711388e-01
RINT31655 nd9742 nd9743 1.627961679741e-01
RINT31656 nd9743 nd9744 1.199550711388e-01
RINT31657 nd9744 nd9745 1.199550711388e-01
RINT31658 nd9745 nd9746 1.199550711388e-01
RINT31659 nd9746 nd9747 1.199550711388e-01
RINT31660 nd9747 nd9748 1.199550711388e-01
RINT31661 nd9748 nd9749 1.199550711388e-01
RINT31662 nd9749 nd9750 3.298764456317e-01
RINT31663 nd9750 nd9751 5.397978201245e-01
RINT31664 nd9751 nd9752 2.924550963786e-01
RINT31665 nd9752 nd9753 2.188625263897e-01
RINT31666 nd9753 nd9754 3.794958474237e+00
RINT31667 nd9754 nd9755 3.733601589195e+00
RINT31668 nd9755 nd9756 2.698989100623e-01
RINT31669 nd9756 nd9757 2.698989100623e-01
RINT31670 nd9757 nd9758 2.698989100623e-01
RINT31671 nd9758 nd9759 2.698989100623e-01
RINT31672 nd9759 nd9760 2.698989100623e-01
RINT31673 nd9760 nd9761 2.698989100623e-01
RINT31674 nd9761 nd9762 2.698989100623e-01
RINT31675 nd9762 nd9763 2.698989100623e-01
RINT31676 nd9763 nd9764 2.698989100623e-01
RINT31677 nd9765 nd9766 2.493313941068e-01
RINT31678 nd9766 nd9767 2.266357619356e-01
RINT31679 nd9767 nd9768 7.660631014006e+00
RINT31680 nd9768 nd9769 7.790300106417e+00
RINT31681 nd9769 nd9770 4.778640357485e-01
RINT31682 nd9770 nd9771 4.697541247393e-01
RINT31683 nd9771 nd9772 2.520135011038e-01
RINT31684 nd9772 nd9773 1.199550711388e-01
RINT31685 nd9773 nd9774 1.627961679741e-01
RINT31686 nd9774 nd9775 1.199550711388e-01
RINT31687 nd9775 nd9776 1.199550711388e-01
RINT31688 nd9776 nd9777 1.199550711388e-01
RINT31689 nd9777 nd9778 1.199550711388e-01
RINT31690 nd9778 nd9779 1.199550711388e-01
RINT31691 nd9779 nd9780 1.199550711388e-01
RINT31692 nd9780 nd9781 3.298764456317e-01
RINT31693 nd9781 nd9782 5.397978201245e-01
RINT31694 nd9782 nd9783 2.924550963786e-01
RINT31695 nd9783 nd9784 2.188625263897e-01
RINT31696 nd9784 nd9785 3.794958474237e+00
RINT31697 nd9785 nd9786 3.733601589195e+00
RINT31698 nd9786 nd9787 2.698989100623e-01
RINT31699 nd9787 nd9788 2.698989100623e-01
RINT31700 nd9788 nd9789 2.698989100623e-01
RINT31701 nd9789 nd9790 2.698989100623e-01
RINT31702 nd9790 nd9791 2.698989100623e-01
RINT31703 nd9791 nd9792 2.698989100623e-01
RINT31704 nd9792 nd9793 2.698989100623e-01
RINT31705 nd9793 nd9794 2.698989100623e-01
RINT31706 nd9794 nd9795 2.698989100623e-01
RINT31707 nd9796 nd9797 2.493313941068e-01
RINT31708 nd9797 nd9798 2.266357619356e-01
RINT31709 nd9798 nd9799 7.660631014006e+00
RINT31710 nd9799 nd9800 7.790300106417e+00
RINT31711 nd9800 nd9801 4.778640357485e-01
RINT31712 nd9801 nd9802 4.697541247393e-01
RINT31713 nd9802 nd9803 2.520135011038e-01
RINT31714 nd9803 nd9804 1.199550711388e-01
RINT31715 nd9804 nd9805 1.627961679741e-01
RINT31716 nd9805 nd9806 1.199550711388e-01
RINT31717 nd9806 nd9807 1.199550711388e-01
RINT31718 nd9807 nd9808 1.199550711388e-01
RINT31719 nd9808 nd9809 1.199550711388e-01
RINT31720 nd9809 nd9810 1.199550711388e-01
RINT31721 nd9810 nd9811 1.199550711388e-01
RINT31722 nd9811 nd9812 3.298764456317e-01
RINT31723 nd9812 nd9813 5.397978201245e-01
RINT31724 nd9813 nd9814 2.924550963786e-01
RINT31725 nd9814 nd9815 2.188625263897e-01
RINT31726 nd9815 nd9816 3.794958474237e+00
RINT31727 nd9816 nd9817 3.733601589195e+00
RINT31728 nd9817 nd9818 2.698989100623e-01
RINT31729 nd9818 nd9819 2.698989100623e-01
RINT31730 nd9819 nd9820 2.698989100623e-01
RINT31731 nd9820 nd9821 2.698989100623e-01
RINT31732 nd9821 nd9822 2.698989100623e-01
RINT31733 nd9822 nd9823 2.698989100623e-01
RINT31734 nd9823 nd9824 2.698989100623e-01
RINT31735 nd9824 nd9825 2.698989100623e-01
RINT31736 nd9825 nd9826 2.698989100623e-01
RINT31737 nd9827 nd9828 2.493313941068e-01
RINT31738 nd9828 nd9829 2.266357619356e-01
RINT31739 nd9829 nd9830 7.660631014006e+00
RINT31740 nd9830 nd9831 7.790300106417e+00
RINT31741 nd9831 nd9832 4.778640357485e-01
RINT31742 nd9832 nd9833 4.697541247393e-01
RINT31743 nd9833 nd9834 2.520135011038e-01
RINT31744 nd9834 nd9835 1.199550711388e-01
RINT31745 nd9835 nd9836 1.627961679741e-01
RINT31746 nd9836 nd9837 1.199550711388e-01
RINT31747 nd9837 nd9838 1.199550711388e-01
RINT31748 nd9838 nd9839 1.199550711388e-01
RINT31749 nd9839 nd9840 1.199550711388e-01
RINT31750 nd9840 nd9841 1.199550711388e-01
RINT31751 nd9841 nd9842 1.199550711388e-01
RINT31752 nd9842 nd9843 3.298764456317e-01
RINT31753 nd9843 nd9844 5.397978201245e-01
RINT31754 nd9844 nd9845 2.924550963786e-01
RINT31755 nd9845 nd9846 2.188625263897e-01
RINT31756 nd9846 nd9847 3.794958474237e+00
RINT31757 nd9847 nd9848 3.733601589195e+00
RINT31758 nd9848 nd9849 2.698989100623e-01
RINT31759 nd9849 nd9850 2.698989100623e-01
RINT31760 nd9850 nd9851 2.698989100623e-01
RINT31761 nd9851 nd9852 2.698989100623e-01
RINT31762 nd9852 nd9853 2.698989100623e-01
RINT31763 nd9853 nd9854 2.698989100623e-01
RINT31764 nd9854 nd9855 2.698989100623e-01
RINT31765 nd9855 nd9856 2.698989100623e-01
RINT31766 nd9856 nd9857 2.698989100623e-01
RINT31767 nd9858 nd9859 1.832876633312e+00
RINT31768 nd9859 nd9860 1.666037258616e+00
RINT31769 nd9860 nd9861 5.631457535580e+01
RINT31770 nd9861 nd9862 5.726779446562e+01
RINT31771 nd9862 nd9863 3.512858170793e+00
RINT31772 nd9863 nd9864 3.453240863313e+00
RINT31773 nd9864 nd9865 9.993586560904e+00
RINT31774 nd9865 nd9866 5.786876290473e+01
RINT31775 nd9866 nd9867 7.853617822785e+01
RINT31776 nd9867 nd9868 5.786876290473e+01
RINT31777 nd9868 nd9869 5.786876290473e+01
RINT31778 nd9869 nd9870 5.786876290473e+01
RINT31779 nd9870 nd9871 5.786876290473e+01
RINT31780 nd9871 nd9872 5.786876290473e+01
RINT31781 nd9872 nd9873 5.786876290473e+01
RINT31782 nd9873 nd9874 1.591390979880e+02
RINT31783 nd9874 nd9875 2.604094330713e+02
RINT31784 nd9875 nd9876 1.303705308206e+02
RINT31785 nd9876 nd9877 1.608894908578e+00
RINT31786 nd9877 nd9878 2.789737223720e+01
RINT31787 nd9878 nd9879 2.744632754910e+01
RINT31788 nd9879 nd9880 1.984071871019e+00
RINT31789 nd9880 nd9881 1.984071871019e+00
RINT31790 nd9881 nd9882 1.984071871019e+00
RINT31791 nd9882 nd9883 1.984071871019e+00
RINT31792 nd9883 nd9884 1.984071871019e+00
RINT31793 nd9884 nd9885 1.984071871019e+00
RINT31794 nd9885 nd9886 1.984071871019e+00
RINT31795 nd9886 nd9887 1.984071871019e+00
RINT31796 nd9887 nd9888 1.984071871019e+00
RINT31797 nd9889 nd9890 1.914284617627e-01
RINT31798 nd9890 nd9891 1.740035002137e-01
RINT31799 nd9891 nd9892 5.881581083666e+00
RINT31800 nd9892 nd9893 5.981136757300e+00
RINT31801 nd9893 nd9894 3.668883239623e-01
RINT31802 nd9894 nd9895 3.606618004430e-01
RINT31803 nd9895 nd9896 1.976741618838e-01
RINT31804 nd9896 nd9897 8.656063970739e-02
RINT31805 nd9897 nd9898 1.760179307529e-01
RINT31806 nd9898 nd9899 2.136011054157e-01
RINT31807 nd9899 nd9900 2.136011054157e-01
RINT31808 nd9900 nd9901 2.136011054157e-01
RINT31809 nd9901 nd9902 2.136011054157e-01
RINT31810 nd9902 nd9903 2.136011054157e-01
RINT31811 nd9903 nd9904 2.136011054157e-01
RINT31812 nd9904 nd9905 2.884961700761e-01
RINT31813 nd9905 nd9906 4.298149835847e-01
RINT31814 nd9906 nd9907 2.654372658145e-01
RINT31815 nd9907 nd9908 1.680354650659e-01
RINT31816 nd9908 nd9909 2.913644572433e+00
RINT31817 nd9909 nd9910 2.866536769726e+00
RINT31818 nd9910 nd9911 2.072195255224e-01
RINT31819 nd9911 nd9912 2.072195255224e-01
RINT31820 nd9912 nd9913 2.072195255224e-01
RINT31821 nd9913 nd9914 2.072195255224e-01
RINT31822 nd9914 nd9915 2.072195255224e-01
RINT31823 nd9915 nd9916 2.072195255224e-01
RINT31824 nd9916 nd9917 2.072195255224e-01
RINT31825 nd9917 nd9918 2.072195255224e-01
RINT31826 nd9918 nd9919 2.072195255224e-01
RINT31827 nd9920 nd9921 1.914284617627e-01
RINT31828 nd9921 nd9922 1.740035002137e-01
RINT31829 nd9922 nd9923 5.881581083666e+00
RINT31830 nd9923 nd9924 5.981136757300e+00
RINT31831 nd9924 nd9925 3.668883239623e-01
RINT31832 nd9925 nd9926 3.606618004430e-01
RINT31833 nd9926 nd9927 1.976741618838e-01
RINT31834 nd9927 nd9928 8.656063970739e-02
RINT31835 nd9928 nd9929 1.760179307529e-01
RINT31836 nd9929 nd9930 2.136011054157e-01
RINT31837 nd9930 nd9931 2.136011054157e-01
RINT31838 nd9931 nd9932 2.136011054157e-01
RINT31839 nd9932 nd9933 2.136011054157e-01
RINT31840 nd9933 nd9934 2.136011054157e-01
RINT31841 nd9934 nd9935 2.136011054157e-01
RINT31842 nd9935 nd9936 2.884961700761e-01
RINT31843 nd9936 nd9937 4.298149835847e-01
RINT31844 nd9937 nd9938 2.654372658145e-01
RINT31845 nd9938 nd9939 1.680354650659e-01
RINT31846 nd9939 nd9940 2.913644572433e+00
RINT31847 nd9940 nd9941 2.866536769726e+00
RINT31848 nd9941 nd9942 2.072195255224e-01
RINT31849 nd9942 nd9943 2.072195255224e-01
RINT31850 nd9943 nd9944 2.072195255224e-01
RINT31851 nd9944 nd9945 2.072195255224e-01
RINT31852 nd9945 nd9946 2.072195255224e-01
RINT31853 nd9946 nd9947 2.072195255224e-01
RINT31854 nd9947 nd9948 2.072195255224e-01
RINT31855 nd9948 nd9949 2.072195255224e-01
RINT31856 nd9949 nd9950 2.072195255224e-01
RINT31857 nd9951 nd9952 1.914284617627e-01
RINT31858 nd9952 nd9953 1.740035002137e-01
RINT31859 nd9953 nd9954 5.881581083666e+00
RINT31860 nd9954 nd9955 5.981136757300e+00
RINT31861 nd9955 nd9956 3.668883239623e-01
RINT31862 nd9956 nd9957 3.606618004430e-01
RINT31863 nd9957 nd9958 1.976741618838e-01
RINT31864 nd9958 nd9959 8.656063970739e-02
RINT31865 nd9959 nd9960 1.760179307529e-01
RINT31866 nd9960 nd9961 2.136011054157e-01
RINT31867 nd9961 nd9962 2.136011054157e-01
RINT31868 nd9962 nd9963 2.136011054157e-01
RINT31869 nd9963 nd9964 2.136011054157e-01
RINT31870 nd9964 nd9965 2.136011054157e-01
RINT31871 nd9965 nd9966 2.136011054157e-01
RINT31872 nd9966 nd9967 2.884961700761e-01
RINT31873 nd9967 nd9968 4.298149835847e-01
RINT31874 nd9968 nd9969 2.654372658145e-01
RINT31875 nd9969 nd9970 1.680354650659e-01
RINT31876 nd9970 nd9971 2.913644572433e+00
RINT31877 nd9971 nd9972 2.866536769726e+00
RINT31878 nd9972 nd9973 2.072195255224e-01
RINT31879 nd9973 nd9974 2.072195255224e-01
RINT31880 nd9974 nd9975 2.072195255224e-01
RINT31881 nd9975 nd9976 2.072195255224e-01
RINT31882 nd9976 nd9977 2.072195255224e-01
RINT31883 nd9977 nd9978 2.072195255224e-01
RINT31884 nd9978 nd9979 2.072195255224e-01
RINT31885 nd9979 nd9980 2.072195255224e-01
RINT31886 nd9980 nd9981 2.072195255224e-01
RINT31887 nd9982 nd9983 1.914284617627e-01
RINT31888 nd9983 nd9984 1.740035002137e-01
RINT31889 nd9984 nd9985 5.881581083666e+00
RINT31890 nd9985 nd9986 5.981136757300e+00
RINT31891 nd9986 nd9987 3.668883239623e-01
RINT31892 nd9987 nd9988 3.606618004430e-01
RINT31893 nd9988 nd9989 1.976741618838e-01
RINT31894 nd9989 nd9990 8.656063970739e-02
RINT31895 nd9990 nd9991 1.760179307529e-01
RINT31896 nd9991 nd9992 2.136011054157e-01
RINT31897 nd9992 nd9993 2.136011054157e-01
RINT31898 nd9993 nd9994 2.136011054157e-01
RINT31899 nd9994 nd9995 2.136011054157e-01
RINT31900 nd9995 nd9996 2.136011054157e-01
RINT31901 nd9996 nd9997 2.136011054157e-01
RINT31902 nd9997 nd9998 2.884961700761e-01
RINT31903 nd9998 nd9999 4.298149835847e-01
RINT31904 nd9999 nd10000 2.654372658145e-01
RINT31905 nd10000 nd10001 1.680354650659e-01
RINT31906 nd10001 nd10002 2.913644572433e+00
RINT31907 nd10002 nd10003 2.866536769726e+00
RINT31908 nd10003 nd10004 2.072195255224e-01
RINT31909 nd10004 nd10005 2.072195255224e-01
RINT31910 nd10005 nd10006 2.072195255224e-01
RINT31911 nd10006 nd10007 2.072195255224e-01
RINT31912 nd10007 nd10008 2.072195255224e-01
RINT31913 nd10008 nd10009 2.072195255224e-01
RINT31914 nd10009 nd10010 2.072195255224e-01
RINT31915 nd10010 nd10011 2.072195255224e-01
RINT31916 nd10011 nd10012 2.072195255224e-01
RINT31917 nd10013 nd10014 1.914284617627e-01
RINT31918 nd10014 nd10015 1.740035002137e-01
RINT31919 nd10015 nd10016 5.881581083666e+00
RINT31920 nd10016 nd10017 5.981136757300e+00
RINT31921 nd10017 nd10018 3.668883239623e-01
RINT31922 nd10018 nd10019 3.606618004430e-01
RINT31923 nd10019 nd10020 1.976741618838e-01
RINT31924 nd10020 nd10021 8.656063970739e-02
RINT31925 nd10021 nd10022 1.760179307529e-01
RINT31926 nd10022 nd10023 2.136011054157e-01
RINT31927 nd10023 nd10024 2.136011054157e-01
RINT31928 nd10024 nd10025 2.136011054157e-01
RINT31929 nd10025 nd10026 2.136011054157e-01
RINT31930 nd10026 nd10027 2.136011054157e-01
RINT31931 nd10027 nd10028 2.136011054157e-01
RINT31932 nd10028 nd10029 2.884961700761e-01
RINT31933 nd10029 nd10030 4.298149835847e-01
RINT31934 nd10030 nd10031 2.654372658145e-01
RINT31935 nd10031 nd10032 1.680354650659e-01
RINT31936 nd10032 nd10033 2.913644572433e+00
RINT31937 nd10033 nd10034 2.866536769726e+00
RINT31938 nd10034 nd10035 2.072195255224e-01
RINT31939 nd10035 nd10036 2.072195255224e-01
RINT31940 nd10036 nd10037 2.072195255224e-01
RINT31941 nd10037 nd10038 2.072195255224e-01
RINT31942 nd10038 nd10039 2.072195255224e-01
RINT31943 nd10039 nd10040 2.072195255224e-01
RINT31944 nd10040 nd10041 2.072195255224e-01
RINT31945 nd10041 nd10042 2.072195255224e-01
RINT31946 nd10042 nd10043 2.072195255224e-01
RINT31947 nd10044 nd10045 1.914284617627e-01
RINT31948 nd10045 nd10046 1.740035002137e-01
RINT31949 nd10046 nd10047 5.881581083666e+00
RINT31950 nd10047 nd10048 5.981136757300e+00
RINT31951 nd10048 nd10049 3.668883239623e-01
RINT31952 nd10049 nd10050 3.606618004430e-01
RINT31953 nd10050 nd10051 1.976741618838e-01
RINT31954 nd10051 nd10052 8.656063970739e-02
RINT31955 nd10052 nd10053 1.760179307529e-01
RINT31956 nd10053 nd10054 2.136011054157e-01
RINT31957 nd10054 nd10055 2.136011054157e-01
RINT31958 nd10055 nd10056 2.136011054157e-01
RINT31959 nd10056 nd10057 2.136011054157e-01
RINT31960 nd10057 nd10058 2.136011054157e-01
RINT31961 nd10058 nd10059 2.136011054157e-01
RINT31962 nd10059 nd10060 2.884961700761e-01
RINT31963 nd10060 nd10061 4.298149835847e-01
RINT31964 nd10061 nd10062 2.654372658145e-01
RINT31965 nd10062 nd10063 1.680354650659e-01
RINT31966 nd10063 nd10064 2.913644572433e+00
RINT31967 nd10064 nd10065 2.866536769726e+00
RINT31968 nd10065 nd10066 2.072195255224e-01
RINT31969 nd10066 nd10067 2.072195255224e-01
RINT31970 nd10067 nd10068 2.072195255224e-01
RINT31971 nd10068 nd10069 2.072195255224e-01
RINT31972 nd10069 nd10070 2.072195255224e-01
RINT31973 nd10070 nd10071 2.072195255224e-01
RINT31974 nd10071 nd10072 2.072195255224e-01
RINT31975 nd10072 nd10073 2.072195255224e-01
RINT31976 nd10073 nd10074 2.072195255224e-01
RINT31977 nd10075 nd10076 1.832876633312e+00
RINT31978 nd10076 nd10077 1.666037258616e+00
RINT31979 nd10077 nd10078 5.631457535579e+01
RINT31980 nd10078 nd10079 5.726779446562e+01
RINT31981 nd10079 nd10080 3.512858170793e+00
RINT31982 nd10080 nd10081 3.453240863313e+00
RINT31983 nd10081 nd10082 9.993586560904e+00
RINT31984 nd10082 nd10083 5.786876290473e+01
RINT31985 nd10083 nd10084 7.853617822785e+01
RINT31986 nd10084 nd10085 5.786876290473e+01
RINT31987 nd10085 nd10086 5.786876290473e+01
RINT31988 nd10086 nd10087 5.786876290473e+01
RINT31989 nd10087 nd10088 5.786876290473e+01
RINT31990 nd10088 nd10089 5.786876290473e+01
RINT31991 nd10089 nd10090 5.786876290473e+01
RINT31992 nd10090 nd10091 1.591390979880e+02
RINT31993 nd10091 nd10092 2.604094330713e+02
RINT31994 nd10092 nd10093 1.303705308206e+02
RINT31995 nd10093 nd10094 1.608894908578e+00
RINT31996 nd10094 nd10095 2.789737223720e+01
RINT31997 nd10095 nd10096 2.744632754910e+01
RINT31998 nd10096 nd10097 1.984071871019e+00
RINT31999 nd10097 nd10098 1.984071871019e+00
RINT32000 nd10098 nd10099 1.984071871019e+00
RINT32001 nd10099 nd10100 1.984071871019e+00
RINT32002 nd10100 nd10101 1.984071871019e+00
RINT32003 nd10101 nd10102 1.984071871019e+00
RINT32004 nd10102 nd10103 1.984071871019e+00
RINT32005 nd10103 nd10104 1.984071871019e+00
RINT32006 nd10104 nd10105 1.984071871019e+00
RINT32007 nd10106 nd10107 1.914284617627e-01
RINT32008 nd10107 nd10108 1.740035002137e-01
RINT32009 nd10108 nd10109 5.881581083666e+00
RINT32010 nd10109 nd10110 5.981136757300e+00
RINT32011 nd10110 nd10111 3.668883239623e-01
RINT32012 nd10111 nd10112 3.606618004430e-01
RINT32013 nd10112 nd10113 1.976741618838e-01
RINT32014 nd10113 nd10114 8.656063970739e-02
RINT32015 nd10114 nd10115 1.760179307529e-01
RINT32016 nd10115 nd10116 2.136011054157e-01
RINT32017 nd10116 nd10117 2.136011054157e-01
RINT32018 nd10117 nd10118 2.136011054157e-01
RINT32019 nd10118 nd10119 2.136011054157e-01
RINT32020 nd10119 nd10120 2.136011054157e-01
RINT32021 nd10120 nd10121 2.136011054157e-01
RINT32022 nd10121 nd10122 2.884961700761e-01
RINT32023 nd10122 nd10123 4.298149835847e-01
RINT32024 nd10123 nd10124 2.654372658145e-01
RINT32025 nd10124 nd10125 1.680354650659e-01
RINT32026 nd10125 nd10126 2.913644572433e+00
RINT32027 nd10126 nd10127 2.866536769726e+00
RINT32028 nd10127 nd10128 2.072195255224e-01
RINT32029 nd10128 nd10129 2.072195255224e-01
RINT32030 nd10129 nd10130 2.072195255224e-01
RINT32031 nd10130 nd10131 2.072195255224e-01
RINT32032 nd10131 nd10132 2.072195255224e-01
RINT32033 nd10132 nd10133 2.072195255224e-01
RINT32034 nd10133 nd10134 2.072195255224e-01
RINT32035 nd10134 nd10135 2.072195255224e-01
RINT32036 nd10135 nd10136 2.072195255224e-01
RINT32037 nd10137 nd10138 1.914284617627e-01
RINT32038 nd10138 nd10139 1.740035002137e-01
RINT32039 nd10139 nd10140 5.881581083666e+00
RINT32040 nd10140 nd10141 5.981136757300e+00
RINT32041 nd10141 nd10142 3.668883239623e-01
RINT32042 nd10142 nd10143 3.606618004430e-01
RINT32043 nd10143 nd10144 1.976741618838e-01
RINT32044 nd10144 nd10145 8.656063970738e-02
RINT32045 nd10145 nd10146 1.760179307529e-01
RINT32046 nd10146 nd10147 2.136011054157e-01
RINT32047 nd10147 nd10148 2.136011054157e-01
RINT32048 nd10148 nd10149 2.136011054157e-01
RINT32049 nd10149 nd10150 2.136011054157e-01
RINT32050 nd10150 nd10151 2.136011054157e-01
RINT32051 nd10151 nd10152 2.136011054157e-01
RINT32052 nd10152 nd10153 2.884961700761e-01
RINT32053 nd10153 nd10154 4.298149835847e-01
RINT32054 nd10154 nd10155 2.654372658145e-01
RINT32055 nd10155 nd10156 1.680354650659e-01
RINT32056 nd10156 nd10157 2.913644572433e+00
RINT32057 nd10157 nd10158 2.866536769726e+00
RINT32058 nd10158 nd10159 2.072195255224e-01
RINT32059 nd10159 nd10160 2.072195255224e-01
RINT32060 nd10160 nd10161 2.072195255224e-01
RINT32061 nd10161 nd10162 2.072195255224e-01
RINT32062 nd10162 nd10163 2.072195255224e-01
RINT32063 nd10163 nd10164 2.072195255224e-01
RINT32064 nd10164 nd10165 2.072195255224e-01
RINT32065 nd10165 nd10166 2.072195255224e-01
RINT32066 nd10166 nd10167 2.072195255224e-01
RINT32067 nd10168 nd10169 1.914284617627e-01
RINT32068 nd10169 nd10170 1.740035002137e-01
RINT32069 nd10170 nd10171 5.881581083666e+00
RINT32070 nd10171 nd10172 5.981136757300e+00
RINT32071 nd10172 nd10173 3.668883239623e-01
RINT32072 nd10173 nd10174 3.606618004430e-01
RINT32073 nd10174 nd10175 1.976741618838e-01
RINT32074 nd10175 nd10176 8.656063970739e-02
RINT32075 nd10176 nd10177 1.760179307529e-01
RINT32076 nd10177 nd10178 2.136011054157e-01
RINT32077 nd10178 nd10179 2.136011054157e-01
RINT32078 nd10179 nd10180 2.136011054157e-01
RINT32079 nd10180 nd10181 2.136011054157e-01
RINT32080 nd10181 nd10182 2.136011054157e-01
RINT32081 nd10182 nd10183 2.136011054157e-01
RINT32082 nd10183 nd10184 2.884961700761e-01
RINT32083 nd10184 nd10185 4.298149835847e-01
RINT32084 nd10185 nd10186 2.654372658145e-01
RINT32085 nd10186 nd10187 1.680354650659e-01
RINT32086 nd10187 nd10188 2.913644572433e+00
RINT32087 nd10188 nd10189 2.866536769726e+00
RINT32088 nd10189 nd10190 2.072195255224e-01
RINT32089 nd10190 nd10191 2.072195255224e-01
RINT32090 nd10191 nd10192 2.072195255224e-01
RINT32091 nd10192 nd10193 2.072195255224e-01
RINT32092 nd10193 nd10194 2.072195255224e-01
RINT32093 nd10194 nd10195 2.072195255224e-01
RINT32094 nd10195 nd10196 2.072195255224e-01
RINT32095 nd10196 nd10197 2.072195255224e-01
RINT32096 nd10197 nd10198 2.072195255224e-01
RINT32097 nd10199 nd10200 1.914284617627e-01
RINT32098 nd10200 nd10201 1.740035002137e-01
RINT32099 nd10201 nd10202 5.881581083666e+00
RINT32100 nd10202 nd10203 5.981136757300e+00
RINT32101 nd10203 nd10204 3.668883239623e-01
RINT32102 nd10204 nd10205 3.606618004430e-01
RINT32103 nd10205 nd10206 1.976741618838e-01
RINT32104 nd10206 nd10207 8.656063970739e-02
RINT32105 nd10207 nd10208 1.760179307529e-01
RINT32106 nd10208 nd10209 2.136011054157e-01
RINT32107 nd10209 nd10210 2.136011054157e-01
RINT32108 nd10210 nd10211 2.136011054157e-01
RINT32109 nd10211 nd10212 2.136011054157e-01
RINT32110 nd10212 nd10213 2.136011054157e-01
RINT32111 nd10213 nd10214 2.136011054157e-01
RINT32112 nd10214 nd10215 2.884961700761e-01
RINT32113 nd10215 nd10216 4.298149835847e-01
RINT32114 nd10216 nd10217 2.654372658145e-01
RINT32115 nd10217 nd10218 1.680354650659e-01
RINT32116 nd10218 nd10219 2.913644572433e+00
RINT32117 nd10219 nd10220 2.866536769726e+00
RINT32118 nd10220 nd10221 2.072195255224e-01
RINT32119 nd10221 nd10222 2.072195255224e-01
RINT32120 nd10222 nd10223 2.072195255224e-01
RINT32121 nd10223 nd10224 2.072195255224e-01
RINT32122 nd10224 nd10225 2.072195255224e-01
RINT32123 nd10225 nd10226 2.072195255224e-01
RINT32124 nd10226 nd10227 2.072195255224e-01
RINT32125 nd10227 nd10228 2.072195255224e-01
RINT32126 nd10228 nd10229 2.072195255224e-01
RINT32127 nd10230 nd10231 1.914284617627e-01
RINT32128 nd10231 nd10232 1.740035002137e-01
RINT32129 nd10232 nd10233 5.881581083666e+00
RINT32130 nd10233 nd10234 5.981136757300e+00
RINT32131 nd10234 nd10235 3.668883239623e-01
RINT32132 nd10235 nd10236 3.606618004430e-01
RINT32133 nd10236 nd10237 1.976741618838e-01
RINT32134 nd10237 nd10238 8.656063970738e-02
RINT32135 nd10238 nd10239 1.760179307529e-01
RINT32136 nd10239 nd10240 2.136011054157e-01
RINT32137 nd10240 nd10241 2.136011054157e-01
RINT32138 nd10241 nd10242 2.136011054157e-01
RINT32139 nd10242 nd10243 2.136011054157e-01
RINT32140 nd10243 nd10244 2.136011054157e-01
RINT32141 nd10244 nd10245 2.136011054157e-01
RINT32142 nd10245 nd10246 2.884961700761e-01
RINT32143 nd10246 nd10247 4.298149835847e-01
RINT32144 nd10247 nd10248 2.654372658145e-01
RINT32145 nd10248 nd10249 1.680354650659e-01
RINT32146 nd10249 nd10250 2.913644572433e+00
RINT32147 nd10250 nd10251 2.866536769726e+00
RINT32148 nd10251 nd10252 2.072195255224e-01
RINT32149 nd10252 nd10253 2.072195255224e-01
RINT32150 nd10253 nd10254 2.072195255224e-01
RINT32151 nd10254 nd10255 2.072195255224e-01
RINT32152 nd10255 nd10256 2.072195255224e-01
RINT32153 nd10256 nd10257 2.072195255224e-01
RINT32154 nd10257 nd10258 2.072195255224e-01
RINT32155 nd10258 nd10259 2.072195255224e-01
RINT32156 nd10259 nd10260 2.072195255224e-01
RINT32157 nd10261 nd10262 1.914284617627e-01
RINT32158 nd10262 nd10263 1.740035002137e-01
RINT32159 nd10263 nd10264 5.881581083666e+00
RINT32160 nd10264 nd10265 5.981136757300e+00
RINT32161 nd10265 nd10266 3.668883239623e-01
RINT32162 nd10266 nd10267 3.606618004430e-01
RINT32163 nd10267 nd10268 1.976741618838e-01
RINT32164 nd10268 nd10269 8.656063970739e-02
RINT32165 nd10269 nd10270 1.760179307529e-01
RINT32166 nd10270 nd10271 2.136011054157e-01
RINT32167 nd10271 nd10272 2.136011054157e-01
RINT32168 nd10272 nd10273 2.136011054157e-01
RINT32169 nd10273 nd10274 2.136011054157e-01
RINT32170 nd10274 nd10275 2.136011054157e-01
RINT32171 nd10275 nd10276 2.136011054157e-01
RINT32172 nd10276 nd10277 2.884961700761e-01
RINT32173 nd10277 nd10278 4.298149835847e-01
RINT32174 nd10278 nd10279 2.654372658145e-01
RINT32175 nd10279 nd10280 1.680354650659e-01
RINT32176 nd10280 nd10281 2.913644572433e+00
RINT32177 nd10281 nd10282 2.866536769726e+00
RINT32178 nd10282 nd10283 2.072195255224e-01
RINT32179 nd10283 nd10284 2.072195255224e-01
RINT32180 nd10284 nd10285 2.072195255224e-01
RINT32181 nd10285 nd10286 2.072195255224e-01
RINT32182 nd10286 nd10287 2.072195255224e-01
RINT32183 nd10287 nd10288 2.072195255224e-01
RINT32184 nd10288 nd10289 2.072195255224e-01
RINT32185 nd10289 nd10290 2.072195255224e-01
RINT32186 nd10290 nd10291 2.072195255224e-01
RINT32187 nd10292 nd10293 1.832876633312e+00
RINT32188 nd10293 nd10294 1.666037258616e+00
RINT32189 nd10294 nd10295 5.631457535579e+01
RINT32190 nd10295 nd10296 5.726779446562e+01
RINT32191 nd10296 nd10297 3.512858170793e+00
RINT32192 nd10297 nd10298 3.453240863313e+00
RINT32193 nd10298 nd10299 9.993586560904e+00
RINT32194 nd10299 nd10300 5.786876290473e+01
RINT32195 nd10300 nd10301 7.853617822785e+01
RINT32196 nd10301 nd10302 5.786876290473e+01
RINT32197 nd10302 nd10303 5.786876290473e+01
RINT32198 nd10303 nd10304 5.786876290473e+01
RINT32199 nd10304 nd10305 5.786876290473e+01
RINT32200 nd10305 nd10306 5.786876290473e+01
RINT32201 nd10306 nd10307 5.786876290473e+01
RINT32202 nd10307 nd10308 1.591390979880e+02
RINT32203 nd10308 nd10309 2.604094330713e+02
RINT32204 nd10309 nd10310 1.303705308206e+02
RINT32205 nd10310 nd10311 1.608894908578e+00
RINT32206 nd10311 nd10312 2.789737223720e+01
RINT32207 nd10312 nd10313 2.744632754910e+01
RINT32208 nd10313 nd10314 1.984071871019e+00
RINT32209 nd10314 nd10315 1.984071871019e+00
RINT32210 nd10315 nd10316 1.984071871019e+00
RINT32211 nd10316 nd10317 1.984071871019e+00
RINT32212 nd10317 nd10318 1.984071871019e+00
RINT32213 nd10318 nd10319 1.984071871019e+00
RINT32214 nd10319 nd10320 1.984071871019e+00
RINT32215 nd10320 nd10321 1.984071871019e+00
RINT32216 nd10321 nd10322 1.984071871019e+00
RINT32217 nd10323 nd10324 2.493313941068e-01
RINT32218 nd10324 nd10325 2.266357619356e-01
RINT32219 nd10325 nd10326 7.660631014006e+00
RINT32220 nd10326 nd10327 7.790300106417e+00
RINT32221 nd10327 nd10328 4.778640357485e-01
RINT32222 nd10328 nd10329 4.697541247393e-01
RINT32223 nd10329 nd10330 2.520135011038e-01
RINT32224 nd10330 nd10331 1.199550711388e-01
RINT32225 nd10331 nd10332 1.627961679741e-01
RINT32226 nd10332 nd10333 1.199550711388e-01
RINT32227 nd10333 nd10334 1.199550711388e-01
RINT32228 nd10334 nd10335 1.199550711388e-01
RINT32229 nd10335 nd10336 1.199550711388e-01
RINT32230 nd10336 nd10337 1.199550711388e-01
RINT32231 nd10337 nd10338 1.199550711388e-01
RINT32232 nd10338 nd10339 3.298764456317e-01
RINT32233 nd10339 nd10340 5.397978201245e-01
RINT32234 nd10340 nd10341 2.924550963786e-01
RINT32235 nd10341 nd10342 2.188625263897e-01
RINT32236 nd10342 nd10343 3.794958474237e+00
RINT32237 nd10343 nd10344 3.733601589195e+00
RINT32238 nd10344 nd10345 2.698989100623e-01
RINT32239 nd10345 nd10346 2.698989100623e-01
RINT32240 nd10346 nd10347 2.698989100623e-01
RINT32241 nd10347 nd10348 2.698989100623e-01
RINT32242 nd10348 nd10349 2.698989100623e-01
RINT32243 nd10349 nd10350 2.698989100623e-01
RINT32244 nd10350 nd10351 2.698989100623e-01
RINT32245 nd10351 nd10352 2.698989100623e-01
RINT32246 nd10352 nd10353 2.698989100623e-01
RINT32247 nd10354 nd10355 2.493313941068e-01
RINT32248 nd10355 nd10356 2.266357619356e-01
RINT32249 nd10356 nd10357 7.660631014006e+00
RINT32250 nd10357 nd10358 7.790300106417e+00
RINT32251 nd10358 nd10359 4.778640357485e-01
RINT32252 nd10359 nd10360 4.697541247393e-01
RINT32253 nd10360 nd10361 2.520135011038e-01
RINT32254 nd10361 nd10362 1.199550711388e-01
RINT32255 nd10362 nd10363 1.627961679741e-01
RINT32256 nd10363 nd10364 1.199550711388e-01
RINT32257 nd10364 nd10365 1.199550711388e-01
RINT32258 nd10365 nd10366 1.199550711388e-01
RINT32259 nd10366 nd10367 1.199550711388e-01
RINT32260 nd10367 nd10368 1.199550711388e-01
RINT32261 nd10368 nd10369 1.199550711388e-01
RINT32262 nd10369 nd10370 3.298764456317e-01
RINT32263 nd10370 nd10371 5.397978201245e-01
RINT32264 nd10371 nd10372 2.924550963786e-01
RINT32265 nd10372 nd10373 2.188625263897e-01
RINT32266 nd10373 nd10374 3.794958474237e+00
RINT32267 nd10374 nd10375 3.733601589195e+00
RINT32268 nd10375 nd10376 2.698989100623e-01
RINT32269 nd10376 nd10377 2.698989100623e-01
RINT32270 nd10377 nd10378 2.698989100623e-01
RINT32271 nd10378 nd10379 2.698989100623e-01
RINT32272 nd10379 nd10380 2.698989100623e-01
RINT32273 nd10380 nd10381 2.698989100623e-01
RINT32274 nd10381 nd10382 2.698989100623e-01
RINT32275 nd10382 nd10383 2.698989100623e-01
RINT32276 nd10383 nd10384 2.698989100623e-01
RINT32277 nd10385 nd10386 2.493313941068e-01
RINT32278 nd10386 nd10387 2.266357619356e-01
RINT32279 nd10387 nd10388 7.660631014006e+00
RINT32280 nd10388 nd10389 7.790300106417e+00
RINT32281 nd10389 nd10390 4.778640357485e-01
RINT32282 nd10390 nd10391 4.697541247393e-01
RINT32283 nd10391 nd10392 2.520135011038e-01
RINT32284 nd10392 nd10393 1.199550711388e-01
RINT32285 nd10393 nd10394 1.627961679741e-01
RINT32286 nd10394 nd10395 1.199550711388e-01
RINT32287 nd10395 nd10396 1.199550711388e-01
RINT32288 nd10396 nd10397 1.199550711388e-01
RINT32289 nd10397 nd10398 1.199550711388e-01
RINT32290 nd10398 nd10399 1.199550711388e-01
RINT32291 nd10399 nd10400 1.199550711388e-01
RINT32292 nd10400 nd10401 3.298764456317e-01
RINT32293 nd10401 nd10402 5.397978201245e-01
RINT32294 nd10402 nd10403 2.924550963786e-01
RINT32295 nd10403 nd10404 2.188625263897e-01
RINT32296 nd10404 nd10405 3.794958474237e+00
RINT32297 nd10405 nd10406 3.733601589195e+00
RINT32298 nd10406 nd10407 2.698989100623e-01
RINT32299 nd10407 nd10408 2.698989100623e-01
RINT32300 nd10408 nd10409 2.698989100623e-01
RINT32301 nd10409 nd10410 2.698989100623e-01
RINT32302 nd10410 nd10411 2.698989100623e-01
RINT32303 nd10411 nd10412 2.698989100623e-01
RINT32304 nd10412 nd10413 2.698989100623e-01
RINT32305 nd10413 nd10414 2.698989100623e-01
RINT32306 nd10414 nd10415 2.698989100623e-01
RINT32307 nd10416 nd10417 2.356247123801e+00
RINT32308 nd10417 nd10418 2.141767442179e+00
RINT32309 nd10418 nd10419 7.239497399800e+01
RINT32310 nd10419 nd10420 7.362038095942e+01
RINT32311 nd10420 nd10421 4.515940577133e+00
RINT32312 nd10421 nd10422 4.439299789244e+00
RINT32313 nd10422 nd10423 2.381593738975e+00
RINT32314 nd10423 nd10424 1.133606910468e+00
RINT32315 nd10424 nd10425 1.538466521349e+00
RINT32316 nd10425 nd10426 1.133606910468e+00
RINT32317 nd10426 nd10427 1.133606910468e+00
RINT32318 nd10427 nd10428 1.133606910468e+00
RINT32319 nd10428 nd10429 1.133606910468e+00
RINT32320 nd10429 nd10430 1.133606910468e+00
RINT32321 nd10430 nd10431 1.133606910468e+00
RINT32322 nd10431 nd10432 3.117419003786e+00
RINT32323 nd10432 nd10433 5.101231097105e+00
RINT32324 nd10433 nd10434 2.763777430240e+00
RINT32325 nd10434 nd10435 2.068308325796e+00
RINT32326 nd10435 nd10436 3.586335375814e+01
RINT32327 nd10436 nd10437 3.528351508831e+01
RINT32328 nd10437 nd10438 2.550615548552e+00
RINT32329 nd10438 nd10439 2.550615548552e+00
RINT32330 nd10439 nd10440 2.550615548552e+00
RINT32331 nd10440 nd10441 2.550615548552e+00
RINT32332 nd10441 nd10442 2.550615548552e+00
RINT32333 nd10442 nd10443 2.550615548552e+00
RINT32334 nd10443 nd10444 2.550615548552e+00
RINT32335 nd10444 nd10445 2.550615548552e+00
RINT32336 nd10445 nd10446 2.550615548552e+00
RINT32337 nd10447 nd10448 2.356247123801e+00
RINT32338 nd10448 nd10449 2.141767442179e+00
RINT32339 nd10449 nd10450 7.239497399800e+01
RINT32340 nd10450 nd10451 7.362038095942e+01
RINT32341 nd10451 nd10452 4.515940577133e+00
RINT32342 nd10452 nd10453 4.439299789244e+00
RINT32343 nd10453 nd10454 2.381593738975e+00
RINT32344 nd10454 nd10455 1.133606910468e+00
RINT32345 nd10455 nd10456 1.538466521349e+00
RINT32346 nd10456 nd10457 1.133606910468e+00
RINT32347 nd10457 nd10458 1.133606910468e+00
RINT32348 nd10458 nd10459 1.133606910468e+00
RINT32349 nd10459 nd10460 1.133606910468e+00
RINT32350 nd10460 nd10461 1.133606910468e+00
RINT32351 nd10461 nd10462 1.133606910468e+00
RINT32352 nd10462 nd10463 3.117419003786e+00
RINT32353 nd10463 nd10464 5.101231097105e+00
RINT32354 nd10464 nd10465 2.763777430240e+00
RINT32355 nd10465 nd10466 2.068308325796e+00
RINT32356 nd10466 nd10467 3.586335375814e+01
RINT32357 nd10467 nd10468 3.528351508831e+01
RINT32358 nd10468 nd10469 2.550615548552e+00
RINT32359 nd10469 nd10470 2.550615548552e+00
RINT32360 nd10470 nd10471 2.550615548552e+00
RINT32361 nd10471 nd10472 2.550615548552e+00
RINT32362 nd10472 nd10473 2.550615548552e+00
RINT32363 nd10473 nd10474 2.550615548552e+00
RINT32364 nd10474 nd10475 2.550615548552e+00
RINT32365 nd10475 nd10476 2.550615548552e+00
RINT32366 nd10476 nd10477 2.550615548552e+00
RINT32367 nd10478 nd10479 2.356247123801e+00
RINT32368 nd10479 nd10480 2.141767442179e+00
RINT32369 nd10480 nd10481 7.239497399800e+01
RINT32370 nd10481 nd10482 7.362038095942e+01
RINT32371 nd10482 nd10483 4.515940577133e+00
RINT32372 nd10483 nd10484 4.439299789244e+00
RINT32373 nd10484 nd10485 2.381593738975e+00
RINT32374 nd10485 nd10486 1.133606910468e+00
RINT32375 nd10486 nd10487 1.538466521349e+00
RINT32376 nd10487 nd10488 1.133606910468e+00
RINT32377 nd10488 nd10489 1.133606910468e+00
RINT32378 nd10489 nd10490 1.133606910468e+00
RINT32379 nd10490 nd10491 1.133606910468e+00
RINT32380 nd10491 nd10492 1.133606910468e+00
RINT32381 nd10492 nd10493 1.133606910468e+00
RINT32382 nd10493 nd10494 3.117419003786e+00
RINT32383 nd10494 nd10495 5.101231097105e+00
RINT32384 nd10495 nd10496 2.763777430240e+00
RINT32385 nd10496 nd10497 2.068308325796e+00
RINT32386 nd10497 nd10498 3.586335375814e+01
RINT32387 nd10498 nd10499 3.528351508831e+01
RINT32388 nd10499 nd10500 2.550615548552e+00
RINT32389 nd10500 nd10501 2.550615548552e+00
RINT32390 nd10501 nd10502 2.550615548552e+00
RINT32391 nd10502 nd10503 2.550615548552e+00
RINT32392 nd10503 nd10504 2.550615548552e+00
RINT32393 nd10504 nd10505 2.550615548552e+00
RINT32394 nd10505 nd10506 2.550615548552e+00
RINT32395 nd10506 nd10507 2.550615548552e+00
RINT32396 nd10507 nd10508 2.550615548552e+00
RINT32397 nd10509 nd10510 1.732116531491e+01
RINT32398 nd10510 nd10511 1.574448942870e+01
RINT32399 nd10511 nd10512 5.321875196883e+02
RINT32400 nd10512 nd10513 5.411956904962e+02
RINT32401 nd10513 nd10514 3.319743183927e+01
RINT32402 nd10514 nd10515 3.263403263403e+01
RINT32403 nd10515 nd10516 9.444201631702e+01
RINT32404 nd10516 nd10517 5.468750000000e+02
RINT32405 nd10517 nd10518 7.421875000000e+02
RINT32406 nd10518 nd10519 5.468750000000e+02
RINT32407 nd10519 nd10520 5.468750000000e+02
RINT32408 nd10520 nd10521 5.468750000000e+02
RINT32409 nd10521 nd10522 5.468750000000e+02
RINT32410 nd10522 nd10523 5.468750000000e+02
RINT32411 nd10523 nd10524 5.468750000000e+02
RINT32412 nd10524 nd10525 1.503906250000e+03
RINT32413 nd10525 nd10526 2.460937500000e+03
RINT32414 nd10526 nd10527 1.232035738519e+03
RINT32415 nd10527 nd10528 1.520447922098e+01
RINT32416 nd10528 nd10529 2.636374907017e+02
RINT32417 nd10529 nd10530 2.593750000000e+02
RINT32418 nd10530 nd10531 1.875000000000e+01
RINT32419 nd10531 nd10532 1.875000000000e+01
RINT32420 nd10532 nd10533 1.875000000000e+01
RINT32421 nd10533 nd10534 1.875000000000e+01
RINT32422 nd10534 nd10535 1.875000000000e+01
RINT32423 nd10535 nd10536 1.875000000000e+01
RINT32424 nd10536 nd10537 1.875000000000e+01
RINT32425 nd10537 nd10538 1.875000000000e+01
RINT32426 nd10538 nd10539 1.875000000000e+01
RINT32427 nd10540 nd10541 1.809049213629e+00
RINT32428 nd10541 nd10542 1.644378752938e+00
RINT32429 nd10542 nd10543 5.558248515568e+01
RINT32430 nd10543 nd10544 5.652331240488e+01
RINT32431 nd10544 nd10545 3.467190969629e+00
RINT32432 nd10545 nd10546 3.408348687909e+00
RINT32433 nd10546 nd10547 9.863669807754e+00
RINT32434 nd10547 nd10548 5.711646824659e+01
RINT32435 nd10548 nd10549 7.751520690609e+01
RINT32436 nd10549 nd10550 5.711646824659e+01
RINT32437 nd10550 nd10551 5.711646824659e+01
RINT32438 nd10551 nd10552 5.711646824659e+01
RINT32439 nd10552 nd10553 5.711646824659e+01
RINT32440 nd10553 nd10554 5.711646824659e+01
RINT32441 nd10554 nd10555 5.711646824659e+01
RINT32442 nd10555 nd10556 1.570702876781e+02
RINT32443 nd10556 nd10557 2.570241071097e+02
RINT32444 nd10557 nd10558 1.286757122520e+02
RINT32445 nd10558 nd10559 1.587979254183e+00
RINT32446 nd10559 nd10560 2.753470604119e+01
RINT32447 nd10560 nd10561 2.708952493981e+01
RINT32448 nd10561 nd10562 1.958278911312e+00
RINT32449 nd10562 nd10563 1.958278911312e+00
RINT32450 nd10563 nd10564 1.958278911312e+00
RINT32451 nd10564 nd10565 1.958278911312e+00
RINT32452 nd10565 nd10566 1.958278911312e+00
RINT32453 nd10566 nd10567 1.958278911312e+00
RINT32454 nd10567 nd10568 1.958278911312e+00
RINT32455 nd10568 nd10569 1.958278911312e+00
RINT32456 nd10569 nd10570 1.958278911312e+00
RINT32457 nd10571 nd10572 1.809049213629e+00
RINT32458 nd10572 nd10573 1.644378752938e+00
RINT32459 nd10573 nd10574 5.558248515568e+01
RINT32460 nd10574 nd10575 5.652331240488e+01
RINT32461 nd10575 nd10576 3.467190969629e+00
RINT32462 nd10576 nd10577 3.408348687909e+00
RINT32463 nd10577 nd10578 9.863669807754e+00
RINT32464 nd10578 nd10579 5.711646824659e+01
RINT32465 nd10579 nd10580 7.751520690609e+01
RINT32466 nd10580 nd10581 5.711646824659e+01
RINT32467 nd10581 nd10582 5.711646824659e+01
RINT32468 nd10582 nd10583 5.711646824659e+01
RINT32469 nd10583 nd10584 5.711646824659e+01
RINT32470 nd10584 nd10585 5.711646824659e+01
RINT32471 nd10585 nd10586 5.711646824659e+01
RINT32472 nd10586 nd10587 1.570702876781e+02
RINT32473 nd10587 nd10588 2.570241071097e+02
RINT32474 nd10588 nd10589 1.286757122520e+02
RINT32475 nd10589 nd10590 1.587979254183e+00
RINT32476 nd10590 nd10591 2.753470604119e+01
RINT32477 nd10591 nd10592 2.708952493981e+01
RINT32478 nd10592 nd10593 1.958278911312e+00
RINT32479 nd10593 nd10594 1.958278911312e+00
RINT32480 nd10594 nd10595 1.958278911312e+00
RINT32481 nd10595 nd10596 1.958278911312e+00
RINT32482 nd10596 nd10597 1.958278911312e+00
RINT32483 nd10597 nd10598 1.958278911312e+00
RINT32484 nd10598 nd10599 1.958278911312e+00
RINT32485 nd10599 nd10600 1.958278911312e+00
RINT32486 nd10600 nd10601 1.958278911312e+00
RINT32487 nd10602 nd10603 1.809049213629e+00
RINT32488 nd10603 nd10604 1.644378752938e+00
RINT32489 nd10604 nd10605 5.558248515568e+01
RINT32490 nd10605 nd10606 5.652331240488e+01
RINT32491 nd10606 nd10607 3.467190969629e+00
RINT32492 nd10607 nd10608 3.408348687909e+00
RINT32493 nd10608 nd10609 9.863669807754e+00
RINT32494 nd10609 nd10610 5.711646824659e+01
RINT32495 nd10610 nd10611 7.751520690609e+01
RINT32496 nd10611 nd10612 5.711646824659e+01
RINT32497 nd10612 nd10613 5.711646824659e+01
RINT32498 nd10613 nd10614 5.711646824659e+01
RINT32499 nd10614 nd10615 5.711646824659e+01
RINT32500 nd10615 nd10616 5.711646824659e+01
RINT32501 nd10616 nd10617 5.711646824659e+01
RINT32502 nd10617 nd10618 1.570702876781e+02
RINT32503 nd10618 nd10619 2.570241071097e+02
RINT32504 nd10619 nd10620 1.286757122520e+02
RINT32505 nd10620 nd10621 1.587979254183e+00
RINT32506 nd10621 nd10622 2.753470604119e+01
RINT32507 nd10622 nd10623 2.708952493981e+01
RINT32508 nd10623 nd10624 1.958278911312e+00
RINT32509 nd10624 nd10625 1.958278911312e+00
RINT32510 nd10625 nd10626 1.958278911312e+00
RINT32511 nd10626 nd10627 1.958278911312e+00
RINT32512 nd10627 nd10628 1.958278911312e+00
RINT32513 nd10628 nd10629 1.958278911312e+00
RINT32514 nd10629 nd10630 1.958278911312e+00
RINT32515 nd10630 nd10631 1.958278911312e+00
RINT32516 nd10631 nd10632 1.958278911312e+00
RINT32517 nd10633 nd10634 1.809049213629e+00
RINT32518 nd10634 nd10635 1.644378752938e+00
RINT32519 nd10635 nd10636 5.558248515568e+01
RINT32520 nd10636 nd10637 5.652331240488e+01
RINT32521 nd10637 nd10638 3.467190969629e+00
RINT32522 nd10638 nd10639 3.408348687909e+00
RINT32523 nd10639 nd10640 9.863669807754e+00
RINT32524 nd10640 nd10641 5.711646824659e+01
RINT32525 nd10641 nd10642 7.751520690609e+01
RINT32526 nd10642 nd10643 5.711646824659e+01
RINT32527 nd10643 nd10644 5.711646824659e+01
RINT32528 nd10644 nd10645 5.711646824659e+01
RINT32529 nd10645 nd10646 5.711646824659e+01
RINT32530 nd10646 nd10647 5.711646824659e+01
RINT32531 nd10647 nd10648 5.711646824659e+01
RINT32532 nd10648 nd10649 1.570702876781e+02
RINT32533 nd10649 nd10650 2.570241071097e+02
RINT32534 nd10650 nd10651 1.286757122520e+02
RINT32535 nd10651 nd10652 1.587979254183e+00
RINT32536 nd10652 nd10653 2.753470604119e+01
RINT32537 nd10653 nd10654 2.708952493981e+01
RINT32538 nd10654 nd10655 1.958278911312e+00
RINT32539 nd10655 nd10656 1.958278911312e+00
RINT32540 nd10656 nd10657 1.958278911312e+00
RINT32541 nd10657 nd10658 1.958278911312e+00
RINT32542 nd10658 nd10659 1.958278911312e+00
RINT32543 nd10659 nd10660 1.958278911312e+00
RINT32544 nd10660 nd10661 1.958278911312e+00
RINT32545 nd10661 nd10662 1.958278911312e+00
RINT32546 nd10662 nd10663 1.958278911312e+00
RINT32547 nd10664 nd10665 1.809049213629e+00
RINT32548 nd10665 nd10666 1.644378752938e+00
RINT32549 nd10666 nd10667 5.558248515568e+01
RINT32550 nd10667 nd10668 5.652331240488e+01
RINT32551 nd10668 nd10669 3.467190969629e+00
RINT32552 nd10669 nd10670 3.408348687909e+00
RINT32553 nd10670 nd10671 9.863669807754e+00
RINT32554 nd10671 nd10672 5.711646824659e+01
RINT32555 nd10672 nd10673 7.751520690609e+01
RINT32556 nd10673 nd10674 5.711646824659e+01
RINT32557 nd10674 nd10675 5.711646824659e+01
RINT32558 nd10675 nd10676 5.711646824659e+01
RINT32559 nd10676 nd10677 5.711646824659e+01
RINT32560 nd10677 nd10678 5.711646824659e+01
RINT32561 nd10678 nd10679 5.711646824659e+01
RINT32562 nd10679 nd10680 1.570702876781e+02
RINT32563 nd10680 nd10681 2.570241071097e+02
RINT32564 nd10681 nd10682 1.286757122520e+02
RINT32565 nd10682 nd10683 1.587979254183e+00
RINT32566 nd10683 nd10684 2.753470604119e+01
RINT32567 nd10684 nd10685 2.708952493981e+01
RINT32568 nd10685 nd10686 1.958278911312e+00
RINT32569 nd10686 nd10687 1.958278911312e+00
RINT32570 nd10687 nd10688 1.958278911312e+00
RINT32571 nd10688 nd10689 1.958278911312e+00
RINT32572 nd10689 nd10690 1.958278911312e+00
RINT32573 nd10690 nd10691 1.958278911312e+00
RINT32574 nd10691 nd10692 1.958278911312e+00
RINT32575 nd10692 nd10693 1.958278911312e+00
RINT32576 nd10693 nd10694 1.958278911312e+00
RINT32577 nd10695 nd10696 1.809049213629e+00
RINT32578 nd10696 nd10697 1.644378752938e+00
RINT32579 nd10697 nd10698 5.558248515568e+01
RINT32580 nd10698 nd10699 5.652331240488e+01
RINT32581 nd10699 nd10700 3.467190969629e+00
RINT32582 nd10700 nd10701 3.408348687909e+00
RINT32583 nd10701 nd10702 9.863669807754e+00
RINT32584 nd10702 nd10703 5.711646824659e+01
RINT32585 nd10703 nd10704 7.751520690609e+01
RINT32586 nd10704 nd10705 5.711646824659e+01
RINT32587 nd10705 nd10706 5.711646824659e+01
RINT32588 nd10706 nd10707 5.711646824659e+01
RINT32589 nd10707 nd10708 5.711646824659e+01
RINT32590 nd10708 nd10709 5.711646824659e+01
RINT32591 nd10709 nd10710 5.711646824659e+01
RINT32592 nd10710 nd10711 1.570702876781e+02
RINT32593 nd10711 nd10712 2.570241071097e+02
RINT32594 nd10712 nd10713 1.286757122520e+02
RINT32595 nd10713 nd10714 1.587979254183e+00
RINT32596 nd10714 nd10715 2.753470604119e+01
RINT32597 nd10715 nd10716 2.708952493981e+01
RINT32598 nd10716 nd10717 1.958278911312e+00
RINT32599 nd10717 nd10718 1.958278911312e+00
RINT32600 nd10718 nd10719 1.958278911312e+00
RINT32601 nd10719 nd10720 1.958278911312e+00
RINT32602 nd10720 nd10721 1.958278911312e+00
RINT32603 nd10721 nd10722 1.958278911312e+00
RINT32604 nd10722 nd10723 1.958278911312e+00
RINT32605 nd10723 nd10724 1.958278911312e+00
RINT32606 nd10724 nd10725 1.958278911312e+00
RINT32607 nd10726 nd10727 1.732116531491e+01
RINT32608 nd10727 nd10728 1.574448942870e+01
RINT32609 nd10728 nd10729 5.321875196883e+02
RINT32610 nd10729 nd10730 5.411956904962e+02
RINT32611 nd10730 nd10731 3.319743183927e+01
RINT32612 nd10731 nd10732 3.263403263403e+01
RINT32613 nd10732 nd10733 9.444201631702e+01
RINT32614 nd10733 nd10734 5.468750000000e+02
RINT32615 nd10734 nd10735 7.421875000000e+02
RINT32616 nd10735 nd10736 5.468750000000e+02
RINT32617 nd10736 nd10737 5.468750000000e+02
RINT32618 nd10737 nd10738 5.468750000000e+02
RINT32619 nd10738 nd10739 5.468750000000e+02
RINT32620 nd10739 nd10740 5.468750000000e+02
RINT32621 nd10740 nd10741 5.468750000000e+02
RINT32622 nd10741 nd10742 1.503906250000e+03
RINT32623 nd10742 nd10743 2.460937500000e+03
RINT32624 nd10743 nd10744 1.232035738519e+03
RINT32625 nd10744 nd10745 1.520447922098e+01
RINT32626 nd10745 nd10746 2.636374907017e+02
RINT32627 nd10746 nd10747 2.593750000000e+02
RINT32628 nd10747 nd10748 1.875000000000e+01
RINT32629 nd10748 nd10749 1.875000000000e+01
RINT32630 nd10749 nd10750 1.875000000000e+01
RINT32631 nd10750 nd10751 1.875000000000e+01
RINT32632 nd10751 nd10752 1.875000000000e+01
RINT32633 nd10752 nd10753 1.875000000000e+01
RINT32634 nd10753 nd10754 1.875000000000e+01
RINT32635 nd10754 nd10755 1.875000000000e+01
RINT32636 nd10755 nd10756 1.875000000000e+01
RINT32637 nd10757 nd10758 1.809049213629e+00
RINT32638 nd10758 nd10759 1.644378752938e+00
RINT32639 nd10759 nd10760 5.558248515568e+01
RINT32640 nd10760 nd10761 5.652331240488e+01
RINT32641 nd10761 nd10762 3.467190969629e+00
RINT32642 nd10762 nd10763 3.408348687909e+00
RINT32643 nd10763 nd10764 9.863669807754e+00
RINT32644 nd10764 nd10765 5.711646824659e+01
RINT32645 nd10765 nd10766 7.751520690609e+01
RINT32646 nd10766 nd10767 5.711646824659e+01
RINT32647 nd10767 nd10768 5.711646824659e+01
RINT32648 nd10768 nd10769 5.711646824659e+01
RINT32649 nd10769 nd10770 5.711646824659e+01
RINT32650 nd10770 nd10771 5.711646824659e+01
RINT32651 nd10771 nd10772 5.711646824659e+01
RINT32652 nd10772 nd10773 1.570702876781e+02
RINT32653 nd10773 nd10774 2.570241071097e+02
RINT32654 nd10774 nd10775 1.286757122520e+02
RINT32655 nd10775 nd10776 1.587979254183e+00
RINT32656 nd10776 nd10777 2.753470604119e+01
RINT32657 nd10777 nd10778 2.708952493981e+01
RINT32658 nd10778 nd10779 1.958278911312e+00
RINT32659 nd10779 nd10780 1.958278911312e+00
RINT32660 nd10780 nd10781 1.958278911312e+00
RINT32661 nd10781 nd10782 1.958278911312e+00
RINT32662 nd10782 nd10783 1.958278911312e+00
RINT32663 nd10783 nd10784 1.958278911312e+00
RINT32664 nd10784 nd10785 1.958278911312e+00
RINT32665 nd10785 nd10786 1.958278911312e+00
RINT32666 nd10786 nd10787 1.958278911312e+00
RINT32667 nd10788 nd10789 1.809049213629e+00
RINT32668 nd10789 nd10790 1.644378752938e+00
RINT32669 nd10790 nd10791 5.558248515568e+01
RINT32670 nd10791 nd10792 5.652331240488e+01
RINT32671 nd10792 nd10793 3.467190969629e+00
RINT32672 nd10793 nd10794 3.408348687909e+00
RINT32673 nd10794 nd10795 9.863669807754e+00
RINT32674 nd10795 nd10796 5.711646824659e+01
RINT32675 nd10796 nd10797 7.751520690609e+01
RINT32676 nd10797 nd10798 5.711646824659e+01
RINT32677 nd10798 nd10799 5.711646824659e+01
RINT32678 nd10799 nd10800 5.711646824659e+01
RINT32679 nd10800 nd10801 5.711646824659e+01
RINT32680 nd10801 nd10802 5.711646824659e+01
RINT32681 nd10802 nd10803 5.711646824659e+01
RINT32682 nd10803 nd10804 1.570702876781e+02
RINT32683 nd10804 nd10805 2.570241071097e+02
RINT32684 nd10805 nd10806 1.286757122520e+02
RINT32685 nd10806 nd10807 1.587979254183e+00
RINT32686 nd10807 nd10808 2.753470604119e+01
RINT32687 nd10808 nd10809 2.708952493981e+01
RINT32688 nd10809 nd10810 1.958278911312e+00
RINT32689 nd10810 nd10811 1.958278911312e+00
RINT32690 nd10811 nd10812 1.958278911312e+00
RINT32691 nd10812 nd10813 1.958278911312e+00
RINT32692 nd10813 nd10814 1.958278911312e+00
RINT32693 nd10814 nd10815 1.958278911312e+00
RINT32694 nd10815 nd10816 1.958278911312e+00
RINT32695 nd10816 nd10817 1.958278911312e+00
RINT32696 nd10817 nd10818 1.958278911312e+00
RINT32697 nd10819 nd10820 1.809049213629e+00
RINT32698 nd10820 nd10821 1.644378752938e+00
RINT32699 nd10821 nd10822 5.558248515568e+01
RINT32700 nd10822 nd10823 5.652331240488e+01
RINT32701 nd10823 nd10824 3.467190969629e+00
RINT32702 nd10824 nd10825 3.408348687909e+00
RINT32703 nd10825 nd10826 9.863669807754e+00
RINT32704 nd10826 nd10827 5.711646824659e+01
RINT32705 nd10827 nd10828 7.751520690609e+01
RINT32706 nd10828 nd10829 5.711646824659e+01
RINT32707 nd10829 nd10830 5.711646824659e+01
RINT32708 nd10830 nd10831 5.711646824659e+01
RINT32709 nd10831 nd10832 5.711646824659e+01
RINT32710 nd10832 nd10833 5.711646824659e+01
RINT32711 nd10833 nd10834 5.711646824659e+01
RINT32712 nd10834 nd10835 1.570702876781e+02
RINT32713 nd10835 nd10836 2.570241071097e+02
RINT32714 nd10836 nd10837 1.286757122520e+02
RINT32715 nd10837 nd10838 1.587979254183e+00
RINT32716 nd10838 nd10839 2.753470604119e+01
RINT32717 nd10839 nd10840 2.708952493981e+01
RINT32718 nd10840 nd10841 1.958278911312e+00
RINT32719 nd10841 nd10842 1.958278911312e+00
RINT32720 nd10842 nd10843 1.958278911312e+00
RINT32721 nd10843 nd10844 1.958278911312e+00
RINT32722 nd10844 nd10845 1.958278911312e+00
RINT32723 nd10845 nd10846 1.958278911312e+00
RINT32724 nd10846 nd10847 1.958278911312e+00
RINT32725 nd10847 nd10848 1.958278911312e+00
RINT32726 nd10848 nd10849 1.958278911312e+00
RINT32727 nd10850 nd10851 1.809049213629e+00
RINT32728 nd10851 nd10852 1.644378752938e+00
RINT32729 nd10852 nd10853 5.558248515568e+01
RINT32730 nd10853 nd10854 5.652331240488e+01
RINT32731 nd10854 nd10855 3.467190969629e+00
RINT32732 nd10855 nd10856 3.408348687909e+00
RINT32733 nd10856 nd10857 9.863669807754e+00
RINT32734 nd10857 nd10858 5.711646824659e+01
RINT32735 nd10858 nd10859 7.751520690609e+01
RINT32736 nd10859 nd10860 5.711646824659e+01
RINT32737 nd10860 nd10861 5.711646824659e+01
RINT32738 nd10861 nd10862 5.711646824659e+01
RINT32739 nd10862 nd10863 5.711646824659e+01
RINT32740 nd10863 nd10864 5.711646824659e+01
RINT32741 nd10864 nd10865 5.711646824659e+01
RINT32742 nd10865 nd10866 1.570702876781e+02
RINT32743 nd10866 nd10867 2.570241071097e+02
RINT32744 nd10867 nd10868 1.286757122520e+02
RINT32745 nd10868 nd10869 1.587979254183e+00
RINT32746 nd10869 nd10870 2.753470604119e+01
RINT32747 nd10870 nd10871 2.708952493981e+01
RINT32748 nd10871 nd10872 1.958278911312e+00
RINT32749 nd10872 nd10873 1.958278911312e+00
RINT32750 nd10873 nd10874 1.958278911312e+00
RINT32751 nd10874 nd10875 1.958278911312e+00
RINT32752 nd10875 nd10876 1.958278911312e+00
RINT32753 nd10876 nd10877 1.958278911312e+00
RINT32754 nd10877 nd10878 1.958278911312e+00
RINT32755 nd10878 nd10879 1.958278911312e+00
RINT32756 nd10879 nd10880 1.958278911312e+00
RINT32757 nd10881 nd10882 1.809049213629e+00
RINT32758 nd10882 nd10883 1.644378752938e+00
RINT32759 nd10883 nd10884 5.558248515568e+01
RINT32760 nd10884 nd10885 5.652331240488e+01
RINT32761 nd10885 nd10886 3.467190969629e+00
RINT32762 nd10886 nd10887 3.408348687909e+00
RINT32763 nd10887 nd10888 9.863669807754e+00
RINT32764 nd10888 nd10889 5.711646824659e+01
RINT32765 nd10889 nd10890 7.751520690609e+01
RINT32766 nd10890 nd10891 5.711646824659e+01
RINT32767 nd10891 nd10892 5.711646824659e+01
RINT32768 nd10892 nd10893 5.711646824659e+01
RINT32769 nd10893 nd10894 5.711646824659e+01
RINT32770 nd10894 nd10895 5.711646824659e+01
RINT32771 nd10895 nd10896 5.711646824659e+01
RINT32772 nd10896 nd10897 1.570702876781e+02
RINT32773 nd10897 nd10898 2.570241071097e+02
RINT32774 nd10898 nd10899 1.286757122520e+02
RINT32775 nd10899 nd10900 1.587979254183e+00
RINT32776 nd10900 nd10901 2.753470604119e+01
RINT32777 nd10901 nd10902 2.708952493981e+01
RINT32778 nd10902 nd10903 1.958278911312e+00
RINT32779 nd10903 nd10904 1.958278911312e+00
RINT32780 nd10904 nd10905 1.958278911312e+00
RINT32781 nd10905 nd10906 1.958278911312e+00
RINT32782 nd10906 nd10907 1.958278911312e+00
RINT32783 nd10907 nd10908 1.958278911312e+00
RINT32784 nd10908 nd10909 1.958278911312e+00
RINT32785 nd10909 nd10910 1.958278911312e+00
RINT32786 nd10910 nd10911 1.958278911312e+00
RINT32787 nd10912 nd10913 1.809049213629e+00
RINT32788 nd10913 nd10914 1.644378752938e+00
RINT32789 nd10914 nd10915 5.558248515568e+01
RINT32790 nd10915 nd10916 5.652331240488e+01
RINT32791 nd10916 nd10917 3.467190969629e+00
RINT32792 nd10917 nd10918 3.408348687909e+00
RINT32793 nd10918 nd10919 9.863669807754e+00
RINT32794 nd10919 nd10920 5.711646824659e+01
RINT32795 nd10920 nd10921 7.751520690609e+01
RINT32796 nd10921 nd10922 5.711646824659e+01
RINT32797 nd10922 nd10923 5.711646824659e+01
RINT32798 nd10923 nd10924 5.711646824659e+01
RINT32799 nd10924 nd10925 5.711646824659e+01
RINT32800 nd10925 nd10926 5.711646824659e+01
RINT32801 nd10926 nd10927 5.711646824659e+01
RINT32802 nd10927 nd10928 1.570702876781e+02
RINT32803 nd10928 nd10929 2.570241071097e+02
RINT32804 nd10929 nd10930 1.286757122520e+02
RINT32805 nd10930 nd10931 1.587979254183e+00
RINT32806 nd10931 nd10932 2.753470604119e+01
RINT32807 nd10932 nd10933 2.708952493981e+01
RINT32808 nd10933 nd10934 1.958278911312e+00
RINT32809 nd10934 nd10935 1.958278911312e+00
RINT32810 nd10935 nd10936 1.958278911312e+00
RINT32811 nd10936 nd10937 1.958278911312e+00
RINT32812 nd10937 nd10938 1.958278911312e+00
RINT32813 nd10938 nd10939 1.958278911312e+00
RINT32814 nd10939 nd10940 1.958278911312e+00
RINT32815 nd10940 nd10941 1.958278911312e+00
RINT32816 nd10941 nd10942 1.958278911312e+00
RINT32817 nd10943 nd10944 1.732116531491e+01
RINT32818 nd10944 nd10945 1.574448942870e+01
RINT32819 nd10945 nd10946 5.321875196883e+02
RINT32820 nd10946 nd10947 5.411956904962e+02
RINT32821 nd10947 nd10948 3.319743183927e+01
RINT32822 nd10948 nd10949 3.263403263403e+01
RINT32823 nd10949 nd10950 9.444201631702e+01
RINT32824 nd10950 nd10951 5.468750000000e+02
RINT32825 nd10951 nd10952 7.421875000000e+02
RINT32826 nd10952 nd10953 5.468750000000e+02
RINT32827 nd10953 nd10954 5.468750000000e+02
RINT32828 nd10954 nd10955 5.468750000000e+02
RINT32829 nd10955 nd10956 5.468750000000e+02
RINT32830 nd10956 nd10957 5.468750000000e+02
RINT32831 nd10957 nd10958 5.468750000000e+02
RINT32832 nd10958 nd10959 1.503906250000e+03
RINT32833 nd10959 nd10960 2.460937500000e+03
RINT32834 nd10960 nd10961 1.232035738519e+03
RINT32835 nd10961 nd10962 1.520447922098e+01
RINT32836 nd10962 nd10963 2.636374907017e+02
RINT32837 nd10963 nd10964 2.593750000000e+02
RINT32838 nd10964 nd10965 1.875000000000e+01
RINT32839 nd10965 nd10966 1.875000000000e+01
RINT32840 nd10966 nd10967 1.875000000000e+01
RINT32841 nd10967 nd10968 1.875000000000e+01
RINT32842 nd10968 nd10969 1.875000000000e+01
RINT32843 nd10969 nd10970 1.875000000000e+01
RINT32844 nd10970 nd10971 1.875000000000e+01
RINT32845 nd10971 nd10972 1.875000000000e+01
RINT32846 nd10972 nd10973 1.875000000000e+01
RINT32847 nd10974 nd10975 2.356247123801e+00
RINT32848 nd10975 nd10976 2.141767442179e+00
RINT32849 nd10976 nd10977 7.239497399800e+01
RINT32850 nd10977 nd10978 7.362038095942e+01
RINT32851 nd10978 nd10979 4.515940577133e+00
RINT32852 nd10979 nd10980 4.439299789244e+00
RINT32853 nd10980 nd10981 2.381593738975e+00
RINT32854 nd10981 nd10982 1.133606910468e+00
RINT32855 nd10982 nd10983 1.538466521349e+00
RINT32856 nd10983 nd10984 1.133606910468e+00
RINT32857 nd10984 nd10985 1.133606910468e+00
RINT32858 nd10985 nd10986 1.133606910468e+00
RINT32859 nd10986 nd10987 1.133606910468e+00
RINT32860 nd10987 nd10988 1.133606910468e+00
RINT32861 nd10988 nd10989 1.133606910468e+00
RINT32862 nd10989 nd10990 3.117419003786e+00
RINT32863 nd10990 nd10991 5.101231097105e+00
RINT32864 nd10991 nd10992 2.763777430240e+00
RINT32865 nd10992 nd10993 2.068308325796e+00
RINT32866 nd10993 nd10994 3.586335375814e+01
RINT32867 nd10994 nd10995 3.528351508831e+01
RINT32868 nd10995 nd10996 2.550615548552e+00
RINT32869 nd10996 nd10997 2.550615548552e+00
RINT32870 nd10997 nd10998 2.550615548552e+00
RINT32871 nd10998 nd10999 2.550615548552e+00
RINT32872 nd10999 nd11000 2.550615548552e+00
RINT32873 nd11000 nd11001 2.550615548552e+00
RINT32874 nd11001 nd11002 2.550615548552e+00
RINT32875 nd11002 nd11003 2.550615548552e+00
RINT32876 nd11003 nd11004 2.550615548552e+00
RINT32877 nd11005 nd11006 2.356247123801e+00
RINT32878 nd11006 nd11007 2.141767442179e+00
RINT32879 nd11007 nd11008 7.239497399800e+01
RINT32880 nd11008 nd11009 7.362038095942e+01
RINT32881 nd11009 nd11010 4.515940577133e+00
RINT32882 nd11010 nd11011 4.439299789244e+00
RINT32883 nd11011 nd11012 2.381593738975e+00
RINT32884 nd11012 nd11013 1.133606910468e+00
RINT32885 nd11013 nd11014 1.538466521349e+00
RINT32886 nd11014 nd11015 1.133606910468e+00
RINT32887 nd11015 nd11016 1.133606910468e+00
RINT32888 nd11016 nd11017 1.133606910468e+00
RINT32889 nd11017 nd11018 1.133606910468e+00
RINT32890 nd11018 nd11019 1.133606910468e+00
RINT32891 nd11019 nd11020 1.133606910468e+00
RINT32892 nd11020 nd11021 3.117419003786e+00
RINT32893 nd11021 nd11022 5.101231097105e+00
RINT32894 nd11022 nd11023 2.763777430240e+00
RINT32895 nd11023 nd11024 2.068308325796e+00
RINT32896 nd11024 nd11025 3.586335375814e+01
RINT32897 nd11025 nd11026 3.528351508831e+01
RINT32898 nd11026 nd11027 2.550615548552e+00
RINT32899 nd11027 nd11028 2.550615548552e+00
RINT32900 nd11028 nd11029 2.550615548552e+00
RINT32901 nd11029 nd11030 2.550615548552e+00
RINT32902 nd11030 nd11031 2.550615548552e+00
RINT32903 nd11031 nd11032 2.550615548552e+00
RINT32904 nd11032 nd11033 2.550615548552e+00
RINT32905 nd11033 nd11034 2.550615548552e+00
RINT32906 nd11034 nd11035 2.550615548552e+00
RINT32907 nd11036 nd11037 2.356247123801e+00
RINT32908 nd11037 nd11038 2.141767442179e+00
RINT32909 nd11038 nd11039 7.239497399800e+01
RINT32910 nd11039 nd11040 7.362038095942e+01
RINT32911 nd11040 nd11041 4.515940577133e+00
RINT32912 nd11041 nd11042 4.439299789244e+00
RINT32913 nd11042 nd11043 2.381593738975e+00
RINT32914 nd11043 nd11044 1.133606910468e+00
RINT32915 nd11044 nd11045 1.538466521349e+00
RINT32916 nd11045 nd11046 1.133606910468e+00
RINT32917 nd11046 nd11047 1.133606910468e+00
RINT32918 nd11047 nd11048 1.133606910468e+00
RINT32919 nd11048 nd11049 1.133606910468e+00
RINT32920 nd11049 nd11050 1.133606910468e+00
RINT32921 nd11050 nd11051 1.133606910468e+00
RINT32922 nd11051 nd11052 3.117419003786e+00
RINT32923 nd11052 nd11053 5.101231097105e+00
RINT32924 nd11053 nd11054 2.763777430240e+00
RINT32925 nd11054 nd11055 2.068308325796e+00
RINT32926 nd11055 nd11056 3.586335375814e+01
RINT32927 nd11056 nd11057 3.528351508831e+01
RINT32928 nd11057 nd11058 2.550615548552e+00
RINT32929 nd11058 nd11059 2.550615548552e+00
RINT32930 nd11059 nd11060 2.550615548552e+00
RINT32931 nd11060 nd11061 2.550615548552e+00
RINT32932 nd11061 nd11062 2.550615548552e+00
RINT32933 nd11062 nd11063 2.550615548552e+00
RINT32934 nd11063 nd11064 2.550615548552e+00
RINT32935 nd11064 nd11065 2.550615548552e+00
RINT32936 nd11065 nd11066 2.550615548552e+00
RINT32937 nd11067 nd11068 4.668678698020e-01
RINT32938 nd11068 nd11069 4.243707687709e-01
RINT32939 nd11069 nd11070 1.434437286031e+01
RINT32940 nd11070 nd11071 1.458717554935e+01
RINT32941 nd11071 nd11072 8.947905065228e-01
RINT32942 nd11072 nd11073 8.796048661797e-01
RINT32943 nd11073 nd11074 4.718900595857e-01
RINT32944 nd11074 nd11075 2.246133854709e-01
RINT32945 nd11075 nd11076 3.048324517105e-01
RINT32946 nd11076 nd11077 2.246133854709e-01
RINT32947 nd11077 nd11078 2.246133854709e-01
RINT32948 nd11078 nd11079 2.246133854709e-01
RINT32949 nd11079 nd11080 2.246133854709e-01
RINT32950 nd11080 nd11081 2.246133854709e-01
RINT32951 nd11081 nd11082 2.246133854709e-01
RINT32952 nd11082 nd11083 6.176868100450e-01
RINT32953 nd11083 nd11084 1.010760234619e+00
RINT32954 nd11084 nd11085 5.476161088664e-01
RINT32955 nd11085 nd11086 4.098155462576e-01
RINT32956 nd11086 nd11087 7.105981118828e+00
RINT32957 nd11087 nd11088 6.991091622782e+00
RINT32958 nd11088 nd11089 5.053801173095e-01
RINT32959 nd11089 nd11090 5.053801173095e-01
RINT32960 nd11090 nd11091 5.053801173095e-01
RINT32961 nd11091 nd11092 5.053801173095e-01
RINT32962 nd11092 nd11093 5.053801173095e-01
RINT32963 nd11093 nd11094 5.053801173095e-01
RINT32964 nd11094 nd11095 5.053801173095e-01
RINT32965 nd11095 nd11096 5.053801173095e-01
RINT32966 nd11096 nd11097 5.053801173095e-01
RINT32967 nd11098 nd11099 4.668678698020e-01
RINT32968 nd11099 nd11100 4.243707687709e-01
RINT32969 nd11100 nd11101 1.434437286031e+01
RINT32970 nd11101 nd11102 1.458717554935e+01
RINT32971 nd11102 nd11103 8.947905065228e-01
RINT32972 nd11103 nd11104 8.796048661797e-01
RINT32973 nd11104 nd11105 4.718900595857e-01
RINT32974 nd11105 nd11106 2.246133854709e-01
RINT32975 nd11106 nd11107 3.048324517105e-01
RINT32976 nd11107 nd11108 2.246133854709e-01
RINT32977 nd11108 nd11109 2.246133854709e-01
RINT32978 nd11109 nd11110 2.246133854709e-01
RINT32979 nd11110 nd11111 2.246133854709e-01
RINT32980 nd11111 nd11112 2.246133854709e-01
RINT32981 nd11112 nd11113 2.246133854709e-01
RINT32982 nd11113 nd11114 6.176868100450e-01
RINT32983 nd11114 nd11115 1.010760234619e+00
RINT32984 nd11115 nd11116 5.476161088664e-01
RINT32985 nd11116 nd11117 4.098155462576e-01
RINT32986 nd11117 nd11118 7.105981118828e+00
RINT32987 nd11118 nd11119 6.991091622782e+00
RINT32988 nd11119 nd11120 5.053801173095e-01
RINT32989 nd11120 nd11121 5.053801173095e-01
RINT32990 nd11121 nd11122 5.053801173095e-01
RINT32991 nd11122 nd11123 5.053801173095e-01
RINT32992 nd11123 nd11124 5.053801173095e-01
RINT32993 nd11124 nd11125 5.053801173095e-01
RINT32994 nd11125 nd11126 5.053801173095e-01
RINT32995 nd11126 nd11127 5.053801173095e-01
RINT32996 nd11127 nd11128 5.053801173095e-01
RINT32997 nd11129 nd11130 4.668678698020e-01
RINT32998 nd11130 nd11131 4.243707687709e-01
RINT32999 nd11131 nd11132 1.434437286031e+01
RINT33000 nd11132 nd11133 1.458717554935e+01
RINT33001 nd11133 nd11134 8.947905065228e-01
RINT33002 nd11134 nd11135 8.796048661797e-01
RINT33003 nd11135 nd11136 4.718900595857e-01
RINT33004 nd11136 nd11137 2.246133854709e-01
RINT33005 nd11137 nd11138 3.048324517105e-01
RINT33006 nd11138 nd11139 2.246133854709e-01
RINT33007 nd11139 nd11140 2.246133854709e-01
RINT33008 nd11140 nd11141 2.246133854709e-01
RINT33009 nd11141 nd11142 2.246133854709e-01
RINT33010 nd11142 nd11143 2.246133854709e-01
RINT33011 nd11143 nd11144 2.246133854709e-01
RINT33012 nd11144 nd11145 6.176868100450e-01
RINT33013 nd11145 nd11146 1.010760234619e+00
RINT33014 nd11146 nd11147 5.476161088664e-01
RINT33015 nd11147 nd11148 4.098155462576e-01
RINT33016 nd11148 nd11149 7.105981118828e+00
RINT33017 nd11149 nd11150 6.991091622782e+00
RINT33018 nd11150 nd11151 5.053801173095e-01
RINT33019 nd11151 nd11152 5.053801173095e-01
RINT33020 nd11152 nd11153 5.053801173095e-01
RINT33021 nd11153 nd11154 5.053801173095e-01
RINT33022 nd11154 nd11155 5.053801173095e-01
RINT33023 nd11155 nd11156 5.053801173095e-01
RINT33024 nd11156 nd11157 5.053801173095e-01
RINT33025 nd11157 nd11158 5.053801173095e-01
RINT33026 nd11158 nd11159 5.053801173095e-01
RINT33027 nd11160 nd11161 3.432023522226e+00
RINT33028 nd11161 nd11162 3.119620249697e+00
RINT33029 nd11162 nd11163 1.054478756249e+02
RINT33030 nd11163 nd11164 1.072327586592e+02
RINT33031 nd11164 nd11165 6.577754145201e+00
RINT33032 nd11165 nd11166 6.466121972098e+00
RINT33033 nd11166 nd11167 3.468942476358e+00
RINT33034 nd11167 nd11168 1.651170432161e+00
RINT33035 nd11168 nd11169 2.240874157933e+00
RINT33036 nd11169 nd11170 1.651170432161e+00
RINT33037 nd11170 nd11171 1.651170432161e+00
RINT33038 nd11171 nd11172 1.651170432161e+00
RINT33039 nd11172 nd11173 1.651170432161e+00
RINT33040 nd11173 nd11174 1.651170432161e+00
RINT33041 nd11174 nd11175 1.651170432161e+00
RINT33042 nd11175 nd11176 4.540718688442e+00
RINT33043 nd11176 nd11177 7.430266944724e+00
RINT33044 nd11177 nd11178 4.025617285628e+00
RINT33045 nd11178 nd11179 3.012622383130e+00
RINT33046 nd11179 nd11180 5.223725153469e+01
RINT33047 nd11180 nd11181 5.139267970101e+01
RINT33048 nd11181 nd11182 3.715133472362e+00
RINT33049 nd11182 nd11183 3.715133472362e+00
RINT33050 nd11183 nd11184 3.715133472362e+00
RINT33051 nd11184 nd11185 3.715133472362e+00
RINT33052 nd11185 nd11186 3.715133472362e+00
RINT33053 nd11186 nd11187 3.715133472362e+00
RINT33054 nd11187 nd11188 3.715133472362e+00
RINT33055 nd11188 nd11189 3.715133472362e+00
RINT33056 nd11189 nd11190 3.715133472362e+00
RINT33057 nd11191 nd11192 3.584458286241e-01
RINT33058 nd11192 nd11193 3.258179491350e-01
RINT33059 nd11193 nd11194 1.101313872421e+01
RINT33060 nd11194 nd11195 1.119955466049e+01
RINT33061 nd11195 nd11196 6.869907854048e-01
RINT33062 nd11196 nd11197 6.753317491163e-01
RINT33063 nd11197 nd11198 3.623017011203e-01
RINT33064 nd11198 nd11199 1.724507859350e-01
RINT33065 nd11199 nd11200 2.340403523404e-01
RINT33066 nd11200 nd11201 1.724507859350e-01
RINT33067 nd11201 nd11202 1.724507859350e-01
RINT33068 nd11202 nd11203 1.724507859350e-01
RINT33069 nd11203 nd11204 1.724507859350e-01
RINT33070 nd11204 nd11205 1.724507859350e-01
RINT33071 nd11205 nd11206 1.724507859350e-01
RINT33072 nd11206 nd11207 4.742396613214e-01
RINT33073 nd11207 nd11208 7.760285367077e-01
RINT33074 nd11208 nd11209 4.204416765578e-01
RINT33075 nd11209 nd11210 3.146429269669e-01
RINT33076 nd11210 nd11211 5.455739096815e+00
RINT33077 nd11211 nd11212 5.367530712228e+00
RINT33078 nd11212 nd11213 3.880142683539e-01
RINT33079 nd11213 nd11214 3.880142683539e-01
RINT33080 nd11214 nd11215 3.880142683539e-01
RINT33081 nd11215 nd11216 3.880142683539e-01
RINT33082 nd11216 nd11217 3.880142683539e-01
RINT33083 nd11217 nd11218 3.880142683539e-01
RINT33084 nd11218 nd11219 3.880142683539e-01
RINT33085 nd11219 nd11220 3.880142683539e-01
RINT33086 nd11220 nd11221 3.880142683539e-01
RINT33087 nd11222 nd11223 3.584458286241e-01
RINT33088 nd11223 nd11224 3.258179491350e-01
RINT33089 nd11224 nd11225 1.101313872421e+01
RINT33090 nd11225 nd11226 1.119955466049e+01
RINT33091 nd11226 nd11227 6.869907854048e-01
RINT33092 nd11227 nd11228 6.753317491163e-01
RINT33093 nd11228 nd11229 3.623017011203e-01
RINT33094 nd11229 nd11230 1.724507859350e-01
RINT33095 nd11230 nd11231 2.340403523404e-01
RINT33096 nd11231 nd11232 1.724507859350e-01
RINT33097 nd11232 nd11233 1.724507859350e-01
RINT33098 nd11233 nd11234 1.724507859350e-01
RINT33099 nd11234 nd11235 1.724507859350e-01
RINT33100 nd11235 nd11236 1.724507859350e-01
RINT33101 nd11236 nd11237 1.724507859350e-01
RINT33102 nd11237 nd11238 4.742396613214e-01
RINT33103 nd11238 nd11239 7.760285367077e-01
RINT33104 nd11239 nd11240 4.204416765578e-01
RINT33105 nd11240 nd11241 3.146429269669e-01
RINT33106 nd11241 nd11242 5.455739096815e+00
RINT33107 nd11242 nd11243 5.367530712228e+00
RINT33108 nd11243 nd11244 3.880142683539e-01
RINT33109 nd11244 nd11245 3.880142683539e-01
RINT33110 nd11245 nd11246 3.880142683539e-01
RINT33111 nd11246 nd11247 3.880142683539e-01
RINT33112 nd11247 nd11248 3.880142683539e-01
RINT33113 nd11248 nd11249 3.880142683539e-01
RINT33114 nd11249 nd11250 3.880142683539e-01
RINT33115 nd11250 nd11251 3.880142683539e-01
RINT33116 nd11251 nd11252 3.880142683539e-01
RINT33117 nd11253 nd11254 3.584458286241e-01
RINT33118 nd11254 nd11255 3.258179491350e-01
RINT33119 nd11255 nd11256 1.101313872421e+01
RINT33120 nd11256 nd11257 1.119955466049e+01
RINT33121 nd11257 nd11258 6.869907854048e-01
RINT33122 nd11258 nd11259 6.753317491163e-01
RINT33123 nd11259 nd11260 3.623017011203e-01
RINT33124 nd11260 nd11261 1.724507859350e-01
RINT33125 nd11261 nd11262 2.340403523404e-01
RINT33126 nd11262 nd11263 1.724507859350e-01
RINT33127 nd11263 nd11264 1.724507859350e-01
RINT33128 nd11264 nd11265 1.724507859350e-01
RINT33129 nd11265 nd11266 1.724507859350e-01
RINT33130 nd11266 nd11267 1.724507859350e-01
RINT33131 nd11267 nd11268 1.724507859350e-01
RINT33132 nd11268 nd11269 4.742396613214e-01
RINT33133 nd11269 nd11270 7.760285367077e-01
RINT33134 nd11270 nd11271 4.204416765578e-01
RINT33135 nd11271 nd11272 3.146429269669e-01
RINT33136 nd11272 nd11273 5.455739096815e+00
RINT33137 nd11273 nd11274 5.367530712228e+00
RINT33138 nd11274 nd11275 3.880142683539e-01
RINT33139 nd11275 nd11276 3.880142683539e-01
RINT33140 nd11276 nd11277 3.880142683539e-01
RINT33141 nd11277 nd11278 3.880142683539e-01
RINT33142 nd11278 nd11279 3.880142683539e-01
RINT33143 nd11279 nd11280 3.880142683539e-01
RINT33144 nd11280 nd11281 3.880142683539e-01
RINT33145 nd11281 nd11282 3.880142683539e-01
RINT33146 nd11282 nd11283 3.880142683539e-01
RINT33147 nd11284 nd11285 3.584458286241e-01
RINT33148 nd11285 nd11286 3.258179491350e-01
RINT33149 nd11286 nd11287 1.101313872421e+01
RINT33150 nd11287 nd11288 1.119955466049e+01
RINT33151 nd11288 nd11289 6.869907854048e-01
RINT33152 nd11289 nd11290 6.753317491163e-01
RINT33153 nd11290 nd11291 3.623017011203e-01
RINT33154 nd11291 nd11292 1.724507859350e-01
RINT33155 nd11292 nd11293 2.340403523404e-01
RINT33156 nd11293 nd11294 1.724507859350e-01
RINT33157 nd11294 nd11295 1.724507859350e-01
RINT33158 nd11295 nd11296 1.724507859350e-01
RINT33159 nd11296 nd11297 1.724507859350e-01
RINT33160 nd11297 nd11298 1.724507859350e-01
RINT33161 nd11298 nd11299 1.724507859350e-01
RINT33162 nd11299 nd11300 4.742396613214e-01
RINT33163 nd11300 nd11301 7.760285367077e-01
RINT33164 nd11301 nd11302 4.204416765578e-01
RINT33165 nd11302 nd11303 3.146429269669e-01
RINT33166 nd11303 nd11304 5.455739096815e+00
RINT33167 nd11304 nd11305 5.367530712228e+00
RINT33168 nd11305 nd11306 3.880142683539e-01
RINT33169 nd11306 nd11307 3.880142683539e-01
RINT33170 nd11307 nd11308 3.880142683539e-01
RINT33171 nd11308 nd11309 3.880142683539e-01
RINT33172 nd11309 nd11310 3.880142683539e-01
RINT33173 nd11310 nd11311 3.880142683539e-01
RINT33174 nd11311 nd11312 3.880142683539e-01
RINT33175 nd11312 nd11313 3.880142683539e-01
RINT33176 nd11313 nd11314 3.880142683539e-01
RINT33177 nd11315 nd11316 3.584458286241e-01
RINT33178 nd11316 nd11317 3.258179491350e-01
RINT33179 nd11317 nd11318 1.101313872421e+01
RINT33180 nd11318 nd11319 1.119955466049e+01
RINT33181 nd11319 nd11320 6.869907854048e-01
RINT33182 nd11320 nd11321 6.753317491163e-01
RINT33183 nd11321 nd11322 3.623017011203e-01
RINT33184 nd11322 nd11323 1.724507859350e-01
RINT33185 nd11323 nd11324 2.340403523404e-01
RINT33186 nd11324 nd11325 1.724507859350e-01
RINT33187 nd11325 nd11326 1.724507859350e-01
RINT33188 nd11326 nd11327 1.724507859350e-01
RINT33189 nd11327 nd11328 1.724507859350e-01
RINT33190 nd11328 nd11329 1.724507859350e-01
RINT33191 nd11329 nd11330 1.724507859350e-01
RINT33192 nd11330 nd11331 4.742396613214e-01
RINT33193 nd11331 nd11332 7.760285367077e-01
RINT33194 nd11332 nd11333 4.204416765578e-01
RINT33195 nd11333 nd11334 3.146429269669e-01
RINT33196 nd11334 nd11335 5.455739096815e+00
RINT33197 nd11335 nd11336 5.367530712228e+00
RINT33198 nd11336 nd11337 3.880142683539e-01
RINT33199 nd11337 nd11338 3.880142683539e-01
RINT33200 nd11338 nd11339 3.880142683539e-01
RINT33201 nd11339 nd11340 3.880142683539e-01
RINT33202 nd11340 nd11341 3.880142683539e-01
RINT33203 nd11341 nd11342 3.880142683539e-01
RINT33204 nd11342 nd11343 3.880142683539e-01
RINT33205 nd11343 nd11344 3.880142683539e-01
RINT33206 nd11344 nd11345 3.880142683539e-01
RINT33207 nd11346 nd11347 3.584458286241e-01
RINT33208 nd11347 nd11348 3.258179491350e-01
RINT33209 nd11348 nd11349 1.101313872421e+01
RINT33210 nd11349 nd11350 1.119955466049e+01
RINT33211 nd11350 nd11351 6.869907854048e-01
RINT33212 nd11351 nd11352 6.753317491163e-01
RINT33213 nd11352 nd11353 3.623017011203e-01
RINT33214 nd11353 nd11354 1.724507859350e-01
RINT33215 nd11354 nd11355 2.340403523404e-01
RINT33216 nd11355 nd11356 1.724507859350e-01
RINT33217 nd11356 nd11357 1.724507859350e-01
RINT33218 nd11357 nd11358 1.724507859350e-01
RINT33219 nd11358 nd11359 1.724507859350e-01
RINT33220 nd11359 nd11360 1.724507859350e-01
RINT33221 nd11360 nd11361 1.724507859350e-01
RINT33222 nd11361 nd11362 4.742396613214e-01
RINT33223 nd11362 nd11363 7.760285367077e-01
RINT33224 nd11363 nd11364 4.204416765578e-01
RINT33225 nd11364 nd11365 3.146429269669e-01
RINT33226 nd11365 nd11366 5.455739096815e+00
RINT33227 nd11366 nd11367 5.367530712228e+00
RINT33228 nd11367 nd11368 3.880142683539e-01
RINT33229 nd11368 nd11369 3.880142683539e-01
RINT33230 nd11369 nd11370 3.880142683539e-01
RINT33231 nd11370 nd11371 3.880142683539e-01
RINT33232 nd11371 nd11372 3.880142683539e-01
RINT33233 nd11372 nd11373 3.880142683539e-01
RINT33234 nd11373 nd11374 3.880142683539e-01
RINT33235 nd11374 nd11375 3.880142683539e-01
RINT33236 nd11375 nd11376 3.880142683539e-01
RINT33237 nd11377 nd11378 3.432023522226e+00
RINT33238 nd11378 nd11379 3.119620249697e+00
RINT33239 nd11379 nd11380 1.054478756249e+02
RINT33240 nd11380 nd11381 1.072327586592e+02
RINT33241 nd11381 nd11382 6.577754145200e+00
RINT33242 nd11382 nd11383 6.466121972098e+00
RINT33243 nd11383 nd11384 3.468942476358e+00
RINT33244 nd11384 nd11385 1.651170432161e+00
RINT33245 nd11385 nd11386 2.240874157933e+00
RINT33246 nd11386 nd11387 1.651170432161e+00
RINT33247 nd11387 nd11388 1.651170432161e+00
RINT33248 nd11388 nd11389 1.651170432161e+00
RINT33249 nd11389 nd11390 1.651170432161e+00
RINT33250 nd11390 nd11391 1.651170432161e+00
RINT33251 nd11391 nd11392 1.651170432161e+00
RINT33252 nd11392 nd11393 4.540718688442e+00
RINT33253 nd11393 nd11394 7.430266944724e+00
RINT33254 nd11394 nd11395 4.025617285628e+00
RINT33255 nd11395 nd11396 3.012622383130e+00
RINT33256 nd11396 nd11397 5.223725153469e+01
RINT33257 nd11397 nd11398 5.139267970101e+01
RINT33258 nd11398 nd11399 3.715133472362e+00
RINT33259 nd11399 nd11400 3.715133472362e+00
RINT33260 nd11400 nd11401 3.715133472362e+00
RINT33261 nd11401 nd11402 3.715133472362e+00
RINT33262 nd11402 nd11403 3.715133472362e+00
RINT33263 nd11403 nd11404 3.715133472362e+00
RINT33264 nd11404 nd11405 3.715133472362e+00
RINT33265 nd11405 nd11406 3.715133472362e+00
RINT33266 nd11406 nd11407 3.715133472362e+00
RINT33267 nd11408 nd11409 3.584458286241e-01
RINT33268 nd11409 nd11410 3.258179491350e-01
RINT33269 nd11410 nd11411 1.101313872421e+01
RINT33270 nd11411 nd11412 1.119955466049e+01
RINT33271 nd11412 nd11413 6.869907854048e-01
RINT33272 nd11413 nd11414 6.753317491163e-01
RINT33273 nd11414 nd11415 3.623017011203e-01
RINT33274 nd11415 nd11416 1.724507859350e-01
RINT33275 nd11416 nd11417 2.340403523404e-01
RINT33276 nd11417 nd11418 1.724507859350e-01
RINT33277 nd11418 nd11419 1.724507859350e-01
RINT33278 nd11419 nd11420 1.724507859350e-01
RINT33279 nd11420 nd11421 1.724507859350e-01
RINT33280 nd11421 nd11422 1.724507859350e-01
RINT33281 nd11422 nd11423 1.724507859350e-01
RINT33282 nd11423 nd11424 4.742396613214e-01
RINT33283 nd11424 nd11425 7.760285367077e-01
RINT33284 nd11425 nd11426 4.204416765578e-01
RINT33285 nd11426 nd11427 3.146429269669e-01
RINT33286 nd11427 nd11428 5.455739096815e+00
RINT33287 nd11428 nd11429 5.367530712228e+00
RINT33288 nd11429 nd11430 3.880142683539e-01
RINT33289 nd11430 nd11431 3.880142683539e-01
RINT33290 nd11431 nd11432 3.880142683539e-01
RINT33291 nd11432 nd11433 3.880142683539e-01
RINT33292 nd11433 nd11434 3.880142683539e-01
RINT33293 nd11434 nd11435 3.880142683539e-01
RINT33294 nd11435 nd11436 3.880142683539e-01
RINT33295 nd11436 nd11437 3.880142683539e-01
RINT33296 nd11437 nd11438 3.880142683539e-01
RINT33297 nd11439 nd11440 3.584458286241e-01
RINT33298 nd11440 nd11441 3.258179491350e-01
RINT33299 nd11441 nd11442 1.101313872421e+01
RINT33300 nd11442 nd11443 1.119955466049e+01
RINT33301 nd11443 nd11444 6.869907854048e-01
RINT33302 nd11444 nd11445 6.753317491163e-01
RINT33303 nd11445 nd11446 3.623017011203e-01
RINT33304 nd11446 nd11447 1.724507859350e-01
RINT33305 nd11447 nd11448 2.340403523404e-01
RINT33306 nd11448 nd11449 1.724507859350e-01
RINT33307 nd11449 nd11450 1.724507859350e-01
RINT33308 nd11450 nd11451 1.724507859350e-01
RINT33309 nd11451 nd11452 1.724507859350e-01
RINT33310 nd11452 nd11453 1.724507859350e-01
RINT33311 nd11453 nd11454 1.724507859350e-01
RINT33312 nd11454 nd11455 4.742396613214e-01
RINT33313 nd11455 nd11456 7.760285367077e-01
RINT33314 nd11456 nd11457 4.204416765578e-01
RINT33315 nd11457 nd11458 3.146429269669e-01
RINT33316 nd11458 nd11459 5.455739096815e+00
RINT33317 nd11459 nd11460 5.367530712228e+00
RINT33318 nd11460 nd11461 3.880142683539e-01
RINT33319 nd11461 nd11462 3.880142683539e-01
RINT33320 nd11462 nd11463 3.880142683539e-01
RINT33321 nd11463 nd11464 3.880142683539e-01
RINT33322 nd11464 nd11465 3.880142683539e-01
RINT33323 nd11465 nd11466 3.880142683539e-01
RINT33324 nd11466 nd11467 3.880142683539e-01
RINT33325 nd11467 nd11468 3.880142683539e-01
RINT33326 nd11468 nd11469 3.880142683539e-01
RINT33327 nd11470 nd11471 3.584458286241e-01
RINT33328 nd11471 nd11472 3.258179491350e-01
RINT33329 nd11472 nd11473 1.101313872421e+01
RINT33330 nd11473 nd11474 1.119955466049e+01
RINT33331 nd11474 nd11475 6.869907854048e-01
RINT33332 nd11475 nd11476 6.753317491163e-01
RINT33333 nd11476 nd11477 3.623017011203e-01
RINT33334 nd11477 nd11478 1.724507859350e-01
RINT33335 nd11478 nd11479 2.340403523404e-01
RINT33336 nd11479 nd11480 1.724507859350e-01
RINT33337 nd11480 nd11481 1.724507859350e-01
RINT33338 nd11481 nd11482 1.724507859350e-01
RINT33339 nd11482 nd11483 1.724507859350e-01
RINT33340 nd11483 nd11484 1.724507859350e-01
RINT33341 nd11484 nd11485 1.724507859350e-01
RINT33342 nd11485 nd11486 4.742396613214e-01
RINT33343 nd11486 nd11487 7.760285367077e-01
RINT33344 nd11487 nd11488 4.204416765578e-01
RINT33345 nd11488 nd11489 3.146429269669e-01
RINT33346 nd11489 nd11490 5.455739096815e+00
RINT33347 nd11490 nd11491 5.367530712228e+00
RINT33348 nd11491 nd11492 3.880142683539e-01
RINT33349 nd11492 nd11493 3.880142683539e-01
RINT33350 nd11493 nd11494 3.880142683539e-01
RINT33351 nd11494 nd11495 3.880142683539e-01
RINT33352 nd11495 nd11496 3.880142683539e-01
RINT33353 nd11496 nd11497 3.880142683539e-01
RINT33354 nd11497 nd11498 3.880142683539e-01
RINT33355 nd11498 nd11499 3.880142683539e-01
RINT33356 nd11499 nd11500 3.880142683539e-01
RINT33357 nd11501 nd11502 3.584458286241e-01
RINT33358 nd11502 nd11503 3.258179491350e-01
RINT33359 nd11503 nd11504 1.101313872421e+01
RINT33360 nd11504 nd11505 1.119955466049e+01
RINT33361 nd11505 nd11506 6.869907854048e-01
RINT33362 nd11506 nd11507 6.753317491163e-01
RINT33363 nd11507 nd11508 3.623017011203e-01
RINT33364 nd11508 nd11509 1.724507859350e-01
RINT33365 nd11509 nd11510 2.340403523404e-01
RINT33366 nd11510 nd11511 1.724507859350e-01
RINT33367 nd11511 nd11512 1.724507859350e-01
RINT33368 nd11512 nd11513 1.724507859350e-01
RINT33369 nd11513 nd11514 1.724507859350e-01
RINT33370 nd11514 nd11515 1.724507859350e-01
RINT33371 nd11515 nd11516 1.724507859350e-01
RINT33372 nd11516 nd11517 4.742396613214e-01
RINT33373 nd11517 nd11518 7.760285367077e-01
RINT33374 nd11518 nd11519 4.204416765578e-01
RINT33375 nd11519 nd11520 3.146429269669e-01
RINT33376 nd11520 nd11521 5.455739096815e+00
RINT33377 nd11521 nd11522 5.367530712228e+00
RINT33378 nd11522 nd11523 3.880142683539e-01
RINT33379 nd11523 nd11524 3.880142683539e-01
RINT33380 nd11524 nd11525 3.880142683539e-01
RINT33381 nd11525 nd11526 3.880142683539e-01
RINT33382 nd11526 nd11527 3.880142683539e-01
RINT33383 nd11527 nd11528 3.880142683539e-01
RINT33384 nd11528 nd11529 3.880142683539e-01
RINT33385 nd11529 nd11530 3.880142683539e-01
RINT33386 nd11530 nd11531 3.880142683539e-01
RINT33387 nd11532 nd11533 3.584458286241e-01
RINT33388 nd11533 nd11534 3.258179491350e-01
RINT33389 nd11534 nd11535 1.101313872421e+01
RINT33390 nd11535 nd11536 1.119955466049e+01
RINT33391 nd11536 nd11537 6.869907854048e-01
RINT33392 nd11537 nd11538 6.753317491163e-01
RINT33393 nd11538 nd11539 3.623017011203e-01
RINT33394 nd11539 nd11540 1.724507859350e-01
RINT33395 nd11540 nd11541 2.340403523404e-01
RINT33396 nd11541 nd11542 1.724507859350e-01
RINT33397 nd11542 nd11543 1.724507859350e-01
RINT33398 nd11543 nd11544 1.724507859350e-01
RINT33399 nd11544 nd11545 1.724507859350e-01
RINT33400 nd11545 nd11546 1.724507859350e-01
RINT33401 nd11546 nd11547 1.724507859350e-01
RINT33402 nd11547 nd11548 4.742396613214e-01
RINT33403 nd11548 nd11549 7.760285367077e-01
RINT33404 nd11549 nd11550 4.204416765578e-01
RINT33405 nd11550 nd11551 3.146429269669e-01
RINT33406 nd11551 nd11552 5.455739096815e+00
RINT33407 nd11552 nd11553 5.367530712228e+00
RINT33408 nd11553 nd11554 3.880142683539e-01
RINT33409 nd11554 nd11555 3.880142683539e-01
RINT33410 nd11555 nd11556 3.880142683539e-01
RINT33411 nd11556 nd11557 3.880142683539e-01
RINT33412 nd11557 nd11558 3.880142683539e-01
RINT33413 nd11558 nd11559 3.880142683539e-01
RINT33414 nd11559 nd11560 3.880142683539e-01
RINT33415 nd11560 nd11561 3.880142683539e-01
RINT33416 nd11561 nd11562 3.880142683539e-01
RINT33417 nd11563 nd11564 3.584458286241e-01
RINT33418 nd11564 nd11565 3.258179491350e-01
RINT33419 nd11565 nd11566 1.101313872421e+01
RINT33420 nd11566 nd11567 1.119955466049e+01
RINT33421 nd11567 nd11568 6.869907854048e-01
RINT33422 nd11568 nd11569 6.753317491163e-01
RINT33423 nd11569 nd11570 3.623017011203e-01
RINT33424 nd11570 nd11571 1.724507859350e-01
RINT33425 nd11571 nd11572 2.340403523404e-01
RINT33426 nd11572 nd11573 1.724507859350e-01
RINT33427 nd11573 nd11574 1.724507859350e-01
RINT33428 nd11574 nd11575 1.724507859350e-01
RINT33429 nd11575 nd11576 1.724507859350e-01
RINT33430 nd11576 nd11577 1.724507859350e-01
RINT33431 nd11577 nd11578 1.724507859350e-01
RINT33432 nd11578 nd11579 4.742396613214e-01
RINT33433 nd11579 nd11580 7.760285367077e-01
RINT33434 nd11580 nd11581 4.204416765578e-01
RINT33435 nd11581 nd11582 3.146429269669e-01
RINT33436 nd11582 nd11583 5.455739096815e+00
RINT33437 nd11583 nd11584 5.367530712228e+00
RINT33438 nd11584 nd11585 3.880142683539e-01
RINT33439 nd11585 nd11586 3.880142683539e-01
RINT33440 nd11586 nd11587 3.880142683539e-01
RINT33441 nd11587 nd11588 3.880142683539e-01
RINT33442 nd11588 nd11589 3.880142683539e-01
RINT33443 nd11589 nd11590 3.880142683539e-01
RINT33444 nd11590 nd11591 3.880142683539e-01
RINT33445 nd11591 nd11592 3.880142683539e-01
RINT33446 nd11592 nd11593 3.880142683539e-01
RINT33447 nd11594 nd11595 3.432023522226e+00
RINT33448 nd11595 nd11596 3.119620249697e+00
RINT33449 nd11596 nd11597 1.054478756249e+02
RINT33450 nd11597 nd11598 1.072327586592e+02
RINT33451 nd11598 nd11599 6.577754145200e+00
RINT33452 nd11599 nd11600 6.466121972098e+00
RINT33453 nd11600 nd11601 3.468942476358e+00
RINT33454 nd11601 nd11602 1.651170432161e+00
RINT33455 nd11602 nd11603 2.240874157933e+00
RINT33456 nd11603 nd11604 1.651170432161e+00
RINT33457 nd11604 nd11605 1.651170432161e+00
RINT33458 nd11605 nd11606 1.651170432161e+00
RINT33459 nd11606 nd11607 1.651170432161e+00
RINT33460 nd11607 nd11608 1.651170432161e+00
RINT33461 nd11608 nd11609 1.651170432161e+00
RINT33462 nd11609 nd11610 4.540718688442e+00
RINT33463 nd11610 nd11611 7.430266944724e+00
RINT33464 nd11611 nd11612 4.025617285628e+00
RINT33465 nd11612 nd11613 3.012622383130e+00
RINT33466 nd11613 nd11614 5.223725153469e+01
RINT33467 nd11614 nd11615 5.139267970101e+01
RINT33468 nd11615 nd11616 3.715133472362e+00
RINT33469 nd11616 nd11617 3.715133472362e+00
RINT33470 nd11617 nd11618 3.715133472362e+00
RINT33471 nd11618 nd11619 3.715133472362e+00
RINT33472 nd11619 nd11620 3.715133472362e+00
RINT33473 nd11620 nd11621 3.715133472362e+00
RINT33474 nd11621 nd11622 3.715133472362e+00
RINT33475 nd11622 nd11623 3.715133472362e+00
RINT33476 nd11623 nd11624 3.715133472362e+00
RINT33477 nd11625 nd11626 4.668678698020e-01
RINT33478 nd11626 nd11627 4.243707687709e-01
RINT33479 nd11627 nd11628 1.434437286031e+01
RINT33480 nd11628 nd11629 1.458717554935e+01
RINT33481 nd11629 nd11630 8.947905065228e-01
RINT33482 nd11630 nd11631 8.796048661798e-01
RINT33483 nd11631 nd11632 4.718900595857e-01
RINT33484 nd11632 nd11633 2.246133854709e-01
RINT33485 nd11633 nd11634 3.048324517105e-01
RINT33486 nd11634 nd11635 2.246133854709e-01
RINT33487 nd11635 nd11636 2.246133854709e-01
RINT33488 nd11636 nd11637 2.246133854709e-01
RINT33489 nd11637 nd11638 2.246133854709e-01
RINT33490 nd11638 nd11639 2.246133854709e-01
RINT33491 nd11639 nd11640 2.246133854709e-01
RINT33492 nd11640 nd11641 6.176868100450e-01
RINT33493 nd11641 nd11642 1.010760234619e+00
RINT33494 nd11642 nd11643 5.476161088664e-01
RINT33495 nd11643 nd11644 4.098155462576e-01
RINT33496 nd11644 nd11645 7.105981118828e+00
RINT33497 nd11645 nd11646 6.991091622782e+00
RINT33498 nd11646 nd11647 5.053801173095e-01
RINT33499 nd11647 nd11648 5.053801173095e-01
RINT33500 nd11648 nd11649 5.053801173095e-01
RINT33501 nd11649 nd11650 5.053801173095e-01
RINT33502 nd11650 nd11651 5.053801173095e-01
RINT33503 nd11651 nd11652 5.053801173095e-01
RINT33504 nd11652 nd11653 5.053801173095e-01
RINT33505 nd11653 nd11654 5.053801173095e-01
RINT33506 nd11654 nd11655 5.053801173095e-01
RINT33507 nd11656 nd11657 4.668678698020e-01
RINT33508 nd11657 nd11658 4.243707687709e-01
RINT33509 nd11658 nd11659 1.434437286031e+01
RINT33510 nd11659 nd11660 1.458717554935e+01
RINT33511 nd11660 nd11661 8.947905065228e-01
RINT33512 nd11661 nd11662 8.796048661798e-01
RINT33513 nd11662 nd11663 4.718900595857e-01
RINT33514 nd11663 nd11664 2.246133854709e-01
RINT33515 nd11664 nd11665 3.048324517105e-01
RINT33516 nd11665 nd11666 2.246133854709e-01
RINT33517 nd11666 nd11667 2.246133854709e-01
RINT33518 nd11667 nd11668 2.246133854709e-01
RINT33519 nd11668 nd11669 2.246133854709e-01
RINT33520 nd11669 nd11670 2.246133854709e-01
RINT33521 nd11670 nd11671 2.246133854709e-01
RINT33522 nd11671 nd11672 6.176868100450e-01
RINT33523 nd11672 nd11673 1.010760234619e+00
RINT33524 nd11673 nd11674 5.476161088664e-01
RINT33525 nd11674 nd11675 4.098155462576e-01
RINT33526 nd11675 nd11676 7.105981118828e+00
RINT33527 nd11676 nd11677 6.991091622782e+00
RINT33528 nd11677 nd11678 5.053801173095e-01
RINT33529 nd11678 nd11679 5.053801173095e-01
RINT33530 nd11679 nd11680 5.053801173095e-01
RINT33531 nd11680 nd11681 5.053801173095e-01
RINT33532 nd11681 nd11682 5.053801173095e-01
RINT33533 nd11682 nd11683 5.053801173095e-01
RINT33534 nd11683 nd11684 5.053801173095e-01
RINT33535 nd11684 nd11685 5.053801173095e-01
RINT33536 nd11685 nd11686 5.053801173095e-01
RINT33537 nd11687 nd11688 4.668678698020e-01
RINT33538 nd11688 nd11689 4.243707687709e-01
RINT33539 nd11689 nd11690 1.434437286031e+01
RINT33540 nd11690 nd11691 1.458717554935e+01
RINT33541 nd11691 nd11692 8.947905065228e-01
RINT33542 nd11692 nd11693 8.796048661798e-01
RINT33543 nd11693 nd11694 4.718900595857e-01
RINT33544 nd11694 nd11695 2.246133854709e-01
RINT33545 nd11695 nd11696 3.048324517105e-01
RINT33546 nd11696 nd11697 2.246133854709e-01
RINT33547 nd11697 nd11698 2.246133854709e-01
RINT33548 nd11698 nd11699 2.246133854709e-01
RINT33549 nd11699 nd11700 2.246133854709e-01
RINT33550 nd11700 nd11701 2.246133854709e-01
RINT33551 nd11701 nd11702 2.246133854709e-01
RINT33552 nd11702 nd11703 6.176868100450e-01
RINT33553 nd11703 nd11704 1.010760234619e+00
RINT33554 nd11704 nd11705 5.476161088664e-01
RINT33555 nd11705 nd11706 4.098155462576e-01
RINT33556 nd11706 nd11707 7.105981118828e+00
RINT33557 nd11707 nd11708 6.991091622782e+00
RINT33558 nd11708 nd11709 5.053801173095e-01
RINT33559 nd11709 nd11710 5.053801173095e-01
RINT33560 nd11710 nd11711 5.053801173095e-01
RINT33561 nd11711 nd11712 5.053801173095e-01
RINT33562 nd11712 nd11713 5.053801173095e-01
RINT33563 nd11713 nd11714 5.053801173095e-01
RINT33564 nd11714 nd11715 5.053801173095e-01
RINT33565 nd11715 nd11716 5.053801173095e-01
RINT33566 nd11716 nd11717 5.053801173095e-01
RAMB0 nd0 0 6.738427031922e+04
RAMB30 nd30 0 1.234337030576e+02
RAMB31 nd31 0 6.738427031922e+04
RAMB61 nd61 0 1.234337030576e+02
RAMB62 nd62 0 6.738427031922e+04
RAMB92 nd92 0 1.234337030576e+02
RAMB93 nd93 0 4.953530016163e+05
RAMB123 nd123 0 9.073817234596e+02
RAMB124 nd124 0 5.173543131469e+04
RAMB154 nd154 0 9.476834632332e+01
RAMB155 nd155 0 5.173543131469e+04
RAMB185 nd185 0 9.476834632332e+01
RAMB186 nd186 0 5.173543131469e+04
RAMB216 nd216 0 9.476834632332e+01
RAMB217 nd217 0 5.173543131469e+04
RAMB247 nd247 0 9.476834632332e+01
RAMB248 nd248 0 5.173543131469e+04
RAMB278 nd278 0 9.476834632332e+01
RAMB279 nd279 0 5.173543131469e+04
RAMB309 nd309 0 9.476834632332e+01
RAMB310 nd310 0 4.953530016163e+05
RAMB340 nd340 0 9.073817234596e+02
RAMB341 nd341 0 5.173543131469e+04
RAMB371 nd371 0 9.476834632332e+01
RAMB372 nd372 0 5.173543131469e+04
RAMB402 nd402 0 9.476834632332e+01
RAMB403 nd403 0 5.173543131469e+04
RAMB433 nd433 0 9.476834632332e+01
RAMB434 nd434 0 5.173543131469e+04
RAMB464 nd464 0 9.476834632332e+01
RAMB465 nd465 0 5.173543131469e+04
RAMB495 nd495 0 9.476834632332e+01
RAMB496 nd496 0 5.173543131469e+04
RAMB526 nd526 0 9.476834632332e+01
RAMB527 nd527 0 4.953530016163e+05
RAMB557 nd557 0 9.073817234596e+02
RAMB558 nd558 0 6.738427031922e+04
RAMB588 nd588 0 1.234337030576e+02
RAMB589 nd589 0 6.738427031922e+04
RAMB619 nd619 0 1.234337030576e+02
RAMB620 nd620 0 6.738427031922e+04
RAMB650 nd650 0 1.234337030576e+02
RAMB651 nd651 0 3.400833583881e+05
RAMB681 nd681 0 6.229606418037e+02
RAMB682 nd682 0 3.400833583881e+05
RAMB712 nd712 0 6.229606418037e+02
RAMB713 nd713 0 3.400833583881e+05
RAMB743 nd743 0 6.229606418037e+02
RAMB744 nd744 0 2.500009442671e+06
RAMB774 nd774 0 4.579487504655e+03
RAMB775 nd775 0 2.611048416332e+05
RAMB805 nd805 0 4.782887362676e+02
RAMB806 nd806 0 2.611048416332e+05
RAMB836 nd836 0 4.782887362676e+02
RAMB837 nd837 0 2.611048416332e+05
RAMB867 nd867 0 4.782887362676e+02
RAMB868 nd868 0 2.611048416332e+05
RAMB898 nd898 0 4.782887362676e+02
RAMB899 nd899 0 2.611048416332e+05
RAMB929 nd929 0 4.782887362676e+02
RAMB930 nd930 0 2.611048416332e+05
RAMB960 nd960 0 4.782887362676e+02
RAMB961 nd961 0 2.500009442671e+06
RAMB991 nd991 0 4.579487504655e+03
RAMB992 nd992 0 2.611048416332e+05
RAMB1022 nd1022 0 4.782887362676e+02
RAMB1023 nd1023 0 2.611048416332e+05
RAMB1053 nd1053 0 4.782887362676e+02
RAMB1054 nd1054 0 2.611048416332e+05
RAMB1084 nd1084 0 4.782887362676e+02
RAMB1085 nd1085 0 2.611048416332e+05
RAMB1115 nd1115 0 4.782887362676e+02
RAMB1116 nd1116 0 2.611048416332e+05
RAMB1146 nd1146 0 4.782887362676e+02
RAMB1147 nd1147 0 2.611048416332e+05
RAMB1177 nd1177 0 4.782887362676e+02
RAMB1178 nd1178 0 2.500009442671e+06
RAMB1208 nd1208 0 4.579487504655e+03
RAMB1209 nd1209 0 3.400833583881e+05
RAMB1239 nd1239 0 6.229606418037e+02
RAMB1240 nd1240 0 3.400833583881e+05
RAMB1270 nd1270 0 6.229606418037e+02
RAMB1271 nd1271 0 3.400833583881e+05
RAMB1301 nd1301 0 6.229606418037e+02
RAMB1302 nd1302 0 3.598665735385e+04
RAMB1332 nd1332 0 6.591992992830e+01
RAMB1333 nd1333 0 3.598665735385e+04
RAMB1363 nd1363 0 6.591992992830e+01
RAMB1364 nd1364 0 3.598665735385e+04
RAMB1394 nd1394 0 6.591992992830e+01
RAMB1395 nd1395 0 2.645439159239e+05
RAMB1425 nd1425 0 4.845883915577e+02
RAMB1426 nd1426 0 2.762937449560e+04
RAMB1456 nd1456 0 5.061115881890e+01
RAMB1457 nd1457 0 2.762937449560e+04
RAMB1487 nd1487 0 5.061115881890e+01
RAMB1488 nd1488 0 2.762937449560e+04
RAMB1518 nd1518 0 5.061115881890e+01
RAMB1519 nd1519 0 2.762937449560e+04
RAMB1549 nd1549 0 5.061115881890e+01
RAMB1550 nd1550 0 2.762937449560e+04
RAMB1580 nd1580 0 5.061115881890e+01
RAMB1581 nd1581 0 2.762937449560e+04
RAMB1611 nd1611 0 5.061115881890e+01
RAMB1612 nd1612 0 2.645439159239e+05
RAMB1642 nd1642 0 4.845883915577e+02
RAMB1643 nd1643 0 2.762937449560e+04
RAMB1673 nd1673 0 5.061115881890e+01
RAMB1674 nd1674 0 2.762937449560e+04
RAMB1704 nd1704 0 5.061115881890e+01
RAMB1705 nd1705 0 2.762937449560e+04
RAMB1735 nd1735 0 5.061115881890e+01
RAMB1736 nd1736 0 2.762937449560e+04
RAMB1766 nd1766 0 5.061115881890e+01
RAMB1767 nd1767 0 2.762937449560e+04
RAMB1797 nd1797 0 5.061115881890e+01
RAMB1798 nd1798 0 2.762937449560e+04
RAMB1828 nd1828 0 5.061115881890e+01
RAMB1829 nd1829 0 2.645439159239e+05
RAMB1859 nd1859 0 4.845883915577e+02
RAMB1860 nd1860 0 3.598665735385e+04
RAMB1890 nd1890 0 6.591992992830e+01
RAMB1891 nd1891 0 3.598665735385e+04
RAMB1921 nd1921 0 6.591992992830e+01
RAMB1922 nd1922 0 3.598665735385e+04
RAMB1952 nd1952 0 6.591992992830e+01
RAMB1953 nd1953 0 3.598665735385e+04
RAMB1983 nd1983 0 6.591992992830e+01
RAMB1984 nd1984 0 3.598665735385e+04
RAMB2014 nd2014 0 6.591992992830e+01
RAMB2015 nd2015 0 3.598665735385e+04
RAMB2045 nd2045 0 6.591992992830e+01
RAMB2046 nd2046 0 2.645439159239e+05
RAMB2076 nd2076 0 4.845883915577e+02
RAMB2077 nd2077 0 2.762937449560e+04
RAMB2107 nd2107 0 5.061115881890e+01
RAMB2108 nd2108 0 2.762937449560e+04
RAMB2138 nd2138 0 5.061115881890e+01
RAMB2139 nd2139 0 2.762937449560e+04
RAMB2169 nd2169 0 5.061115881890e+01
RAMB2170 nd2170 0 2.762937449560e+04
RAMB2200 nd2200 0 5.061115881890e+01
RAMB2201 nd2201 0 2.762937449560e+04
RAMB2231 nd2231 0 5.061115881890e+01
RAMB2232 nd2232 0 2.762937449560e+04
RAMB2262 nd2262 0 5.061115881890e+01
RAMB2263 nd2263 0 2.645439159239e+05
RAMB2293 nd2293 0 4.845883915577e+02
RAMB2294 nd2294 0 2.762937449560e+04
RAMB2324 nd2324 0 5.061115881890e+01
RAMB2325 nd2325 0 2.762937449560e+04
RAMB2355 nd2355 0 5.061115881890e+01
RAMB2356 nd2356 0 2.762937449560e+04
RAMB2386 nd2386 0 5.061115881890e+01
RAMB2387 nd2387 0 2.762937449560e+04
RAMB2417 nd2417 0 5.061115881890e+01
RAMB2418 nd2418 0 2.762937449560e+04
RAMB2448 nd2448 0 5.061115881890e+01
RAMB2449 nd2449 0 2.762937449560e+04
RAMB2479 nd2479 0 5.061115881890e+01
RAMB2480 nd2480 0 2.645439159239e+05
RAMB2510 nd2510 0 4.845883915577e+02
RAMB2511 nd2511 0 3.598665735385e+04
RAMB2541 nd2541 0 6.591992992830e+01
RAMB2542 nd2542 0 3.598665735385e+04
RAMB2572 nd2572 0 6.591992992830e+01
RAMB2573 nd2573 0 3.598665735385e+04
RAMB2603 nd2603 0 6.591992992830e+01
RAMB2604 nd2604 0 3.598665735385e+04
RAMB2634 nd2634 0 6.591992992830e+01
RAMB2635 nd2635 0 3.598665735385e+04
RAMB2665 nd2665 0 6.591992992830e+01
RAMB2666 nd2666 0 3.598665735385e+04
RAMB2696 nd2696 0 6.591992992830e+01
RAMB2697 nd2697 0 2.645439159239e+05
RAMB2727 nd2727 0 4.845883915577e+02
RAMB2728 nd2728 0 2.762937449560e+04
RAMB2758 nd2758 0 5.061115881890e+01
RAMB2759 nd2759 0 2.762937449560e+04
RAMB2789 nd2789 0 5.061115881890e+01
RAMB2790 nd2790 0 2.762937449560e+04
RAMB2820 nd2820 0 5.061115881890e+01
RAMB2821 nd2821 0 2.762937449560e+04
RAMB2851 nd2851 0 5.061115881890e+01
RAMB2852 nd2852 0 2.762937449560e+04
RAMB2882 nd2882 0 5.061115881890e+01
RAMB2883 nd2883 0 2.762937449560e+04
RAMB2913 nd2913 0 5.061115881890e+01
RAMB2914 nd2914 0 2.645439159239e+05
RAMB2944 nd2944 0 4.845883915577e+02
RAMB2945 nd2945 0 2.762937449560e+04
RAMB2975 nd2975 0 5.061115881890e+01
RAMB2976 nd2976 0 2.762937449560e+04
RAMB3006 nd3006 0 5.061115881890e+01
RAMB3007 nd3007 0 2.762937449560e+04
RAMB3037 nd3037 0 5.061115881890e+01
RAMB3038 nd3038 0 2.762937449560e+04
RAMB3068 nd3068 0 5.061115881890e+01
RAMB3069 nd3069 0 2.762937449560e+04
RAMB3099 nd3099 0 5.061115881890e+01
RAMB3100 nd3100 0 2.762937449560e+04
RAMB3130 nd3130 0 5.061115881890e+01
RAMB3131 nd3131 0 2.645439159239e+05
RAMB3161 nd3161 0 4.845883915577e+02
RAMB3162 nd3162 0 3.598665735385e+04
RAMB3192 nd3192 0 6.591992992830e+01
RAMB3193 nd3193 0 3.598665735385e+04
RAMB3223 nd3223 0 6.591992992830e+01
RAMB3224 nd3224 0 3.598665735385e+04
RAMB3254 nd3254 0 6.591992992830e+01
RAMB3255 nd3255 0 3.598665735385e+04
RAMB3285 nd3285 0 6.591992992830e+01
RAMB3286 nd3286 0 3.598665735385e+04
RAMB3316 nd3316 0 6.591992992830e+01
RAMB3317 nd3317 0 3.598665735385e+04
RAMB3347 nd3347 0 6.591992992830e+01
RAMB3348 nd3348 0 2.645439159239e+05
RAMB3378 nd3378 0 4.845883915577e+02
RAMB3379 nd3379 0 2.762937449560e+04
RAMB3409 nd3409 0 5.061115881890e+01
RAMB3410 nd3410 0 2.762937449560e+04
RAMB3440 nd3440 0 5.061115881890e+01
RAMB3441 nd3441 0 2.762937449560e+04
RAMB3471 nd3471 0 5.061115881890e+01
RAMB3472 nd3472 0 2.762937449560e+04
RAMB3502 nd3502 0 5.061115881890e+01
RAMB3503 nd3503 0 2.762937449560e+04
RAMB3533 nd3533 0 5.061115881890e+01
RAMB3534 nd3534 0 2.762937449560e+04
RAMB3564 nd3564 0 5.061115881890e+01
RAMB3565 nd3565 0 2.645439159239e+05
RAMB3595 nd3595 0 4.845883915577e+02
RAMB3596 nd3596 0 2.762937449560e+04
RAMB3626 nd3626 0 5.061115881890e+01
RAMB3627 nd3627 0 2.762937449560e+04
RAMB3657 nd3657 0 5.061115881890e+01
RAMB3658 nd3658 0 2.762937449560e+04
RAMB3688 nd3688 0 5.061115881890e+01
RAMB3689 nd3689 0 2.762937449560e+04
RAMB3719 nd3719 0 5.061115881890e+01
RAMB3720 nd3720 0 2.762937449560e+04
RAMB3750 nd3750 0 5.061115881890e+01
RAMB3751 nd3751 0 2.762937449560e+04
RAMB3781 nd3781 0 5.061115881890e+01
RAMB3782 nd3782 0 2.645439159239e+05
RAMB3812 nd3812 0 4.845883915577e+02
RAMB3813 nd3813 0 3.598665735385e+04
RAMB3843 nd3843 0 6.591992992830e+01
RAMB3844 nd3844 0 3.598665735385e+04
RAMB3874 nd3874 0 6.591992992830e+01
RAMB3875 nd3875 0 3.598665735385e+04
RAMB3905 nd3905 0 6.591992992830e+01
RAMB3906 nd3906 0 3.400833583881e+05
RAMB3936 nd3936 0 6.229606418037e+02
RAMB3937 nd3937 0 3.400833583881e+05
RAMB3967 nd3967 0 6.229606418037e+02
RAMB3968 nd3968 0 3.400833583881e+05
RAMB3998 nd3998 0 6.229606418037e+02
RAMB3999 nd3999 0 2.500009442671e+06
RAMB4029 nd4029 0 4.579487504655e+03
RAMB4030 nd4030 0 2.611048416332e+05
RAMB4060 nd4060 0 4.782887362676e+02
RAMB4061 nd4061 0 2.611048416332e+05
RAMB4091 nd4091 0 4.782887362676e+02
RAMB4092 nd4092 0 2.611048416332e+05
RAMB4122 nd4122 0 4.782887362676e+02
RAMB4123 nd4123 0 2.611048416332e+05
RAMB4153 nd4153 0 4.782887362676e+02
RAMB4154 nd4154 0 2.611048416332e+05
RAMB4184 nd4184 0 4.782887362676e+02
RAMB4185 nd4185 0 2.611048416332e+05
RAMB4215 nd4215 0 4.782887362676e+02
RAMB4216 nd4216 0 2.500009442671e+06
RAMB4246 nd4246 0 4.579487504655e+03
RAMB4247 nd4247 0 2.611048416332e+05
RAMB4277 nd4277 0 4.782887362676e+02
RAMB4278 nd4278 0 2.611048416332e+05
RAMB4308 nd4308 0 4.782887362676e+02
RAMB4309 nd4309 0 2.611048416332e+05
RAMB4339 nd4339 0 4.782887362676e+02
RAMB4340 nd4340 0 2.611048416332e+05
RAMB4370 nd4370 0 4.782887362676e+02
RAMB4371 nd4371 0 2.611048416332e+05
RAMB4401 nd4401 0 4.782887362676e+02
RAMB4402 nd4402 0 2.611048416332e+05
RAMB4432 nd4432 0 4.782887362676e+02
RAMB4433 nd4433 0 2.500009442671e+06
RAMB4463 nd4463 0 4.579487504655e+03
RAMB4464 nd4464 0 3.400833583881e+05
RAMB4494 nd4494 0 6.229606418037e+02
RAMB4495 nd4495 0 3.400833583881e+05
RAMB4525 nd4525 0 6.229606418037e+02
RAMB4526 nd4526 0 3.400833583881e+05
RAMB4556 nd4556 0 6.229606418037e+02
RAMB4557 nd4557 0 3.598665735385e+04
RAMB4587 nd4587 0 6.591992992830e+01
RAMB4588 nd4588 0 3.598665735385e+04
RAMB4618 nd4618 0 6.591992992830e+01
RAMB4619 nd4619 0 3.598665735385e+04
RAMB4649 nd4649 0 6.591992992830e+01
RAMB4650 nd4650 0 2.645439159239e+05
RAMB4680 nd4680 0 4.845883915577e+02
RAMB4681 nd4681 0 2.762937449560e+04
RAMB4711 nd4711 0 5.061115881890e+01
RAMB4712 nd4712 0 2.762937449560e+04
RAMB4742 nd4742 0 5.061115881890e+01
RAMB4743 nd4743 0 2.762937449560e+04
RAMB4773 nd4773 0 5.061115881890e+01
RAMB4774 nd4774 0 2.762937449560e+04
RAMB4804 nd4804 0 5.061115881890e+01
RAMB4805 nd4805 0 2.762937449560e+04
RAMB4835 nd4835 0 5.061115881890e+01
RAMB4836 nd4836 0 2.762937449560e+04
RAMB4866 nd4866 0 5.061115881890e+01
RAMB4867 nd4867 0 2.645439159239e+05
RAMB4897 nd4897 0 4.845883915577e+02
RAMB4898 nd4898 0 2.762937449560e+04
RAMB4928 nd4928 0 5.061115881890e+01
RAMB4929 nd4929 0 2.762937449560e+04
RAMB4959 nd4959 0 5.061115881890e+01
RAMB4960 nd4960 0 2.762937449560e+04
RAMB4990 nd4990 0 5.061115881890e+01
RAMB4991 nd4991 0 2.762937449560e+04
RAMB5021 nd5021 0 5.061115881890e+01
RAMB5022 nd5022 0 2.762937449560e+04
RAMB5052 nd5052 0 5.061115881890e+01
RAMB5053 nd5053 0 2.762937449560e+04
RAMB5083 nd5083 0 5.061115881890e+01
RAMB5084 nd5084 0 2.645439159239e+05
RAMB5114 nd5114 0 4.845883915577e+02
RAMB5115 nd5115 0 3.598665735385e+04
RAMB5145 nd5145 0 6.591992992830e+01
RAMB5146 nd5146 0 3.598665735385e+04
RAMB5176 nd5176 0 6.591992992830e+01
RAMB5177 nd5177 0 3.598665735385e+04
RAMB5207 nd5207 0 6.591992992830e+01
RAMB5208 nd5208 0 3.598665735385e+04
RAMB5238 nd5238 0 6.591992992830e+01
RAMB5239 nd5239 0 3.598665735385e+04
RAMB5269 nd5269 0 6.591992992830e+01
RAMB5270 nd5270 0 3.598665735385e+04
RAMB5300 nd5300 0 6.591992992830e+01
RAMB5301 nd5301 0 2.645439159239e+05
RAMB5331 nd5331 0 4.845883915577e+02
RAMB5332 nd5332 0 2.762937449560e+04
RAMB5362 nd5362 0 5.061115881890e+01
RAMB5363 nd5363 0 2.762937449560e+04
RAMB5393 nd5393 0 5.061115881890e+01
RAMB5394 nd5394 0 2.762937449560e+04
RAMB5424 nd5424 0 5.061115881890e+01
RAMB5425 nd5425 0 2.762937449560e+04
RAMB5455 nd5455 0 5.061115881890e+01
RAMB5456 nd5456 0 2.762937449560e+04
RAMB5486 nd5486 0 5.061115881890e+01
RAMB5487 nd5487 0 2.762937449560e+04
RAMB5517 nd5517 0 5.061115881890e+01
RAMB5518 nd5518 0 2.645439159239e+05
RAMB5548 nd5548 0 4.845883915577e+02
RAMB5549 nd5549 0 2.762937449560e+04
RAMB5579 nd5579 0 5.061115881890e+01
RAMB5580 nd5580 0 2.762937449560e+04
RAMB5610 nd5610 0 5.061115881890e+01
RAMB5611 nd5611 0 2.762937449560e+04
RAMB5641 nd5641 0 5.061115881890e+01
RAMB5642 nd5642 0 2.762937449560e+04
RAMB5672 nd5672 0 5.061115881890e+01
RAMB5673 nd5673 0 2.762937449560e+04
RAMB5703 nd5703 0 5.061115881890e+01
RAMB5704 nd5704 0 2.762937449560e+04
RAMB5734 nd5734 0 5.061115881890e+01
RAMB5735 nd5735 0 2.645439159239e+05
RAMB5765 nd5765 0 4.845883915577e+02
RAMB5766 nd5766 0 3.598665735385e+04
RAMB5796 nd5796 0 6.591992992830e+01
RAMB5797 nd5797 0 3.598665735385e+04
RAMB5827 nd5827 0 6.591992992830e+01
RAMB5828 nd5828 0 3.598665735385e+04
RAMB5858 nd5858 0 6.591992992830e+01
RAMB5859 nd5859 0 3.598665735385e+04
RAMB5889 nd5889 0 6.591992992830e+01
RAMB5890 nd5890 0 3.598665735385e+04
RAMB5920 nd5920 0 6.591992992830e+01
RAMB5921 nd5921 0 3.598665735385e+04
RAMB5951 nd5951 0 6.591992992830e+01
RAMB5952 nd5952 0 2.645439159239e+05
RAMB5982 nd5982 0 4.845883915577e+02
RAMB5983 nd5983 0 2.762937449560e+04
RAMB6013 nd6013 0 5.061115881890e+01
RAMB6014 nd6014 0 2.762937449560e+04
RAMB6044 nd6044 0 5.061115881890e+01
RAMB6045 nd6045 0 2.762937449560e+04
RAMB6075 nd6075 0 5.061115881890e+01
RAMB6076 nd6076 0 2.762937449560e+04
RAMB6106 nd6106 0 5.061115881890e+01
RAMB6107 nd6107 0 2.762937449560e+04
RAMB6137 nd6137 0 5.061115881890e+01
RAMB6138 nd6138 0 2.762937449560e+04
RAMB6168 nd6168 0 5.061115881890e+01
RAMB6169 nd6169 0 2.645439159239e+05
RAMB6199 nd6199 0 4.845883915577e+02
RAMB6200 nd6200 0 2.762937449560e+04
RAMB6230 nd6230 0 5.061115881890e+01
RAMB6231 nd6231 0 2.762937449560e+04
RAMB6261 nd6261 0 5.061115881890e+01
RAMB6262 nd6262 0 2.762937449560e+04
RAMB6292 nd6292 0 5.061115881890e+01
RAMB6293 nd6293 0 2.762937449560e+04
RAMB6323 nd6323 0 5.061115881890e+01
RAMB6324 nd6324 0 2.762937449560e+04
RAMB6354 nd6354 0 5.061115881890e+01
RAMB6355 nd6355 0 2.762937449560e+04
RAMB6385 nd6385 0 5.061115881890e+01
RAMB6386 nd6386 0 2.645439159239e+05
RAMB6416 nd6416 0 4.845883915577e+02
RAMB6417 nd6417 0 3.598665735385e+04
RAMB6447 nd6447 0 6.591992992830e+01
RAMB6448 nd6448 0 3.598665735385e+04
RAMB6478 nd6478 0 6.591992992830e+01
RAMB6479 nd6479 0 3.598665735385e+04
RAMB6509 nd6509 0 6.591992992830e+01
RAMB6510 nd6510 0 3.598665735385e+04
RAMB6540 nd6540 0 6.591992992830e+01
RAMB6541 nd6541 0 3.598665735385e+04
RAMB6571 nd6571 0 6.591992992830e+01
RAMB6572 nd6572 0 3.598665735385e+04
RAMB6602 nd6602 0 6.591992992830e+01
RAMB6603 nd6603 0 2.645439159239e+05
RAMB6633 nd6633 0 4.845883915577e+02
RAMB6634 nd6634 0 2.762937449560e+04
RAMB6664 nd6664 0 5.061115881890e+01
RAMB6665 nd6665 0 2.762937449560e+04
RAMB6695 nd6695 0 5.061115881890e+01
RAMB6696 nd6696 0 2.762937449560e+04
RAMB6726 nd6726 0 5.061115881890e+01
RAMB6727 nd6727 0 2.762937449560e+04
RAMB6757 nd6757 0 5.061115881890e+01
RAMB6758 nd6758 0 2.762937449560e+04
RAMB6788 nd6788 0 5.061115881890e+01
RAMB6789 nd6789 0 2.762937449560e+04
RAMB6819 nd6819 0 5.061115881890e+01
RAMB6820 nd6820 0 2.645439159239e+05
RAMB6850 nd6850 0 4.845883915577e+02
RAMB6851 nd6851 0 2.762937449560e+04
RAMB6881 nd6881 0 5.061115881890e+01
RAMB6882 nd6882 0 2.762937449560e+04
RAMB6912 nd6912 0 5.061115881890e+01
RAMB6913 nd6913 0 2.762937449560e+04
RAMB6943 nd6943 0 5.061115881890e+01
RAMB6944 nd6944 0 2.762937449560e+04
RAMB6974 nd6974 0 5.061115881890e+01
RAMB6975 nd6975 0 2.762937449560e+04
RAMB7005 nd7005 0 5.061115881890e+01
RAMB7006 nd7006 0 2.762937449560e+04
RAMB7036 nd7036 0 5.061115881890e+01
RAMB7037 nd7037 0 2.645439159239e+05
RAMB7067 nd7067 0 4.845883915577e+02
RAMB7068 nd7068 0 3.598665735385e+04
RAMB7098 nd7098 0 6.591992992830e+01
RAMB7099 nd7099 0 3.598665735385e+04
RAMB7129 nd7129 0 6.591992992830e+01
RAMB7130 nd7130 0 3.598665735385e+04
RAMB7160 nd7160 0 6.591992992830e+01
RAMB7161 nd7161 0 3.400833583881e+05
RAMB7191 nd7191 0 6.229606418037e+02
RAMB7192 nd7192 0 3.400833583881e+05
RAMB7222 nd7222 0 6.229606418037e+02
RAMB7223 nd7223 0 3.400833583881e+05
RAMB7253 nd7253 0 6.229606418037e+02
RAMB7254 nd7254 0 2.500009442671e+06
RAMB7284 nd7284 0 4.579487504655e+03
RAMB7285 nd7285 0 2.611048416332e+05
RAMB7315 nd7315 0 4.782887362676e+02
RAMB7316 nd7316 0 2.611048416332e+05
RAMB7346 nd7346 0 4.782887362676e+02
RAMB7347 nd7347 0 2.611048416332e+05
RAMB7377 nd7377 0 4.782887362676e+02
RAMB7378 nd7378 0 2.611048416332e+05
RAMB7408 nd7408 0 4.782887362676e+02
RAMB7409 nd7409 0 2.611048416332e+05
RAMB7439 nd7439 0 4.782887362676e+02
RAMB7440 nd7440 0 2.611048416332e+05
RAMB7470 nd7470 0 4.782887362676e+02
RAMB7471 nd7471 0 2.500009442671e+06
RAMB7501 nd7501 0 4.579487504655e+03
RAMB7502 nd7502 0 2.611048416332e+05
RAMB7532 nd7532 0 4.782887362676e+02
RAMB7533 nd7533 0 2.611048416332e+05
RAMB7563 nd7563 0 4.782887362676e+02
RAMB7564 nd7564 0 2.611048416332e+05
RAMB7594 nd7594 0 4.782887362676e+02
RAMB7595 nd7595 0 2.611048416332e+05
RAMB7625 nd7625 0 4.782887362676e+02
RAMB7626 nd7626 0 2.611048416332e+05
RAMB7656 nd7656 0 4.782887362676e+02
RAMB7657 nd7657 0 2.611048416332e+05
RAMB7687 nd7687 0 4.782887362676e+02
RAMB7688 nd7688 0 2.500009442671e+06
RAMB7718 nd7718 0 4.579487504655e+03
RAMB7719 nd7719 0 3.400833583881e+05
RAMB7749 nd7749 0 6.229606418037e+02
RAMB7750 nd7750 0 3.400833583881e+05
RAMB7780 nd7780 0 6.229606418037e+02
RAMB7781 nd7781 0 3.400833583881e+05
RAMB7811 nd7811 0 6.229606418037e+02
RAMB7812 nd7812 0 3.598665735385e+04
RAMB7842 nd7842 0 6.591992992830e+01
RAMB7843 nd7843 0 3.598665735385e+04
RAMB7873 nd7873 0 6.591992992830e+01
RAMB7874 nd7874 0 3.598665735385e+04
RAMB7904 nd7904 0 6.591992992830e+01
RAMB7905 nd7905 0 2.645439159239e+05
RAMB7935 nd7935 0 4.845883915577e+02
RAMB7936 nd7936 0 2.762937449560e+04
RAMB7966 nd7966 0 5.061115881890e+01
RAMB7967 nd7967 0 2.762937449560e+04
RAMB7997 nd7997 0 5.061115881890e+01
RAMB7998 nd7998 0 2.762937449560e+04
RAMB8028 nd8028 0 5.061115881890e+01
RAMB8029 nd8029 0 2.762937449560e+04
RAMB8059 nd8059 0 5.061115881890e+01
RAMB8060 nd8060 0 2.762937449560e+04
RAMB8090 nd8090 0 5.061115881890e+01
RAMB8091 nd8091 0 2.762937449560e+04
RAMB8121 nd8121 0 5.061115881890e+01
RAMB8122 nd8122 0 2.645439159239e+05
RAMB8152 nd8152 0 4.845883915577e+02
RAMB8153 nd8153 0 2.762937449560e+04
RAMB8183 nd8183 0 5.061115881890e+01
RAMB8184 nd8184 0 2.762937449560e+04
RAMB8214 nd8214 0 5.061115881890e+01
RAMB8215 nd8215 0 2.762937449560e+04
RAMB8245 nd8245 0 5.061115881890e+01
RAMB8246 nd8246 0 2.762937449560e+04
RAMB8276 nd8276 0 5.061115881890e+01
RAMB8277 nd8277 0 2.762937449560e+04
RAMB8307 nd8307 0 5.061115881890e+01
RAMB8308 nd8308 0 2.762937449560e+04
RAMB8338 nd8338 0 5.061115881890e+01
RAMB8339 nd8339 0 2.645439159239e+05
RAMB8369 nd8369 0 4.845883915577e+02
RAMB8370 nd8370 0 3.598665735385e+04
RAMB8400 nd8400 0 6.591992992830e+01
RAMB8401 nd8401 0 3.598665735385e+04
RAMB8431 nd8431 0 6.591992992830e+01
RAMB8432 nd8432 0 3.598665735385e+04
RAMB8462 nd8462 0 6.591992992830e+01
RAMB8463 nd8463 0 3.598665735385e+04
RAMB8493 nd8493 0 6.591992992830e+01
RAMB8494 nd8494 0 3.598665735385e+04
RAMB8524 nd8524 0 6.591992992830e+01
RAMB8525 nd8525 0 3.598665735385e+04
RAMB8555 nd8555 0 6.591992992830e+01
RAMB8556 nd8556 0 2.645439159239e+05
RAMB8586 nd8586 0 4.845883915577e+02
RAMB8587 nd8587 0 2.762937449560e+04
RAMB8617 nd8617 0 5.061115881890e+01
RAMB8618 nd8618 0 2.762937449560e+04
RAMB8648 nd8648 0 5.061115881890e+01
RAMB8649 nd8649 0 2.762937449560e+04
RAMB8679 nd8679 0 5.061115881890e+01
RAMB8680 nd8680 0 2.762937449560e+04
RAMB8710 nd8710 0 5.061115881890e+01
RAMB8711 nd8711 0 2.762937449560e+04
RAMB8741 nd8741 0 5.061115881890e+01
RAMB8742 nd8742 0 2.762937449560e+04
RAMB8772 nd8772 0 5.061115881890e+01
RAMB8773 nd8773 0 2.645439159239e+05
RAMB8803 nd8803 0 4.845883915577e+02
RAMB8804 nd8804 0 2.762937449560e+04
RAMB8834 nd8834 0 5.061115881890e+01
RAMB8835 nd8835 0 2.762937449560e+04
RAMB8865 nd8865 0 5.061115881890e+01
RAMB8866 nd8866 0 2.762937449560e+04
RAMB8896 nd8896 0 5.061115881890e+01
RAMB8897 nd8897 0 2.762937449560e+04
RAMB8927 nd8927 0 5.061115881890e+01
RAMB8928 nd8928 0 2.762937449560e+04
RAMB8958 nd8958 0 5.061115881890e+01
RAMB8959 nd8959 0 2.762937449560e+04
RAMB8989 nd8989 0 5.061115881890e+01
RAMB8990 nd8990 0 2.645439159239e+05
RAMB9020 nd9020 0 4.845883915577e+02
RAMB9021 nd9021 0 3.598665735385e+04
RAMB9051 nd9051 0 6.591992992830e+01
RAMB9052 nd9052 0 3.598665735385e+04
RAMB9082 nd9082 0 6.591992992830e+01
RAMB9083 nd9083 0 3.598665735385e+04
RAMB9113 nd9113 0 6.591992992830e+01
RAMB9114 nd9114 0 3.598665735385e+04
RAMB9144 nd9144 0 6.591992992830e+01
RAMB9145 nd9145 0 3.598665735385e+04
RAMB9175 nd9175 0 6.591992992830e+01
RAMB9176 nd9176 0 3.598665735385e+04
RAMB9206 nd9206 0 6.591992992830e+01
RAMB9207 nd9207 0 2.645439159239e+05
RAMB9237 nd9237 0 4.845883915577e+02
RAMB9238 nd9238 0 2.762937449560e+04
RAMB9268 nd9268 0 5.061115881890e+01
RAMB9269 nd9269 0 2.762937449560e+04
RAMB9299 nd9299 0 5.061115881890e+01
RAMB9300 nd9300 0 2.762937449560e+04
RAMB9330 nd9330 0 5.061115881890e+01
RAMB9331 nd9331 0 2.762937449560e+04
RAMB9361 nd9361 0 5.061115881890e+01
RAMB9362 nd9362 0 2.762937449560e+04
RAMB9392 nd9392 0 5.061115881890e+01
RAMB9393 nd9393 0 2.762937449560e+04
RAMB9423 nd9423 0 5.061115881890e+01
RAMB9424 nd9424 0 2.645439159239e+05
RAMB9454 nd9454 0 4.845883915577e+02
RAMB9455 nd9455 0 2.762937449560e+04
RAMB9485 nd9485 0 5.061115881890e+01
RAMB9486 nd9486 0 2.762937449560e+04
RAMB9516 nd9516 0 5.061115881890e+01
RAMB9517 nd9517 0 2.762937449560e+04
RAMB9547 nd9547 0 5.061115881890e+01
RAMB9548 nd9548 0 2.762937449560e+04
RAMB9578 nd9578 0 5.061115881890e+01
RAMB9579 nd9579 0 2.762937449560e+04
RAMB9609 nd9609 0 5.061115881890e+01
RAMB9610 nd9610 0 2.762937449560e+04
RAMB9640 nd9640 0 5.061115881890e+01
RAMB9641 nd9641 0 2.645439159239e+05
RAMB9671 nd9671 0 4.845883915577e+02
RAMB9672 nd9672 0 3.598665735385e+04
RAMB9702 nd9702 0 6.591992992830e+01
RAMB9703 nd9703 0 3.598665735385e+04
RAMB9733 nd9733 0 6.591992992830e+01
RAMB9734 nd9734 0 3.598665735385e+04
RAMB9764 nd9764 0 6.591992992830e+01
RAMB9765 nd9765 0 3.598665735385e+04
RAMB9795 nd9795 0 6.591992992830e+01
RAMB9796 nd9796 0 3.598665735385e+04
RAMB9826 nd9826 0 6.591992992830e+01
RAMB9827 nd9827 0 3.598665735385e+04
RAMB9857 nd9857 0 6.591992992830e+01
RAMB9858 nd9858 0 2.645439159239e+05
RAMB9888 nd9888 0 4.845883915577e+02
RAMB9889 nd9889 0 2.762937449560e+04
RAMB9919 nd9919 0 5.061115881890e+01
RAMB9920 nd9920 0 2.762937449560e+04
RAMB9950 nd9950 0 5.061115881890e+01
RAMB9951 nd9951 0 2.762937449560e+04
RAMB9981 nd9981 0 5.061115881890e+01
RAMB9982 nd9982 0 2.762937449560e+04
RAMB10012 nd10012 0 5.061115881890e+01
RAMB10013 nd10013 0 2.762937449560e+04
RAMB10043 nd10043 0 5.061115881890e+01
RAMB10044 nd10044 0 2.762937449560e+04
RAMB10074 nd10074 0 5.061115881890e+01
RAMB10075 nd10075 0 2.645439159239e+05
RAMB10105 nd10105 0 4.845883915577e+02
RAMB10106 nd10106 0 2.762937449560e+04
RAMB10136 nd10136 0 5.061115881890e+01
RAMB10137 nd10137 0 2.762937449560e+04
RAMB10167 nd10167 0 5.061115881890e+01
RAMB10168 nd10168 0 2.762937449560e+04
RAMB10198 nd10198 0 5.061115881890e+01
RAMB10199 nd10199 0 2.762937449560e+04
RAMB10229 nd10229 0 5.061115881890e+01
RAMB10230 nd10230 0 2.762937449560e+04
RAMB10260 nd10260 0 5.061115881890e+01
RAMB10261 nd10261 0 2.762937449560e+04
RAMB10291 nd10291 0 5.061115881890e+01
RAMB10292 nd10292 0 2.645439159239e+05
RAMB10322 nd10322 0 4.845883915577e+02
RAMB10323 nd10323 0 3.598665735385e+04
RAMB10353 nd10353 0 6.591992992830e+01
RAMB10354 nd10354 0 3.598665735385e+04
RAMB10384 nd10384 0 6.591992992830e+01
RAMB10385 nd10385 0 3.598665735385e+04
RAMB10415 nd10415 0 6.591992992830e+01
RAMB10416 nd10416 0 3.400833583881e+05
RAMB10446 nd10446 0 6.229606418037e+02
RAMB10447 nd10447 0 3.400833583881e+05
RAMB10477 nd10477 0 6.229606418037e+02
RAMB10478 nd10478 0 3.400833583881e+05
RAMB10508 nd10508 0 6.229606418037e+02
RAMB10509 nd10509 0 2.500009442671e+06
RAMB10539 nd10539 0 4.579487504655e+03
RAMB10540 nd10540 0 2.611048416332e+05
RAMB10570 nd10570 0 4.782887362676e+02
RAMB10571 nd10571 0 2.611048416332e+05
RAMB10601 nd10601 0 4.782887362676e+02
RAMB10602 nd10602 0 2.611048416332e+05
RAMB10632 nd10632 0 4.782887362676e+02
RAMB10633 nd10633 0 2.611048416332e+05
RAMB10663 nd10663 0 4.782887362676e+02
RAMB10664 nd10664 0 2.611048416332e+05
RAMB10694 nd10694 0 4.782887362676e+02
RAMB10695 nd10695 0 2.611048416332e+05
RAMB10725 nd10725 0 4.782887362676e+02
RAMB10726 nd10726 0 2.500009442671e+06
RAMB10756 nd10756 0 4.579487504655e+03
RAMB10757 nd10757 0 2.611048416332e+05
RAMB10787 nd10787 0 4.782887362676e+02
RAMB10788 nd10788 0 2.611048416332e+05
RAMB10818 nd10818 0 4.782887362676e+02
RAMB10819 nd10819 0 2.611048416332e+05
RAMB10849 nd10849 0 4.782887362676e+02
RAMB10850 nd10850 0 2.611048416332e+05
RAMB10880 nd10880 0 4.782887362676e+02
RAMB10881 nd10881 0 2.611048416332e+05
RAMB10911 nd10911 0 4.782887362676e+02
RAMB10912 nd10912 0 2.611048416332e+05
RAMB10942 nd10942 0 4.782887362676e+02
RAMB10943 nd10943 0 2.500009442671e+06
RAMB10973 nd10973 0 4.579487504655e+03
RAMB10974 nd10974 0 3.400833583881e+05
RAMB11004 nd11004 0 6.229606418037e+02
RAMB11005 nd11005 0 3.400833583881e+05
RAMB11035 nd11035 0 6.229606418037e+02
RAMB11036 nd11036 0 3.400833583881e+05
RAMB11066 nd11066 0 6.229606418037e+02
RAMB11067 nd11067 0 6.738427031921e+04
RAMB11097 nd11097 0 1.234337030576e+02
RAMB11098 nd11098 0 6.738427031921e+04
RAMB11128 nd11128 0 1.234337030576e+02
RAMB11129 nd11129 0 6.738427031921e+04
RAMB11159 nd11159 0 1.234337030576e+02
RAMB11160 nd11160 0 4.953530016163e+05
RAMB11190 nd11190 0 9.073817234596e+02
RAMB11191 nd11191 0 5.173543131469e+04
RAMB11221 nd11221 0 9.476834632332e+01
RAMB11222 nd11222 0 5.173543131469e+04
RAMB11252 nd11252 0 9.476834632332e+01
RAMB11253 nd11253 0 5.173543131469e+04
RAMB11283 nd11283 0 9.476834632332e+01
RAMB11284 nd11284 0 5.173543131469e+04
RAMB11314 nd11314 0 9.476834632332e+01
RAMB11315 nd11315 0 5.173543131469e+04
RAMB11345 nd11345 0 9.476834632332e+01
RAMB11346 nd11346 0 5.173543131469e+04
RAMB11376 nd11376 0 9.476834632332e+01
RAMB11377 nd11377 0 4.953530016163e+05
RAMB11407 nd11407 0 9.073817234596e+02
RAMB11408 nd11408 0 5.173543131469e+04
RAMB11438 nd11438 0 9.476834632332e+01
RAMB11439 nd11439 0 5.173543131469e+04
RAMB11469 nd11469 0 9.476834632332e+01
RAMB11470 nd11470 0 5.173543131469e+04
RAMB11500 nd11500 0 9.476834632332e+01
RAMB11501 nd11501 0 5.173543131469e+04
RAMB11531 nd11531 0 9.476834632332e+01
RAMB11532 nd11532 0 5.173543131469e+04
RAMB11562 nd11562 0 9.476834632332e+01
RAMB11563 nd11563 0 5.173543131469e+04
RAMB11593 nd11593 0 9.476834632332e+01
RAMB11594 nd11594 0 4.953530016163e+05
RAMB11624 nd11624 0 9.073817234596e+02
RAMB11625 nd11625 0 6.738427031921e+04
RAMB11655 nd11655 0 1.234337030576e+02
RAMB11656 nd11656 0 6.738427031921e+04
RAMB11686 nd11686 0 1.234337030576e+02
RAMB11687 nd11687 0 6.738427031921e+04
RAMB11717 nd11717 0 1.234337030576e+02
IPWR19 0 nd19 DC 4.849776111614e-01
IPWR50 0 nd50 DC 4.849776111614e-01
IPWR81 0 nd81 DC 4.849776111614e-01
IPWR112 0 nd112 DC 6.597287657216e-02
IPWR143 0 nd143 DC 6.316727553887e-01
IPWR174 0 nd174 DC 6.316727553887e-01
IPWR205 0 nd205 DC 6.316727553887e-01
IPWR236 0 nd236 DC 6.316727553887e-01
IPWR267 0 nd267 DC 6.316727553887e-01
IPWR298 0 nd298 DC 6.316727553887e-01
IPWR329 0 nd329 DC 6.597287657216e-02
IPWR360 0 nd360 DC 6.316727553887e-01
IPWR391 0 nd391 DC 6.316727553887e-01
IPWR422 0 nd422 DC 6.316727553887e-01
IPWR453 0 nd453 DC 6.316727553887e-01
IPWR484 0 nd484 DC 6.316727553887e-01
IPWR515 0 nd515 DC 6.316727553887e-01
IPWR546 0 nd546 DC 6.597287657216e-02
IPWR577 0 nd577 DC 4.849776111614e-01
IPWR608 0 nd608 DC 4.849776111614e-01
IPWR639 0 nd639 DC 4.849776111614e-01
IPWR670 0 nd670 DC 9.609368301716e-02
IPWR701 0 nd701 DC 9.609368301716e-02
IPWR732 0 nd732 DC 9.609368301716e-02
IPWR763 0 nd763 DC 1.307189557447e-02
IPWR794 0 nd794 DC 1.251599251799e-01
IPWR825 0 nd825 DC 1.251599251799e-01
IPWR856 0 nd856 DC 1.251599251799e-01
IPWR887 0 nd887 DC 1.251599251799e-01
IPWR918 0 nd918 DC 1.251599251799e-01
IPWR949 0 nd949 DC 1.251599251799e-01
IPWR980 0 nd980 DC 1.307189557447e-02
IPWR1011 0 nd1011 DC 1.251599251799e-01
IPWR1042 0 nd1042 DC 1.251599251799e-01
IPWR1073 0 nd1073 DC 1.251599251799e-01
IPWR1104 0 nd1104 DC 1.251599251799e-01
IPWR1135 0 nd1135 DC 1.251599251799e-01
IPWR1166 0 nd1166 DC 1.251599251799e-01
IPWR1197 0 nd1197 DC 1.307189557447e-02
IPWR1228 0 nd1228 DC 9.609368301716e-02
IPWR1259 0 nd1259 DC 9.609368301716e-02
IPWR1290 0 nd1290 DC 9.609368301716e-02
IPWR1321 0 nd1321 DC 9.081105291039e-01
IPWR1352 0 nd1352 DC 9.081105291039e-01
IPWR1383 0 nd1383 DC 9.081105291039e-01
IPWR1414 0 nd1414 DC 1.235328445513e-01
IPWR1434 0 nd1434 DC 4.166666666667e-02
IPWR1435 0 nd1435 DC 2.083333333333e-02
IPWR1436 0 nd1436 DC 2.083333333333e-02
IPWR1437 0 nd1437 DC 2.083333333333e-02
IPWR1438 0 nd1438 DC 2.083333333333e-02
IPWR1439 0 nd1439 DC 2.083333333333e-02
IPWR1440 0 nd1440 DC 2.083333333333e-02
IPWR1441 0 nd1441 DC 2.083333333333e-02
IPWR1442 0 nd1442 DC 1.041666666667e-02
IPWR1443 0 nd1443 DC 1.041666666667e-02
IPWR1445 0 nd1445 DC 1.182794147431e+00
IPWR1465 0 nd1465 DC 4.166666666667e-02
IPWR1466 0 nd1466 DC 2.083333333333e-02
IPWR1467 0 nd1467 DC 2.083333333333e-02
IPWR1468 0 nd1468 DC 2.083333333333e-02
IPWR1469 0 nd1469 DC 2.083333333333e-02
IPWR1470 0 nd1470 DC 2.083333333333e-02
IPWR1471 0 nd1471 DC 2.083333333333e-02
IPWR1472 0 nd1472 DC 2.083333333333e-02
IPWR1473 0 nd1473 DC 1.041666666667e-02
IPWR1474 0 nd1474 DC 1.041666666667e-02
IPWR1476 0 nd1476 DC 1.182794147431e+00
IPWR1496 0 nd1496 DC 4.166666666667e-02
IPWR1497 0 nd1497 DC 2.083333333333e-02
IPWR1498 0 nd1498 DC 2.083333333333e-02
IPWR1499 0 nd1499 DC 2.083333333333e-02
IPWR1500 0 nd1500 DC 2.083333333333e-02
IPWR1501 0 nd1501 DC 2.083333333333e-02
IPWR1502 0 nd1502 DC 2.083333333333e-02
IPWR1503 0 nd1503 DC 2.083333333333e-02
IPWR1504 0 nd1504 DC 1.041666666667e-02
IPWR1505 0 nd1505 DC 1.041666666667e-02
IPWR1507 0 nd1507 DC 1.182794147431e+00
IPWR1527 0 nd1527 DC 4.166666666667e-02
IPWR1528 0 nd1528 DC 2.083333333333e-02
IPWR1529 0 nd1529 DC 2.083333333333e-02
IPWR1530 0 nd1530 DC 2.083333333333e-02
IPWR1531 0 nd1531 DC 2.083333333333e-02
IPWR1532 0 nd1532 DC 2.083333333333e-02
IPWR1533 0 nd1533 DC 2.083333333333e-02
IPWR1534 0 nd1534 DC 2.083333333333e-02
IPWR1535 0 nd1535 DC 1.041666666667e-02
IPWR1536 0 nd1536 DC 1.041666666667e-02
IPWR1538 0 nd1538 DC 1.182794147431e+00
IPWR1558 0 nd1558 DC 4.166666666667e-02
IPWR1559 0 nd1559 DC 2.083333333333e-02
IPWR1560 0 nd1560 DC 2.083333333333e-02
IPWR1561 0 nd1561 DC 2.083333333333e-02
IPWR1562 0 nd1562 DC 2.083333333333e-02
IPWR1563 0 nd1563 DC 2.083333333333e-02
IPWR1564 0 nd1564 DC 2.083333333333e-02
IPWR1565 0 nd1565 DC 2.083333333333e-02
IPWR1566 0 nd1566 DC 1.041666666667e-02
IPWR1567 0 nd1567 DC 1.041666666667e-02
IPWR1569 0 nd1569 DC 1.182794147431e+00
IPWR1589 0 nd1589 DC 4.166666666667e-02
IPWR1590 0 nd1590 DC 2.083333333333e-02
IPWR1591 0 nd1591 DC 2.083333333333e-02
IPWR1592 0 nd1592 DC 2.083333333333e-02
IPWR1593 0 nd1593 DC 2.083333333333e-02
IPWR1594 0 nd1594 DC 2.083333333333e-02
IPWR1595 0 nd1595 DC 2.083333333333e-02
IPWR1596 0 nd1596 DC 2.083333333333e-02
IPWR1597 0 nd1597 DC 1.041666666667e-02
IPWR1598 0 nd1598 DC 1.041666666667e-02
IPWR1600 0 nd1600 DC 1.182794147431e+00
IPWR1631 0 nd1631 DC 1.235328445513e-01
IPWR1651 0 nd1651 DC 4.166666666667e-02
IPWR1652 0 nd1652 DC 2.083333333333e-02
IPWR1653 0 nd1653 DC 2.083333333333e-02
IPWR1654 0 nd1654 DC 2.083333333333e-02
IPWR1655 0 nd1655 DC 2.083333333333e-02
IPWR1656 0 nd1656 DC 2.083333333333e-02
IPWR1657 0 nd1657 DC 2.083333333333e-02
IPWR1658 0 nd1658 DC 2.083333333333e-02
IPWR1659 0 nd1659 DC 1.041666666667e-02
IPWR1660 0 nd1660 DC 1.041666666667e-02
IPWR1662 0 nd1662 DC 1.182794147431e+00
IPWR1682 0 nd1682 DC 4.166666666667e-02
IPWR1683 0 nd1683 DC 2.083333333333e-02
IPWR1684 0 nd1684 DC 2.083333333333e-02
IPWR1685 0 nd1685 DC 2.083333333333e-02
IPWR1686 0 nd1686 DC 2.083333333333e-02
IPWR1687 0 nd1687 DC 2.083333333333e-02
IPWR1688 0 nd1688 DC 2.083333333333e-02
IPWR1689 0 nd1689 DC 2.083333333333e-02
IPWR1690 0 nd1690 DC 1.041666666667e-02
IPWR1691 0 nd1691 DC 1.041666666667e-02
IPWR1693 0 nd1693 DC 1.182794147431e+00
IPWR1713 0 nd1713 DC 4.166666666667e-02
IPWR1714 0 nd1714 DC 2.083333333333e-02
IPWR1715 0 nd1715 DC 2.083333333333e-02
IPWR1716 0 nd1716 DC 2.083333333333e-02
IPWR1717 0 nd1717 DC 2.083333333333e-02
IPWR1718 0 nd1718 DC 2.083333333333e-02
IPWR1719 0 nd1719 DC 2.083333333333e-02
IPWR1720 0 nd1720 DC 2.083333333333e-02
IPWR1721 0 nd1721 DC 1.041666666667e-02
IPWR1722 0 nd1722 DC 1.041666666667e-02
IPWR1724 0 nd1724 DC 1.182794147431e+00
IPWR1744 0 nd1744 DC 4.166666666667e-02
IPWR1745 0 nd1745 DC 2.083333333333e-02
IPWR1746 0 nd1746 DC 2.083333333333e-02
IPWR1747 0 nd1747 DC 2.083333333333e-02
IPWR1748 0 nd1748 DC 2.083333333333e-02
IPWR1749 0 nd1749 DC 2.083333333333e-02
IPWR1750 0 nd1750 DC 2.083333333333e-02
IPWR1751 0 nd1751 DC 2.083333333333e-02
IPWR1752 0 nd1752 DC 1.041666666667e-02
IPWR1753 0 nd1753 DC 1.041666666667e-02
IPWR1755 0 nd1755 DC 1.182794147431e+00
IPWR1775 0 nd1775 DC 4.166666666667e-02
IPWR1776 0 nd1776 DC 2.083333333333e-02
IPWR1777 0 nd1777 DC 2.083333333333e-02
IPWR1778 0 nd1778 DC 2.083333333333e-02
IPWR1779 0 nd1779 DC 2.083333333333e-02
IPWR1780 0 nd1780 DC 2.083333333333e-02
IPWR1781 0 nd1781 DC 2.083333333333e-02
IPWR1782 0 nd1782 DC 2.083333333333e-02
IPWR1783 0 nd1783 DC 1.041666666667e-02
IPWR1784 0 nd1784 DC 1.041666666667e-02
IPWR1786 0 nd1786 DC 1.182794147431e+00
IPWR1806 0 nd1806 DC 4.166666666667e-02
IPWR1807 0 nd1807 DC 2.083333333333e-02
IPWR1808 0 nd1808 DC 2.083333333333e-02
IPWR1809 0 nd1809 DC 2.083333333333e-02
IPWR1810 0 nd1810 DC 2.083333333333e-02
IPWR1811 0 nd1811 DC 2.083333333333e-02
IPWR1812 0 nd1812 DC 2.083333333333e-02
IPWR1813 0 nd1813 DC 2.083333333333e-02
IPWR1814 0 nd1814 DC 1.041666666667e-02
IPWR1815 0 nd1815 DC 1.041666666667e-02
IPWR1817 0 nd1817 DC 1.182794147431e+00
IPWR1848 0 nd1848 DC 1.235328445513e-01
IPWR1879 0 nd1879 DC 9.081105291039e-01
IPWR1910 0 nd1910 DC 9.081105291039e-01
IPWR1941 0 nd1941 DC 9.081105291039e-01
IPWR1972 0 nd1972 DC 9.081105291039e-01
IPWR2003 0 nd2003 DC 9.081105291039e-01
IPWR2034 0 nd2034 DC 9.081105291039e-01
IPWR2065 0 nd2065 DC 1.235328445513e-01
IPWR2085 0 nd2085 DC 4.166666666667e-02
IPWR2086 0 nd2086 DC 2.083333333333e-02
IPWR2087 0 nd2087 DC 2.083333333333e-02
IPWR2088 0 nd2088 DC 2.083333333333e-02
IPWR2089 0 nd2089 DC 2.083333333333e-02
IPWR2090 0 nd2090 DC 2.083333333333e-02
IPWR2091 0 nd2091 DC 2.083333333333e-02
IPWR2092 0 nd2092 DC 2.083333333333e-02
IPWR2093 0 nd2093 DC 1.041666666667e-02
IPWR2094 0 nd2094 DC 1.041666666667e-02
IPWR2096 0 nd2096 DC 1.182794147431e+00
IPWR2116 0 nd2116 DC 4.166666666667e-02
IPWR2117 0 nd2117 DC 2.083333333333e-02
IPWR2118 0 nd2118 DC 2.083333333333e-02
IPWR2119 0 nd2119 DC 2.083333333333e-02
IPWR2120 0 nd2120 DC 2.083333333333e-02
IPWR2121 0 nd2121 DC 2.083333333333e-02
IPWR2122 0 nd2122 DC 2.083333333333e-02
IPWR2123 0 nd2123 DC 2.083333333333e-02
IPWR2124 0 nd2124 DC 1.041666666667e-02
IPWR2125 0 nd2125 DC 1.041666666667e-02
IPWR2127 0 nd2127 DC 1.182794147431e+00
IPWR2147 0 nd2147 DC 4.166666666667e-02
IPWR2148 0 nd2148 DC 2.083333333333e-02
IPWR2149 0 nd2149 DC 2.083333333333e-02
IPWR2150 0 nd2150 DC 2.083333333333e-02
IPWR2151 0 nd2151 DC 2.083333333333e-02
IPWR2152 0 nd2152 DC 2.083333333333e-02
IPWR2153 0 nd2153 DC 2.083333333333e-02
IPWR2154 0 nd2154 DC 2.083333333333e-02
IPWR2155 0 nd2155 DC 1.041666666667e-02
IPWR2156 0 nd2156 DC 1.041666666667e-02
IPWR2158 0 nd2158 DC 1.182794147431e+00
IPWR2178 0 nd2178 DC 4.166666666667e-02
IPWR2179 0 nd2179 DC 2.083333333333e-02
IPWR2180 0 nd2180 DC 2.083333333333e-02
IPWR2181 0 nd2181 DC 2.083333333333e-02
IPWR2182 0 nd2182 DC 2.083333333333e-02
IPWR2183 0 nd2183 DC 2.083333333333e-02
IPWR2184 0 nd2184 DC 2.083333333333e-02
IPWR2185 0 nd2185 DC 2.083333333333e-02
IPWR2186 0 nd2186 DC 1.041666666667e-02
IPWR2187 0 nd2187 DC 1.041666666667e-02
IPWR2189 0 nd2189 DC 1.182794147431e+00
IPWR2209 0 nd2209 DC 4.166666666667e-02
IPWR2210 0 nd2210 DC 2.083333333333e-02
IPWR2211 0 nd2211 DC 2.083333333333e-02
IPWR2212 0 nd2212 DC 2.083333333333e-02
IPWR2213 0 nd2213 DC 2.083333333333e-02
IPWR2214 0 nd2214 DC 2.083333333333e-02
IPWR2215 0 nd2215 DC 2.083333333333e-02
IPWR2216 0 nd2216 DC 2.083333333333e-02
IPWR2217 0 nd2217 DC 1.041666666667e-02
IPWR2218 0 nd2218 DC 1.041666666667e-02
IPWR2220 0 nd2220 DC 1.182794147431e+00
IPWR2240 0 nd2240 DC 4.166666666667e-02
IPWR2241 0 nd2241 DC 2.083333333333e-02
IPWR2242 0 nd2242 DC 2.083333333333e-02
IPWR2243 0 nd2243 DC 2.083333333333e-02
IPWR2244 0 nd2244 DC 2.083333333333e-02
IPWR2245 0 nd2245 DC 2.083333333333e-02
IPWR2246 0 nd2246 DC 2.083333333333e-02
IPWR2247 0 nd2247 DC 2.083333333333e-02
IPWR2248 0 nd2248 DC 1.041666666667e-02
IPWR2249 0 nd2249 DC 1.041666666667e-02
IPWR2251 0 nd2251 DC 1.182794147431e+00
IPWR2282 0 nd2282 DC 1.235328445513e-01
IPWR2302 0 nd2302 DC 4.166666666667e-02
IPWR2303 0 nd2303 DC 2.083333333333e-02
IPWR2304 0 nd2304 DC 2.083333333333e-02
IPWR2305 0 nd2305 DC 2.083333333333e-02
IPWR2306 0 nd2306 DC 2.083333333333e-02
IPWR2307 0 nd2307 DC 2.083333333333e-02
IPWR2308 0 nd2308 DC 2.083333333333e-02
IPWR2309 0 nd2309 DC 2.083333333333e-02
IPWR2310 0 nd2310 DC 1.041666666667e-02
IPWR2311 0 nd2311 DC 1.041666666667e-02
IPWR2313 0 nd2313 DC 1.182794147431e+00
IPWR2333 0 nd2333 DC 4.166666666667e-02
IPWR2334 0 nd2334 DC 2.083333333333e-02
IPWR2335 0 nd2335 DC 2.083333333333e-02
IPWR2336 0 nd2336 DC 2.083333333333e-02
IPWR2337 0 nd2337 DC 2.083333333333e-02
IPWR2338 0 nd2338 DC 2.083333333333e-02
IPWR2339 0 nd2339 DC 2.083333333333e-02
IPWR2340 0 nd2340 DC 2.083333333333e-02
IPWR2341 0 nd2341 DC 1.041666666667e-02
IPWR2342 0 nd2342 DC 1.041666666667e-02
IPWR2344 0 nd2344 DC 1.182794147431e+00
IPWR2364 0 nd2364 DC 4.166666666667e-02
IPWR2365 0 nd2365 DC 2.083333333333e-02
IPWR2366 0 nd2366 DC 2.083333333333e-02
IPWR2367 0 nd2367 DC 2.083333333333e-02
IPWR2368 0 nd2368 DC 2.083333333333e-02
IPWR2369 0 nd2369 DC 2.083333333333e-02
IPWR2370 0 nd2370 DC 2.083333333333e-02
IPWR2371 0 nd2371 DC 2.083333333333e-02
IPWR2372 0 nd2372 DC 1.041666666667e-02
IPWR2373 0 nd2373 DC 1.041666666667e-02
IPWR2375 0 nd2375 DC 1.182794147431e+00
IPWR2395 0 nd2395 DC 4.166666666667e-02
IPWR2396 0 nd2396 DC 2.083333333333e-02
IPWR2397 0 nd2397 DC 2.083333333333e-02
IPWR2398 0 nd2398 DC 2.083333333333e-02
IPWR2399 0 nd2399 DC 2.083333333333e-02
IPWR2400 0 nd2400 DC 2.083333333333e-02
IPWR2401 0 nd2401 DC 2.083333333333e-02
IPWR2402 0 nd2402 DC 2.083333333333e-02
IPWR2403 0 nd2403 DC 1.041666666667e-02
IPWR2404 0 nd2404 DC 1.041666666667e-02
IPWR2406 0 nd2406 DC 1.182794147431e+00
IPWR2426 0 nd2426 DC 4.166666666667e-02
IPWR2427 0 nd2427 DC 2.083333333333e-02
IPWR2428 0 nd2428 DC 2.083333333333e-02
IPWR2429 0 nd2429 DC 2.083333333333e-02
IPWR2430 0 nd2430 DC 2.083333333333e-02
IPWR2431 0 nd2431 DC 2.083333333333e-02
IPWR2432 0 nd2432 DC 2.083333333333e-02
IPWR2433 0 nd2433 DC 2.083333333333e-02
IPWR2434 0 nd2434 DC 1.041666666667e-02
IPWR2435 0 nd2435 DC 1.041666666667e-02
IPWR2437 0 nd2437 DC 1.182794147431e+00
IPWR2457 0 nd2457 DC 4.166666666667e-02
IPWR2458 0 nd2458 DC 2.083333333333e-02
IPWR2459 0 nd2459 DC 2.083333333333e-02
IPWR2460 0 nd2460 DC 2.083333333333e-02
IPWR2461 0 nd2461 DC 2.083333333333e-02
IPWR2462 0 nd2462 DC 2.083333333333e-02
IPWR2463 0 nd2463 DC 2.083333333333e-02
IPWR2464 0 nd2464 DC 2.083333333333e-02
IPWR2465 0 nd2465 DC 1.041666666667e-02
IPWR2466 0 nd2466 DC 1.041666666667e-02
IPWR2468 0 nd2468 DC 1.182794147431e+00
IPWR2499 0 nd2499 DC 1.235328445513e-01
IPWR2530 0 nd2530 DC 9.081105291039e-01
IPWR2561 0 nd2561 DC 9.081105291039e-01
IPWR2592 0 nd2592 DC 9.081105291039e-01
IPWR2623 0 nd2623 DC 9.081105291039e-01
IPWR2654 0 nd2654 DC 9.081105291039e-01
IPWR2685 0 nd2685 DC 9.081105291039e-01
IPWR2716 0 nd2716 DC 1.235328445513e-01
IPWR2736 0 nd2736 DC 4.166666666667e-02
IPWR2737 0 nd2737 DC 2.083333333333e-02
IPWR2738 0 nd2738 DC 2.083333333333e-02
IPWR2739 0 nd2739 DC 2.083333333333e-02
IPWR2740 0 nd2740 DC 2.083333333333e-02
IPWR2741 0 nd2741 DC 2.083333333333e-02
IPWR2742 0 nd2742 DC 2.083333333333e-02
IPWR2743 0 nd2743 DC 2.083333333333e-02
IPWR2744 0 nd2744 DC 1.041666666667e-02
IPWR2745 0 nd2745 DC 1.041666666667e-02
IPWR2747 0 nd2747 DC 1.182794147431e+00
IPWR2767 0 nd2767 DC 4.166666666667e-02
IPWR2768 0 nd2768 DC 2.083333333333e-02
IPWR2769 0 nd2769 DC 2.083333333333e-02
IPWR2770 0 nd2770 DC 2.083333333333e-02
IPWR2771 0 nd2771 DC 2.083333333333e-02
IPWR2772 0 nd2772 DC 2.083333333333e-02
IPWR2773 0 nd2773 DC 2.083333333333e-02
IPWR2774 0 nd2774 DC 2.083333333333e-02
IPWR2775 0 nd2775 DC 1.041666666667e-02
IPWR2776 0 nd2776 DC 1.041666666667e-02
IPWR2778 0 nd2778 DC 1.182794147431e+00
IPWR2798 0 nd2798 DC 4.166666666667e-02
IPWR2799 0 nd2799 DC 2.083333333333e-02
IPWR2800 0 nd2800 DC 2.083333333333e-02
IPWR2801 0 nd2801 DC 2.083333333333e-02
IPWR2802 0 nd2802 DC 2.083333333333e-02
IPWR2803 0 nd2803 DC 2.083333333333e-02
IPWR2804 0 nd2804 DC 2.083333333333e-02
IPWR2805 0 nd2805 DC 2.083333333333e-02
IPWR2806 0 nd2806 DC 1.041666666667e-02
IPWR2807 0 nd2807 DC 1.041666666667e-02
IPWR2809 0 nd2809 DC 1.182794147431e+00
IPWR2829 0 nd2829 DC 4.166666666667e-02
IPWR2830 0 nd2830 DC 2.083333333333e-02
IPWR2831 0 nd2831 DC 2.083333333333e-02
IPWR2832 0 nd2832 DC 2.083333333333e-02
IPWR2833 0 nd2833 DC 2.083333333333e-02
IPWR2834 0 nd2834 DC 2.083333333333e-02
IPWR2835 0 nd2835 DC 2.083333333333e-02
IPWR2836 0 nd2836 DC 2.083333333333e-02
IPWR2837 0 nd2837 DC 1.041666666667e-02
IPWR2838 0 nd2838 DC 1.041666666667e-02
IPWR2840 0 nd2840 DC 1.182794147431e+00
IPWR2860 0 nd2860 DC 4.166666666667e-02
IPWR2861 0 nd2861 DC 2.083333333333e-02
IPWR2862 0 nd2862 DC 2.083333333333e-02
IPWR2863 0 nd2863 DC 2.083333333333e-02
IPWR2864 0 nd2864 DC 2.083333333333e-02
IPWR2865 0 nd2865 DC 2.083333333333e-02
IPWR2866 0 nd2866 DC 2.083333333333e-02
IPWR2867 0 nd2867 DC 2.083333333333e-02
IPWR2868 0 nd2868 DC 1.041666666667e-02
IPWR2869 0 nd2869 DC 1.041666666667e-02
IPWR2871 0 nd2871 DC 1.182794147431e+00
IPWR2891 0 nd2891 DC 4.166666666667e-02
IPWR2892 0 nd2892 DC 2.083333333333e-02
IPWR2893 0 nd2893 DC 2.083333333333e-02
IPWR2894 0 nd2894 DC 2.083333333333e-02
IPWR2895 0 nd2895 DC 2.083333333333e-02
IPWR2896 0 nd2896 DC 2.083333333333e-02
IPWR2897 0 nd2897 DC 2.083333333333e-02
IPWR2898 0 nd2898 DC 2.083333333333e-02
IPWR2899 0 nd2899 DC 1.041666666667e-02
IPWR2900 0 nd2900 DC 1.041666666667e-02
IPWR2902 0 nd2902 DC 1.182794147431e+00
IPWR2933 0 nd2933 DC 1.235328445513e-01
IPWR2953 0 nd2953 DC 4.166666666667e-02
IPWR2954 0 nd2954 DC 2.083333333333e-02
IPWR2955 0 nd2955 DC 2.083333333333e-02
IPWR2956 0 nd2956 DC 2.083333333333e-02
IPWR2957 0 nd2957 DC 2.083333333333e-02
IPWR2958 0 nd2958 DC 2.083333333333e-02
IPWR2959 0 nd2959 DC 2.083333333333e-02
IPWR2960 0 nd2960 DC 2.083333333333e-02
IPWR2961 0 nd2961 DC 1.041666666667e-02
IPWR2962 0 nd2962 DC 1.041666666667e-02
IPWR2964 0 nd2964 DC 1.182794147431e+00
IPWR2984 0 nd2984 DC 4.166666666667e-02
IPWR2985 0 nd2985 DC 2.083333333333e-02
IPWR2986 0 nd2986 DC 2.083333333333e-02
IPWR2987 0 nd2987 DC 2.083333333333e-02
IPWR2988 0 nd2988 DC 2.083333333333e-02
IPWR2989 0 nd2989 DC 2.083333333333e-02
IPWR2990 0 nd2990 DC 2.083333333333e-02
IPWR2991 0 nd2991 DC 2.083333333333e-02
IPWR2992 0 nd2992 DC 1.041666666667e-02
IPWR2993 0 nd2993 DC 1.041666666667e-02
IPWR2995 0 nd2995 DC 1.182794147431e+00
IPWR3015 0 nd3015 DC 4.166666666667e-02
IPWR3016 0 nd3016 DC 2.083333333333e-02
IPWR3017 0 nd3017 DC 2.083333333333e-02
IPWR3018 0 nd3018 DC 2.083333333333e-02
IPWR3019 0 nd3019 DC 2.083333333333e-02
IPWR3020 0 nd3020 DC 2.083333333333e-02
IPWR3021 0 nd3021 DC 2.083333333333e-02
IPWR3022 0 nd3022 DC 2.083333333333e-02
IPWR3023 0 nd3023 DC 1.041666666667e-02
IPWR3024 0 nd3024 DC 1.041666666667e-02
IPWR3026 0 nd3026 DC 1.182794147431e+00
IPWR3046 0 nd3046 DC 4.166666666667e-02
IPWR3047 0 nd3047 DC 2.083333333333e-02
IPWR3048 0 nd3048 DC 2.083333333333e-02
IPWR3049 0 nd3049 DC 2.083333333333e-02
IPWR3050 0 nd3050 DC 2.083333333333e-02
IPWR3051 0 nd3051 DC 2.083333333333e-02
IPWR3052 0 nd3052 DC 2.083333333333e-02
IPWR3053 0 nd3053 DC 2.083333333333e-02
IPWR3054 0 nd3054 DC 1.041666666667e-02
IPWR3055 0 nd3055 DC 1.041666666667e-02
IPWR3057 0 nd3057 DC 1.182794147431e+00
IPWR3077 0 nd3077 DC 4.166666666667e-02
IPWR3078 0 nd3078 DC 2.083333333333e-02
IPWR3079 0 nd3079 DC 2.083333333333e-02
IPWR3080 0 nd3080 DC 2.083333333333e-02
IPWR3081 0 nd3081 DC 2.083333333333e-02
IPWR3082 0 nd3082 DC 2.083333333333e-02
IPWR3083 0 nd3083 DC 2.083333333333e-02
IPWR3084 0 nd3084 DC 2.083333333333e-02
IPWR3085 0 nd3085 DC 1.041666666667e-02
IPWR3086 0 nd3086 DC 1.041666666667e-02
IPWR3088 0 nd3088 DC 1.182794147431e+00
IPWR3108 0 nd3108 DC 4.166666666667e-02
IPWR3109 0 nd3109 DC 2.083333333333e-02
IPWR3110 0 nd3110 DC 2.083333333333e-02
IPWR3111 0 nd3111 DC 2.083333333333e-02
IPWR3112 0 nd3112 DC 2.083333333333e-02
IPWR3113 0 nd3113 DC 2.083333333333e-02
IPWR3114 0 nd3114 DC 2.083333333333e-02
IPWR3115 0 nd3115 DC 2.083333333333e-02
IPWR3116 0 nd3116 DC 1.041666666667e-02
IPWR3117 0 nd3117 DC 1.041666666667e-02
IPWR3119 0 nd3119 DC 1.182794147431e+00
IPWR3150 0 nd3150 DC 1.235328445513e-01
IPWR3181 0 nd3181 DC 9.081105291039e-01
IPWR3212 0 nd3212 DC 9.081105291039e-01
IPWR3243 0 nd3243 DC 9.081105291039e-01
IPWR3274 0 nd3274 DC 9.081105291039e-01
IPWR3305 0 nd3305 DC 9.081105291039e-01
IPWR3336 0 nd3336 DC 9.081105291039e-01
IPWR3367 0 nd3367 DC 1.235328445513e-01
IPWR3387 0 nd3387 DC 4.166666666667e-02
IPWR3388 0 nd3388 DC 2.083333333333e-02
IPWR3389 0 nd3389 DC 2.083333333333e-02
IPWR3390 0 nd3390 DC 2.083333333333e-02
IPWR3391 0 nd3391 DC 2.083333333333e-02
IPWR3392 0 nd3392 DC 2.083333333333e-02
IPWR3393 0 nd3393 DC 2.083333333333e-02
IPWR3394 0 nd3394 DC 2.083333333333e-02
IPWR3395 0 nd3395 DC 1.041666666667e-02
IPWR3396 0 nd3396 DC 1.041666666667e-02
IPWR3398 0 nd3398 DC 1.182794147431e+00
IPWR3418 0 nd3418 DC 4.166666666667e-02
IPWR3419 0 nd3419 DC 2.083333333333e-02
IPWR3420 0 nd3420 DC 2.083333333333e-02
IPWR3421 0 nd3421 DC 2.083333333333e-02
IPWR3422 0 nd3422 DC 2.083333333333e-02
IPWR3423 0 nd3423 DC 2.083333333333e-02
IPWR3424 0 nd3424 DC 2.083333333333e-02
IPWR3425 0 nd3425 DC 2.083333333333e-02
IPWR3426 0 nd3426 DC 1.041666666667e-02
IPWR3427 0 nd3427 DC 1.041666666667e-02
IPWR3429 0 nd3429 DC 1.182794147431e+00
IPWR3449 0 nd3449 DC 4.166666666667e-02
IPWR3450 0 nd3450 DC 2.083333333333e-02
IPWR3451 0 nd3451 DC 2.083333333333e-02
IPWR3452 0 nd3452 DC 2.083333333333e-02
IPWR3453 0 nd3453 DC 2.083333333333e-02
IPWR3454 0 nd3454 DC 2.083333333333e-02
IPWR3455 0 nd3455 DC 2.083333333333e-02
IPWR3456 0 nd3456 DC 2.083333333333e-02
IPWR3457 0 nd3457 DC 1.041666666667e-02
IPWR3458 0 nd3458 DC 1.041666666667e-02
IPWR3460 0 nd3460 DC 1.182794147431e+00
IPWR3480 0 nd3480 DC 4.166666666667e-02
IPWR3481 0 nd3481 DC 2.083333333333e-02
IPWR3482 0 nd3482 DC 2.083333333333e-02
IPWR3483 0 nd3483 DC 2.083333333333e-02
IPWR3484 0 nd3484 DC 2.083333333333e-02
IPWR3485 0 nd3485 DC 2.083333333333e-02
IPWR3486 0 nd3486 DC 2.083333333333e-02
IPWR3487 0 nd3487 DC 2.083333333333e-02
IPWR3488 0 nd3488 DC 1.041666666667e-02
IPWR3489 0 nd3489 DC 1.041666666667e-02
IPWR3491 0 nd3491 DC 1.182794147431e+00
IPWR3511 0 nd3511 DC 4.166666666667e-02
IPWR3512 0 nd3512 DC 2.083333333333e-02
IPWR3513 0 nd3513 DC 2.083333333333e-02
IPWR3514 0 nd3514 DC 2.083333333333e-02
IPWR3515 0 nd3515 DC 2.083333333333e-02
IPWR3516 0 nd3516 DC 2.083333333333e-02
IPWR3517 0 nd3517 DC 2.083333333333e-02
IPWR3518 0 nd3518 DC 2.083333333333e-02
IPWR3519 0 nd3519 DC 1.041666666667e-02
IPWR3520 0 nd3520 DC 1.041666666667e-02
IPWR3522 0 nd3522 DC 1.182794147431e+00
IPWR3542 0 nd3542 DC 4.166666666667e-02
IPWR3543 0 nd3543 DC 2.083333333333e-02
IPWR3544 0 nd3544 DC 2.083333333333e-02
IPWR3545 0 nd3545 DC 2.083333333333e-02
IPWR3546 0 nd3546 DC 2.083333333333e-02
IPWR3547 0 nd3547 DC 2.083333333333e-02
IPWR3548 0 nd3548 DC 2.083333333333e-02
IPWR3549 0 nd3549 DC 2.083333333333e-02
IPWR3550 0 nd3550 DC 1.041666666667e-02
IPWR3551 0 nd3551 DC 1.041666666667e-02
IPWR3553 0 nd3553 DC 1.182794147431e+00
IPWR3584 0 nd3584 DC 1.235328445513e-01
IPWR3604 0 nd3604 DC 4.166666666667e-02
IPWR3605 0 nd3605 DC 2.083333333333e-02
IPWR3606 0 nd3606 DC 2.083333333333e-02
IPWR3607 0 nd3607 DC 2.083333333333e-02
IPWR3608 0 nd3608 DC 2.083333333333e-02
IPWR3609 0 nd3609 DC 2.083333333333e-02
IPWR3610 0 nd3610 DC 2.083333333333e-02
IPWR3611 0 nd3611 DC 2.083333333333e-02
IPWR3612 0 nd3612 DC 1.041666666667e-02
IPWR3613 0 nd3613 DC 1.041666666667e-02
IPWR3615 0 nd3615 DC 1.182794147431e+00
IPWR3635 0 nd3635 DC 4.166666666667e-02
IPWR3636 0 nd3636 DC 2.083333333333e-02
IPWR3637 0 nd3637 DC 2.083333333333e-02
IPWR3638 0 nd3638 DC 2.083333333333e-02
IPWR3639 0 nd3639 DC 2.083333333333e-02
IPWR3640 0 nd3640 DC 2.083333333333e-02
IPWR3641 0 nd3641 DC 2.083333333333e-02
IPWR3642 0 nd3642 DC 2.083333333333e-02
IPWR3643 0 nd3643 DC 1.041666666667e-02
IPWR3644 0 nd3644 DC 1.041666666667e-02
IPWR3646 0 nd3646 DC 1.182794147431e+00
IPWR3666 0 nd3666 DC 4.166666666667e-02
IPWR3667 0 nd3667 DC 2.083333333333e-02
IPWR3668 0 nd3668 DC 2.083333333333e-02
IPWR3669 0 nd3669 DC 2.083333333333e-02
IPWR3670 0 nd3670 DC 2.083333333333e-02
IPWR3671 0 nd3671 DC 2.083333333333e-02
IPWR3672 0 nd3672 DC 2.083333333333e-02
IPWR3673 0 nd3673 DC 2.083333333333e-02
IPWR3674 0 nd3674 DC 1.041666666667e-02
IPWR3675 0 nd3675 DC 1.041666666667e-02
IPWR3677 0 nd3677 DC 1.182794147431e+00
IPWR3697 0 nd3697 DC 4.166666666667e-02
IPWR3698 0 nd3698 DC 2.083333333333e-02
IPWR3699 0 nd3699 DC 2.083333333333e-02
IPWR3700 0 nd3700 DC 2.083333333333e-02
IPWR3701 0 nd3701 DC 2.083333333333e-02
IPWR3702 0 nd3702 DC 2.083333333333e-02
IPWR3703 0 nd3703 DC 2.083333333333e-02
IPWR3704 0 nd3704 DC 2.083333333333e-02
IPWR3705 0 nd3705 DC 1.041666666667e-02
IPWR3706 0 nd3706 DC 1.041666666667e-02
IPWR3708 0 nd3708 DC 1.182794147431e+00
IPWR3728 0 nd3728 DC 4.166666666667e-02
IPWR3729 0 nd3729 DC 2.083333333333e-02
IPWR3730 0 nd3730 DC 2.083333333333e-02
IPWR3731 0 nd3731 DC 2.083333333333e-02
IPWR3732 0 nd3732 DC 2.083333333333e-02
IPWR3733 0 nd3733 DC 2.083333333333e-02
IPWR3734 0 nd3734 DC 2.083333333333e-02
IPWR3735 0 nd3735 DC 2.083333333333e-02
IPWR3736 0 nd3736 DC 1.041666666667e-02
IPWR3737 0 nd3737 DC 1.041666666667e-02
IPWR3739 0 nd3739 DC 1.182794147431e+00
IPWR3759 0 nd3759 DC 4.166666666667e-02
IPWR3760 0 nd3760 DC 2.083333333333e-02
IPWR3761 0 nd3761 DC 2.083333333333e-02
IPWR3762 0 nd3762 DC 2.083333333333e-02
IPWR3763 0 nd3763 DC 2.083333333333e-02
IPWR3764 0 nd3764 DC 2.083333333333e-02
IPWR3765 0 nd3765 DC 2.083333333333e-02
IPWR3766 0 nd3766 DC 2.083333333333e-02
IPWR3767 0 nd3767 DC 1.041666666667e-02
IPWR3768 0 nd3768 DC 1.041666666667e-02
IPWR3770 0 nd3770 DC 1.182794147431e+00
IPWR3801 0 nd3801 DC 1.235328445513e-01
IPWR3832 0 nd3832 DC 9.081105291039e-01
IPWR3863 0 nd3863 DC 9.081105291039e-01
IPWR3894 0 nd3894 DC 9.081105291039e-01
IPWR3925 0 nd3925 DC 9.609368301716e-02
IPWR3956 0 nd3956 DC 9.609368301716e-02
IPWR3987 0 nd3987 DC 9.609368301716e-02
IPWR4018 0 nd4018 DC 1.307189557447e-02
IPWR4049 0 nd4049 DC 1.251599251799e-01
IPWR4080 0 nd4080 DC 1.251599251799e-01
IPWR4111 0 nd4111 DC 1.251599251799e-01
IPWR4142 0 nd4142 DC 1.251599251799e-01
IPWR4173 0 nd4173 DC 1.251599251799e-01
IPWR4204 0 nd4204 DC 1.251599251799e-01
IPWR4235 0 nd4235 DC 1.307189557447e-02
IPWR4266 0 nd4266 DC 1.251599251799e-01
IPWR4297 0 nd4297 DC 1.251599251799e-01
IPWR4328 0 nd4328 DC 1.251599251799e-01
IPWR4359 0 nd4359 DC 1.251599251799e-01
IPWR4390 0 nd4390 DC 1.251599251799e-01
IPWR4421 0 nd4421 DC 1.251599251799e-01
IPWR4452 0 nd4452 DC 1.307189557447e-02
IPWR4483 0 nd4483 DC 9.609368301716e-02
IPWR4514 0 nd4514 DC 9.609368301716e-02
IPWR4545 0 nd4545 DC 9.609368301716e-02
IPWR4576 0 nd4576 DC 9.081105291039e-01
IPWR4607 0 nd4607 DC 9.081105291039e-01
IPWR4638 0 nd4638 DC 9.081105291039e-01
IPWR4669 0 nd4669 DC 1.235328445513e-01
IPWR4689 0 nd4689 DC 4.166666666667e-02
IPWR4690 0 nd4690 DC 2.083333333333e-02
IPWR4691 0 nd4691 DC 2.083333333333e-02
IPWR4692 0 nd4692 DC 2.083333333333e-02
IPWR4693 0 nd4693 DC 2.083333333333e-02
IPWR4694 0 nd4694 DC 2.083333333333e-02
IPWR4695 0 nd4695 DC 2.083333333333e-02
IPWR4696 0 nd4696 DC 2.083333333333e-02
IPWR4697 0 nd4697 DC 1.041666666667e-02
IPWR4698 0 nd4698 DC 1.041666666667e-02
IPWR4700 0 nd4700 DC 1.182794147431e+00
IPWR4720 0 nd4720 DC 4.166666666667e-02
IPWR4721 0 nd4721 DC 2.083333333333e-02
IPWR4722 0 nd4722 DC 2.083333333333e-02
IPWR4723 0 nd4723 DC 2.083333333333e-02
IPWR4724 0 nd4724 DC 2.083333333333e-02
IPWR4725 0 nd4725 DC 2.083333333333e-02
IPWR4726 0 nd4726 DC 2.083333333333e-02
IPWR4727 0 nd4727 DC 2.083333333333e-02
IPWR4728 0 nd4728 DC 1.041666666667e-02
IPWR4729 0 nd4729 DC 1.041666666667e-02
IPWR4731 0 nd4731 DC 1.182794147431e+00
IPWR4751 0 nd4751 DC 4.166666666667e-02
IPWR4752 0 nd4752 DC 2.083333333333e-02
IPWR4753 0 nd4753 DC 2.083333333333e-02
IPWR4754 0 nd4754 DC 2.083333333333e-02
IPWR4755 0 nd4755 DC 2.083333333333e-02
IPWR4756 0 nd4756 DC 2.083333333333e-02
IPWR4757 0 nd4757 DC 2.083333333333e-02
IPWR4758 0 nd4758 DC 2.083333333333e-02
IPWR4759 0 nd4759 DC 1.041666666667e-02
IPWR4760 0 nd4760 DC 1.041666666667e-02
IPWR4762 0 nd4762 DC 1.182794147431e+00
IPWR4782 0 nd4782 DC 4.166666666667e-02
IPWR4783 0 nd4783 DC 2.083333333333e-02
IPWR4784 0 nd4784 DC 2.083333333333e-02
IPWR4785 0 nd4785 DC 2.083333333333e-02
IPWR4786 0 nd4786 DC 2.083333333333e-02
IPWR4787 0 nd4787 DC 2.083333333333e-02
IPWR4788 0 nd4788 DC 2.083333333333e-02
IPWR4789 0 nd4789 DC 2.083333333333e-02
IPWR4790 0 nd4790 DC 1.041666666667e-02
IPWR4791 0 nd4791 DC 1.041666666667e-02
IPWR4793 0 nd4793 DC 1.182794147431e+00
IPWR4813 0 nd4813 DC 4.166666666667e-02
IPWR4814 0 nd4814 DC 2.083333333333e-02
IPWR4815 0 nd4815 DC 2.083333333333e-02
IPWR4816 0 nd4816 DC 2.083333333333e-02
IPWR4817 0 nd4817 DC 2.083333333333e-02
IPWR4818 0 nd4818 DC 2.083333333333e-02
IPWR4819 0 nd4819 DC 2.083333333333e-02
IPWR4820 0 nd4820 DC 2.083333333333e-02
IPWR4821 0 nd4821 DC 1.041666666667e-02
IPWR4822 0 nd4822 DC 1.041666666667e-02
IPWR4824 0 nd4824 DC 1.182794147431e+00
IPWR4844 0 nd4844 DC 4.166666666667e-02
IPWR4845 0 nd4845 DC 2.083333333333e-02
IPWR4846 0 nd4846 DC 2.083333333333e-02
IPWR4847 0 nd4847 DC 2.083333333333e-02
IPWR4848 0 nd4848 DC 2.083333333333e-02
IPWR4849 0 nd4849 DC 2.083333333333e-02
IPWR4850 0 nd4850 DC 2.083333333333e-02
IPWR4851 0 nd4851 DC 2.083333333333e-02
IPWR4852 0 nd4852 DC 1.041666666667e-02
IPWR4853 0 nd4853 DC 1.041666666667e-02
IPWR4855 0 nd4855 DC 1.182794147431e+00
IPWR4886 0 nd4886 DC 1.235328445513e-01
IPWR4906 0 nd4906 DC 4.166666666667e-02
IPWR4907 0 nd4907 DC 2.083333333333e-02
IPWR4908 0 nd4908 DC 2.083333333333e-02
IPWR4909 0 nd4909 DC 2.083333333333e-02
IPWR4910 0 nd4910 DC 2.083333333333e-02
IPWR4911 0 nd4911 DC 2.083333333333e-02
IPWR4912 0 nd4912 DC 2.083333333333e-02
IPWR4913 0 nd4913 DC 2.083333333333e-02
IPWR4914 0 nd4914 DC 1.041666666667e-02
IPWR4915 0 nd4915 DC 1.041666666667e-02
IPWR4917 0 nd4917 DC 1.182794147431e+00
IPWR4937 0 nd4937 DC 4.166666666667e-02
IPWR4938 0 nd4938 DC 2.083333333333e-02
IPWR4939 0 nd4939 DC 2.083333333333e-02
IPWR4940 0 nd4940 DC 2.083333333333e-02
IPWR4941 0 nd4941 DC 2.083333333333e-02
IPWR4942 0 nd4942 DC 2.083333333333e-02
IPWR4943 0 nd4943 DC 2.083333333333e-02
IPWR4944 0 nd4944 DC 2.083333333333e-02
IPWR4945 0 nd4945 DC 1.041666666667e-02
IPWR4946 0 nd4946 DC 1.041666666667e-02
IPWR4948 0 nd4948 DC 1.182794147431e+00
IPWR4968 0 nd4968 DC 4.166666666667e-02
IPWR4969 0 nd4969 DC 2.083333333333e-02
IPWR4970 0 nd4970 DC 2.083333333333e-02
IPWR4971 0 nd4971 DC 2.083333333333e-02
IPWR4972 0 nd4972 DC 2.083333333333e-02
IPWR4973 0 nd4973 DC 2.083333333333e-02
IPWR4974 0 nd4974 DC 2.083333333333e-02
IPWR4975 0 nd4975 DC 2.083333333333e-02
IPWR4976 0 nd4976 DC 1.041666666667e-02
IPWR4977 0 nd4977 DC 1.041666666667e-02
IPWR4979 0 nd4979 DC 1.182794147431e+00
IPWR4999 0 nd4999 DC 4.166666666667e-02
IPWR5000 0 nd5000 DC 2.083333333333e-02
IPWR5001 0 nd5001 DC 2.083333333333e-02
IPWR5002 0 nd5002 DC 2.083333333333e-02
IPWR5003 0 nd5003 DC 2.083333333333e-02
IPWR5004 0 nd5004 DC 2.083333333333e-02
IPWR5005 0 nd5005 DC 2.083333333333e-02
IPWR5006 0 nd5006 DC 2.083333333333e-02
IPWR5007 0 nd5007 DC 1.041666666667e-02
IPWR5008 0 nd5008 DC 1.041666666667e-02
IPWR5010 0 nd5010 DC 1.182794147431e+00
IPWR5030 0 nd5030 DC 4.166666666667e-02
IPWR5031 0 nd5031 DC 2.083333333333e-02
IPWR5032 0 nd5032 DC 2.083333333333e-02
IPWR5033 0 nd5033 DC 2.083333333333e-02
IPWR5034 0 nd5034 DC 2.083333333333e-02
IPWR5035 0 nd5035 DC 2.083333333333e-02
IPWR5036 0 nd5036 DC 2.083333333333e-02
IPWR5037 0 nd5037 DC 2.083333333333e-02
IPWR5038 0 nd5038 DC 1.041666666667e-02
IPWR5039 0 nd5039 DC 1.041666666667e-02
IPWR5041 0 nd5041 DC 1.182794147431e+00
IPWR5061 0 nd5061 DC 4.166666666667e-02
IPWR5062 0 nd5062 DC 2.083333333333e-02
IPWR5063 0 nd5063 DC 2.083333333333e-02
IPWR5064 0 nd5064 DC 2.083333333333e-02
IPWR5065 0 nd5065 DC 2.083333333333e-02
IPWR5066 0 nd5066 DC 2.083333333333e-02
IPWR5067 0 nd5067 DC 2.083333333333e-02
IPWR5068 0 nd5068 DC 2.083333333333e-02
IPWR5069 0 nd5069 DC 1.041666666667e-02
IPWR5070 0 nd5070 DC 1.041666666667e-02
IPWR5072 0 nd5072 DC 1.182794147431e+00
IPWR5103 0 nd5103 DC 1.235328445513e-01
IPWR5134 0 nd5134 DC 9.081105291039e-01
IPWR5165 0 nd5165 DC 9.081105291039e-01
IPWR5196 0 nd5196 DC 9.081105291039e-01
IPWR5227 0 nd5227 DC 9.081105291039e-01
IPWR5258 0 nd5258 DC 9.081105291039e-01
IPWR5289 0 nd5289 DC 9.081105291039e-01
IPWR5320 0 nd5320 DC 1.235328445513e-01
IPWR5340 0 nd5340 DC 4.166666666667e-02
IPWR5341 0 nd5341 DC 2.083333333333e-02
IPWR5342 0 nd5342 DC 2.083333333333e-02
IPWR5343 0 nd5343 DC 2.083333333333e-02
IPWR5344 0 nd5344 DC 2.083333333333e-02
IPWR5345 0 nd5345 DC 2.083333333333e-02
IPWR5346 0 nd5346 DC 2.083333333333e-02
IPWR5347 0 nd5347 DC 2.083333333333e-02
IPWR5348 0 nd5348 DC 1.041666666667e-02
IPWR5349 0 nd5349 DC 1.041666666667e-02
IPWR5351 0 nd5351 DC 1.182794147431e+00
IPWR5371 0 nd5371 DC 4.166666666667e-02
IPWR5372 0 nd5372 DC 2.083333333333e-02
IPWR5373 0 nd5373 DC 2.083333333333e-02
IPWR5374 0 nd5374 DC 2.083333333333e-02
IPWR5375 0 nd5375 DC 2.083333333333e-02
IPWR5376 0 nd5376 DC 2.083333333333e-02
IPWR5377 0 nd5377 DC 2.083333333333e-02
IPWR5378 0 nd5378 DC 2.083333333333e-02
IPWR5379 0 nd5379 DC 1.041666666667e-02
IPWR5380 0 nd5380 DC 1.041666666667e-02
IPWR5382 0 nd5382 DC 1.182794147431e+00
IPWR5402 0 nd5402 DC 4.166666666667e-02
IPWR5403 0 nd5403 DC 2.083333333333e-02
IPWR5404 0 nd5404 DC 2.083333333333e-02
IPWR5405 0 nd5405 DC 2.083333333333e-02
IPWR5406 0 nd5406 DC 2.083333333333e-02
IPWR5407 0 nd5407 DC 2.083333333333e-02
IPWR5408 0 nd5408 DC 2.083333333333e-02
IPWR5409 0 nd5409 DC 2.083333333333e-02
IPWR5410 0 nd5410 DC 1.041666666667e-02
IPWR5411 0 nd5411 DC 1.041666666667e-02
IPWR5413 0 nd5413 DC 1.182794147431e+00
IPWR5433 0 nd5433 DC 4.166666666667e-02
IPWR5434 0 nd5434 DC 2.083333333333e-02
IPWR5435 0 nd5435 DC 2.083333333333e-02
IPWR5436 0 nd5436 DC 2.083333333333e-02
IPWR5437 0 nd5437 DC 2.083333333333e-02
IPWR5438 0 nd5438 DC 2.083333333333e-02
IPWR5439 0 nd5439 DC 2.083333333333e-02
IPWR5440 0 nd5440 DC 2.083333333333e-02
IPWR5441 0 nd5441 DC 1.041666666667e-02
IPWR5442 0 nd5442 DC 1.041666666667e-02
IPWR5444 0 nd5444 DC 1.182794147431e+00
IPWR5464 0 nd5464 DC 4.166666666667e-02
IPWR5465 0 nd5465 DC 2.083333333333e-02
IPWR5466 0 nd5466 DC 2.083333333333e-02
IPWR5467 0 nd5467 DC 2.083333333333e-02
IPWR5468 0 nd5468 DC 2.083333333333e-02
IPWR5469 0 nd5469 DC 2.083333333333e-02
IPWR5470 0 nd5470 DC 2.083333333333e-02
IPWR5471 0 nd5471 DC 2.083333333333e-02
IPWR5472 0 nd5472 DC 1.041666666667e-02
IPWR5473 0 nd5473 DC 1.041666666667e-02
IPWR5475 0 nd5475 DC 1.182794147431e+00
IPWR5495 0 nd5495 DC 4.166666666667e-02
IPWR5496 0 nd5496 DC 2.083333333333e-02
IPWR5497 0 nd5497 DC 2.083333333333e-02
IPWR5498 0 nd5498 DC 2.083333333333e-02
IPWR5499 0 nd5499 DC 2.083333333333e-02
IPWR5500 0 nd5500 DC 2.083333333333e-02
IPWR5501 0 nd5501 DC 2.083333333333e-02
IPWR5502 0 nd5502 DC 2.083333333333e-02
IPWR5503 0 nd5503 DC 1.041666666667e-02
IPWR5504 0 nd5504 DC 1.041666666667e-02
IPWR5506 0 nd5506 DC 1.182794147431e+00
IPWR5537 0 nd5537 DC 1.235328445513e-01
IPWR5557 0 nd5557 DC 4.166666666667e-02
IPWR5558 0 nd5558 DC 2.083333333333e-02
IPWR5559 0 nd5559 DC 2.083333333333e-02
IPWR5560 0 nd5560 DC 2.083333333333e-02
IPWR5561 0 nd5561 DC 2.083333333333e-02
IPWR5562 0 nd5562 DC 2.083333333333e-02
IPWR5563 0 nd5563 DC 2.083333333333e-02
IPWR5564 0 nd5564 DC 2.083333333333e-02
IPWR5565 0 nd5565 DC 1.041666666667e-02
IPWR5566 0 nd5566 DC 1.041666666667e-02
IPWR5568 0 nd5568 DC 1.182794147431e+00
IPWR5588 0 nd5588 DC 4.166666666667e-02
IPWR5589 0 nd5589 DC 2.083333333333e-02
IPWR5590 0 nd5590 DC 2.083333333333e-02
IPWR5591 0 nd5591 DC 2.083333333333e-02
IPWR5592 0 nd5592 DC 2.083333333333e-02
IPWR5593 0 nd5593 DC 2.083333333333e-02
IPWR5594 0 nd5594 DC 2.083333333333e-02
IPWR5595 0 nd5595 DC 2.083333333333e-02
IPWR5596 0 nd5596 DC 1.041666666667e-02
IPWR5597 0 nd5597 DC 1.041666666667e-02
IPWR5599 0 nd5599 DC 1.182794147431e+00
IPWR5619 0 nd5619 DC 4.166666666667e-02
IPWR5620 0 nd5620 DC 2.083333333333e-02
IPWR5621 0 nd5621 DC 2.083333333333e-02
IPWR5622 0 nd5622 DC 2.083333333333e-02
IPWR5623 0 nd5623 DC 2.083333333333e-02
IPWR5624 0 nd5624 DC 2.083333333333e-02
IPWR5625 0 nd5625 DC 2.083333333333e-02
IPWR5626 0 nd5626 DC 2.083333333333e-02
IPWR5627 0 nd5627 DC 1.041666666667e-02
IPWR5628 0 nd5628 DC 1.041666666667e-02
IPWR5630 0 nd5630 DC 1.182794147431e+00
IPWR5650 0 nd5650 DC 4.166666666667e-02
IPWR5651 0 nd5651 DC 2.083333333333e-02
IPWR5652 0 nd5652 DC 2.083333333333e-02
IPWR5653 0 nd5653 DC 2.083333333333e-02
IPWR5654 0 nd5654 DC 2.083333333333e-02
IPWR5655 0 nd5655 DC 2.083333333333e-02
IPWR5656 0 nd5656 DC 2.083333333333e-02
IPWR5657 0 nd5657 DC 2.083333333333e-02
IPWR5658 0 nd5658 DC 1.041666666667e-02
IPWR5659 0 nd5659 DC 1.041666666667e-02
IPWR5661 0 nd5661 DC 1.182794147431e+00
IPWR5681 0 nd5681 DC 4.166666666667e-02
IPWR5682 0 nd5682 DC 2.083333333333e-02
IPWR5683 0 nd5683 DC 2.083333333333e-02
IPWR5684 0 nd5684 DC 2.083333333333e-02
IPWR5685 0 nd5685 DC 2.083333333333e-02
IPWR5686 0 nd5686 DC 2.083333333333e-02
IPWR5687 0 nd5687 DC 2.083333333333e-02
IPWR5688 0 nd5688 DC 2.083333333333e-02
IPWR5689 0 nd5689 DC 1.041666666667e-02
IPWR5690 0 nd5690 DC 1.041666666667e-02
IPWR5692 0 nd5692 DC 1.182794147431e+00
IPWR5712 0 nd5712 DC 4.166666666667e-02
IPWR5713 0 nd5713 DC 2.083333333333e-02
IPWR5714 0 nd5714 DC 2.083333333333e-02
IPWR5715 0 nd5715 DC 2.083333333333e-02
IPWR5716 0 nd5716 DC 2.083333333333e-02
IPWR5717 0 nd5717 DC 2.083333333333e-02
IPWR5718 0 nd5718 DC 2.083333333333e-02
IPWR5719 0 nd5719 DC 2.083333333333e-02
IPWR5720 0 nd5720 DC 1.041666666667e-02
IPWR5721 0 nd5721 DC 1.041666666667e-02
IPWR5723 0 nd5723 DC 1.182794147431e+00
IPWR5754 0 nd5754 DC 1.235328445513e-01
IPWR5785 0 nd5785 DC 9.081105291039e-01
IPWR5816 0 nd5816 DC 9.081105291039e-01
IPWR5847 0 nd5847 DC 9.081105291039e-01
IPWR5878 0 nd5878 DC 9.081105291039e-01
IPWR5909 0 nd5909 DC 9.081105291039e-01
IPWR5940 0 nd5940 DC 9.081105291039e-01
IPWR5971 0 nd5971 DC 1.235328445513e-01
IPWR5991 0 nd5991 DC 4.166666666667e-02
IPWR5992 0 nd5992 DC 2.083333333333e-02
IPWR5993 0 nd5993 DC 2.083333333333e-02
IPWR5994 0 nd5994 DC 2.083333333333e-02
IPWR5995 0 nd5995 DC 2.083333333333e-02
IPWR5996 0 nd5996 DC 2.083333333333e-02
IPWR5997 0 nd5997 DC 2.083333333333e-02
IPWR5998 0 nd5998 DC 2.083333333333e-02
IPWR5999 0 nd5999 DC 1.041666666667e-02
IPWR6000 0 nd6000 DC 1.041666666667e-02
IPWR6002 0 nd6002 DC 1.182794147431e+00
IPWR6022 0 nd6022 DC 4.166666666667e-02
IPWR6023 0 nd6023 DC 2.083333333333e-02
IPWR6024 0 nd6024 DC 2.083333333333e-02
IPWR6025 0 nd6025 DC 2.083333333333e-02
IPWR6026 0 nd6026 DC 2.083333333333e-02
IPWR6027 0 nd6027 DC 2.083333333333e-02
IPWR6028 0 nd6028 DC 2.083333333333e-02
IPWR6029 0 nd6029 DC 2.083333333333e-02
IPWR6030 0 nd6030 DC 1.041666666667e-02
IPWR6031 0 nd6031 DC 1.041666666667e-02
IPWR6033 0 nd6033 DC 1.182794147431e+00
IPWR6053 0 nd6053 DC 4.166666666667e-02
IPWR6054 0 nd6054 DC 2.083333333333e-02
IPWR6055 0 nd6055 DC 2.083333333333e-02
IPWR6056 0 nd6056 DC 2.083333333333e-02
IPWR6057 0 nd6057 DC 2.083333333333e-02
IPWR6058 0 nd6058 DC 2.083333333333e-02
IPWR6059 0 nd6059 DC 2.083333333333e-02
IPWR6060 0 nd6060 DC 2.083333333333e-02
IPWR6061 0 nd6061 DC 1.041666666667e-02
IPWR6062 0 nd6062 DC 1.041666666667e-02
IPWR6064 0 nd6064 DC 1.182794147431e+00
IPWR6084 0 nd6084 DC 4.166666666667e-02
IPWR6085 0 nd6085 DC 2.083333333333e-02
IPWR6086 0 nd6086 DC 2.083333333333e-02
IPWR6087 0 nd6087 DC 2.083333333333e-02
IPWR6088 0 nd6088 DC 2.083333333333e-02
IPWR6089 0 nd6089 DC 2.083333333333e-02
IPWR6090 0 nd6090 DC 2.083333333333e-02
IPWR6091 0 nd6091 DC 2.083333333333e-02
IPWR6092 0 nd6092 DC 1.041666666667e-02
IPWR6093 0 nd6093 DC 1.041666666667e-02
IPWR6095 0 nd6095 DC 1.182794147431e+00
IPWR6115 0 nd6115 DC 4.166666666667e-02
IPWR6116 0 nd6116 DC 2.083333333333e-02
IPWR6117 0 nd6117 DC 2.083333333333e-02
IPWR6118 0 nd6118 DC 2.083333333333e-02
IPWR6119 0 nd6119 DC 2.083333333333e-02
IPWR6120 0 nd6120 DC 2.083333333333e-02
IPWR6121 0 nd6121 DC 2.083333333333e-02
IPWR6122 0 nd6122 DC 2.083333333333e-02
IPWR6123 0 nd6123 DC 1.041666666667e-02
IPWR6124 0 nd6124 DC 1.041666666667e-02
IPWR6126 0 nd6126 DC 1.182794147431e+00
IPWR6146 0 nd6146 DC 4.166666666667e-02
IPWR6147 0 nd6147 DC 2.083333333333e-02
IPWR6148 0 nd6148 DC 2.083333333333e-02
IPWR6149 0 nd6149 DC 2.083333333333e-02
IPWR6150 0 nd6150 DC 2.083333333333e-02
IPWR6151 0 nd6151 DC 2.083333333333e-02
IPWR6152 0 nd6152 DC 2.083333333333e-02
IPWR6153 0 nd6153 DC 2.083333333333e-02
IPWR6154 0 nd6154 DC 1.041666666667e-02
IPWR6155 0 nd6155 DC 1.041666666667e-02
IPWR6157 0 nd6157 DC 1.182794147431e+00
IPWR6188 0 nd6188 DC 1.235328445513e-01
IPWR6208 0 nd6208 DC 4.166666666667e-02
IPWR6209 0 nd6209 DC 2.083333333333e-02
IPWR6210 0 nd6210 DC 2.083333333333e-02
IPWR6211 0 nd6211 DC 2.083333333333e-02
IPWR6212 0 nd6212 DC 2.083333333333e-02
IPWR6213 0 nd6213 DC 2.083333333333e-02
IPWR6214 0 nd6214 DC 2.083333333333e-02
IPWR6215 0 nd6215 DC 2.083333333333e-02
IPWR6216 0 nd6216 DC 1.041666666667e-02
IPWR6217 0 nd6217 DC 1.041666666667e-02
IPWR6219 0 nd6219 DC 1.182794147431e+00
IPWR6239 0 nd6239 DC 4.166666666667e-02
IPWR6240 0 nd6240 DC 2.083333333333e-02
IPWR6241 0 nd6241 DC 2.083333333333e-02
IPWR6242 0 nd6242 DC 2.083333333333e-02
IPWR6243 0 nd6243 DC 2.083333333333e-02
IPWR6244 0 nd6244 DC 2.083333333333e-02
IPWR6245 0 nd6245 DC 2.083333333333e-02
IPWR6246 0 nd6246 DC 2.083333333333e-02
IPWR6247 0 nd6247 DC 1.041666666667e-02
IPWR6248 0 nd6248 DC 1.041666666667e-02
IPWR6250 0 nd6250 DC 1.182794147431e+00
IPWR6270 0 nd6270 DC 4.166666666667e-02
IPWR6271 0 nd6271 DC 2.083333333333e-02
IPWR6272 0 nd6272 DC 2.083333333333e-02
IPWR6273 0 nd6273 DC 2.083333333333e-02
IPWR6274 0 nd6274 DC 2.083333333333e-02
IPWR6275 0 nd6275 DC 2.083333333333e-02
IPWR6276 0 nd6276 DC 2.083333333333e-02
IPWR6277 0 nd6277 DC 2.083333333333e-02
IPWR6278 0 nd6278 DC 1.041666666667e-02
IPWR6279 0 nd6279 DC 1.041666666667e-02
IPWR6281 0 nd6281 DC 1.182794147431e+00
IPWR6301 0 nd6301 DC 4.166666666667e-02
IPWR6302 0 nd6302 DC 2.083333333333e-02
IPWR6303 0 nd6303 DC 2.083333333333e-02
IPWR6304 0 nd6304 DC 2.083333333333e-02
IPWR6305 0 nd6305 DC 2.083333333333e-02
IPWR6306 0 nd6306 DC 2.083333333333e-02
IPWR6307 0 nd6307 DC 2.083333333333e-02
IPWR6308 0 nd6308 DC 2.083333333333e-02
IPWR6309 0 nd6309 DC 1.041666666667e-02
IPWR6310 0 nd6310 DC 1.041666666667e-02
IPWR6312 0 nd6312 DC 1.182794147431e+00
IPWR6332 0 nd6332 DC 4.166666666667e-02
IPWR6333 0 nd6333 DC 2.083333333333e-02
IPWR6334 0 nd6334 DC 2.083333333333e-02
IPWR6335 0 nd6335 DC 2.083333333333e-02
IPWR6336 0 nd6336 DC 2.083333333333e-02
IPWR6337 0 nd6337 DC 2.083333333333e-02
IPWR6338 0 nd6338 DC 2.083333333333e-02
IPWR6339 0 nd6339 DC 2.083333333333e-02
IPWR6340 0 nd6340 DC 1.041666666667e-02
IPWR6341 0 nd6341 DC 1.041666666667e-02
IPWR6343 0 nd6343 DC 1.182794147431e+00
IPWR6363 0 nd6363 DC 4.166666666667e-02
IPWR6364 0 nd6364 DC 2.083333333333e-02
IPWR6365 0 nd6365 DC 2.083333333333e-02
IPWR6366 0 nd6366 DC 2.083333333333e-02
IPWR6367 0 nd6367 DC 2.083333333333e-02
IPWR6368 0 nd6368 DC 2.083333333333e-02
IPWR6369 0 nd6369 DC 2.083333333333e-02
IPWR6370 0 nd6370 DC 2.083333333333e-02
IPWR6371 0 nd6371 DC 1.041666666667e-02
IPWR6372 0 nd6372 DC 1.041666666667e-02
IPWR6374 0 nd6374 DC 1.182794147431e+00
IPWR6405 0 nd6405 DC 1.235328445513e-01
IPWR6436 0 nd6436 DC 9.081105291039e-01
IPWR6467 0 nd6467 DC 9.081105291039e-01
IPWR6498 0 nd6498 DC 9.081105291039e-01
IPWR6529 0 nd6529 DC 9.081105291039e-01
IPWR6560 0 nd6560 DC 9.081105291039e-01
IPWR6591 0 nd6591 DC 9.081105291039e-01
IPWR6622 0 nd6622 DC 1.235328445513e-01
IPWR6642 0 nd6642 DC 4.166666666667e-02
IPWR6643 0 nd6643 DC 2.083333333333e-02
IPWR6644 0 nd6644 DC 2.083333333333e-02
IPWR6645 0 nd6645 DC 2.083333333333e-02
IPWR6646 0 nd6646 DC 2.083333333333e-02
IPWR6647 0 nd6647 DC 2.083333333333e-02
IPWR6648 0 nd6648 DC 2.083333333333e-02
IPWR6649 0 nd6649 DC 2.083333333333e-02
IPWR6650 0 nd6650 DC 1.041666666667e-02
IPWR6651 0 nd6651 DC 1.041666666667e-02
IPWR6653 0 nd6653 DC 1.182794147431e+00
IPWR6673 0 nd6673 DC 4.166666666667e-02
IPWR6674 0 nd6674 DC 2.083333333333e-02
IPWR6675 0 nd6675 DC 2.083333333333e-02
IPWR6676 0 nd6676 DC 2.083333333333e-02
IPWR6677 0 nd6677 DC 2.083333333333e-02
IPWR6678 0 nd6678 DC 2.083333333333e-02
IPWR6679 0 nd6679 DC 2.083333333333e-02
IPWR6680 0 nd6680 DC 2.083333333333e-02
IPWR6681 0 nd6681 DC 1.041666666667e-02
IPWR6682 0 nd6682 DC 1.041666666667e-02
IPWR6684 0 nd6684 DC 1.182794147431e+00
IPWR6704 0 nd6704 DC 4.166666666667e-02
IPWR6705 0 nd6705 DC 2.083333333333e-02
IPWR6706 0 nd6706 DC 2.083333333333e-02
IPWR6707 0 nd6707 DC 2.083333333333e-02
IPWR6708 0 nd6708 DC 2.083333333333e-02
IPWR6709 0 nd6709 DC 2.083333333333e-02
IPWR6710 0 nd6710 DC 2.083333333333e-02
IPWR6711 0 nd6711 DC 2.083333333333e-02
IPWR6712 0 nd6712 DC 1.041666666667e-02
IPWR6713 0 nd6713 DC 1.041666666667e-02
IPWR6715 0 nd6715 DC 1.182794147431e+00
IPWR6735 0 nd6735 DC 4.166666666667e-02
IPWR6736 0 nd6736 DC 2.083333333333e-02
IPWR6737 0 nd6737 DC 2.083333333333e-02
IPWR6738 0 nd6738 DC 2.083333333333e-02
IPWR6739 0 nd6739 DC 2.083333333333e-02
IPWR6740 0 nd6740 DC 2.083333333333e-02
IPWR6741 0 nd6741 DC 2.083333333333e-02
IPWR6742 0 nd6742 DC 2.083333333333e-02
IPWR6743 0 nd6743 DC 1.041666666667e-02
IPWR6744 0 nd6744 DC 1.041666666667e-02
IPWR6746 0 nd6746 DC 1.182794147431e+00
IPWR6766 0 nd6766 DC 4.166666666667e-02
IPWR6767 0 nd6767 DC 2.083333333333e-02
IPWR6768 0 nd6768 DC 2.083333333333e-02
IPWR6769 0 nd6769 DC 2.083333333333e-02
IPWR6770 0 nd6770 DC 2.083333333333e-02
IPWR6771 0 nd6771 DC 2.083333333333e-02
IPWR6772 0 nd6772 DC 2.083333333333e-02
IPWR6773 0 nd6773 DC 2.083333333333e-02
IPWR6774 0 nd6774 DC 1.041666666667e-02
IPWR6775 0 nd6775 DC 1.041666666667e-02
IPWR6777 0 nd6777 DC 1.182794147431e+00
IPWR6797 0 nd6797 DC 4.166666666667e-02
IPWR6798 0 nd6798 DC 2.083333333333e-02
IPWR6799 0 nd6799 DC 2.083333333333e-02
IPWR6800 0 nd6800 DC 2.083333333333e-02
IPWR6801 0 nd6801 DC 2.083333333333e-02
IPWR6802 0 nd6802 DC 2.083333333333e-02
IPWR6803 0 nd6803 DC 2.083333333333e-02
IPWR6804 0 nd6804 DC 2.083333333333e-02
IPWR6805 0 nd6805 DC 1.041666666667e-02
IPWR6806 0 nd6806 DC 1.041666666667e-02
IPWR6808 0 nd6808 DC 1.182794147431e+00
IPWR6839 0 nd6839 DC 1.235328445513e-01
IPWR6859 0 nd6859 DC 4.166666666667e-02
IPWR6860 0 nd6860 DC 2.083333333333e-02
IPWR6861 0 nd6861 DC 2.083333333333e-02
IPWR6862 0 nd6862 DC 2.083333333333e-02
IPWR6863 0 nd6863 DC 2.083333333333e-02
IPWR6864 0 nd6864 DC 2.083333333333e-02
IPWR6865 0 nd6865 DC 2.083333333333e-02
IPWR6866 0 nd6866 DC 2.083333333333e-02
IPWR6867 0 nd6867 DC 1.041666666667e-02
IPWR6868 0 nd6868 DC 1.041666666667e-02
IPWR6870 0 nd6870 DC 1.182794147431e+00
IPWR6890 0 nd6890 DC 4.166666666667e-02
IPWR6891 0 nd6891 DC 2.083333333333e-02
IPWR6892 0 nd6892 DC 2.083333333333e-02
IPWR6893 0 nd6893 DC 2.083333333333e-02
IPWR6894 0 nd6894 DC 2.083333333333e-02
IPWR6895 0 nd6895 DC 2.083333333333e-02
IPWR6896 0 nd6896 DC 2.083333333333e-02
IPWR6897 0 nd6897 DC 2.083333333333e-02
IPWR6898 0 nd6898 DC 1.041666666667e-02
IPWR6899 0 nd6899 DC 1.041666666667e-02
IPWR6901 0 nd6901 DC 1.182794147431e+00
IPWR6921 0 nd6921 DC 4.166666666667e-02
IPWR6922 0 nd6922 DC 2.083333333333e-02
IPWR6923 0 nd6923 DC 2.083333333333e-02
IPWR6924 0 nd6924 DC 2.083333333333e-02
IPWR6925 0 nd6925 DC 2.083333333333e-02
IPWR6926 0 nd6926 DC 2.083333333333e-02
IPWR6927 0 nd6927 DC 2.083333333333e-02
IPWR6928 0 nd6928 DC 2.083333333333e-02
IPWR6929 0 nd6929 DC 1.041666666667e-02
IPWR6930 0 nd6930 DC 1.041666666667e-02
IPWR6932 0 nd6932 DC 1.182794147431e+00
IPWR6952 0 nd6952 DC 4.166666666667e-02
IPWR6953 0 nd6953 DC 2.083333333333e-02
IPWR6954 0 nd6954 DC 2.083333333333e-02
IPWR6955 0 nd6955 DC 2.083333333333e-02
IPWR6956 0 nd6956 DC 2.083333333333e-02
IPWR6957 0 nd6957 DC 2.083333333333e-02
IPWR6958 0 nd6958 DC 2.083333333333e-02
IPWR6959 0 nd6959 DC 2.083333333333e-02
IPWR6960 0 nd6960 DC 1.041666666667e-02
IPWR6961 0 nd6961 DC 1.041666666667e-02
IPWR6963 0 nd6963 DC 1.182794147431e+00
IPWR6983 0 nd6983 DC 4.166666666667e-02
IPWR6984 0 nd6984 DC 2.083333333333e-02
IPWR6985 0 nd6985 DC 2.083333333333e-02
IPWR6986 0 nd6986 DC 2.083333333333e-02
IPWR6987 0 nd6987 DC 2.083333333333e-02
IPWR6988 0 nd6988 DC 2.083333333333e-02
IPWR6989 0 nd6989 DC 2.083333333333e-02
IPWR6990 0 nd6990 DC 2.083333333333e-02
IPWR6991 0 nd6991 DC 1.041666666667e-02
IPWR6992 0 nd6992 DC 1.041666666667e-02
IPWR6994 0 nd6994 DC 1.182794147431e+00
IPWR7014 0 nd7014 DC 4.166666666667e-02
IPWR7015 0 nd7015 DC 2.083333333333e-02
IPWR7016 0 nd7016 DC 2.083333333333e-02
IPWR7017 0 nd7017 DC 2.083333333333e-02
IPWR7018 0 nd7018 DC 2.083333333333e-02
IPWR7019 0 nd7019 DC 2.083333333333e-02
IPWR7020 0 nd7020 DC 2.083333333333e-02
IPWR7021 0 nd7021 DC 2.083333333333e-02
IPWR7022 0 nd7022 DC 1.041666666667e-02
IPWR7023 0 nd7023 DC 1.041666666667e-02
IPWR7025 0 nd7025 DC 1.182794147431e+00
IPWR7056 0 nd7056 DC 1.235328445513e-01
IPWR7087 0 nd7087 DC 9.081105291039e-01
IPWR7118 0 nd7118 DC 9.081105291039e-01
IPWR7149 0 nd7149 DC 9.081105291039e-01
IPWR7180 0 nd7180 DC 9.609368301716e-02
IPWR7211 0 nd7211 DC 9.609368301716e-02
IPWR7242 0 nd7242 DC 9.609368301716e-02
IPWR7273 0 nd7273 DC 1.307189557447e-02
IPWR7304 0 nd7304 DC 1.251599251799e-01
IPWR7335 0 nd7335 DC 1.251599251799e-01
IPWR7366 0 nd7366 DC 1.251599251799e-01
IPWR7397 0 nd7397 DC 1.251599251799e-01
IPWR7428 0 nd7428 DC 1.251599251799e-01
IPWR7459 0 nd7459 DC 1.251599251799e-01
IPWR7490 0 nd7490 DC 1.307189557447e-02
IPWR7521 0 nd7521 DC 1.251599251799e-01
IPWR7552 0 nd7552 DC 1.251599251799e-01
IPWR7583 0 nd7583 DC 1.251599251799e-01
IPWR7614 0 nd7614 DC 1.251599251799e-01
IPWR7645 0 nd7645 DC 1.251599251799e-01
IPWR7676 0 nd7676 DC 1.251599251799e-01
IPWR7707 0 nd7707 DC 1.307189557447e-02
IPWR7738 0 nd7738 DC 9.609368301716e-02
IPWR7769 0 nd7769 DC 9.609368301716e-02
IPWR7800 0 nd7800 DC 9.609368301716e-02
IPWR7831 0 nd7831 DC 9.081105291039e-01
IPWR7862 0 nd7862 DC 9.081105291039e-01
IPWR7893 0 nd7893 DC 9.081105291039e-01
IPWR7924 0 nd7924 DC 1.235328445513e-01
IPWR7944 0 nd7944 DC 4.166666666667e-02
IPWR7945 0 nd7945 DC 2.083333333333e-02
IPWR7946 0 nd7946 DC 2.083333333333e-02
IPWR7947 0 nd7947 DC 2.083333333333e-02
IPWR7948 0 nd7948 DC 2.083333333333e-02
IPWR7949 0 nd7949 DC 2.083333333333e-02
IPWR7950 0 nd7950 DC 2.083333333333e-02
IPWR7951 0 nd7951 DC 2.083333333333e-02
IPWR7952 0 nd7952 DC 1.041666666667e-02
IPWR7953 0 nd7953 DC 1.041666666667e-02
IPWR7955 0 nd7955 DC 1.182794147431e+00
IPWR7975 0 nd7975 DC 4.166666666667e-02
IPWR7976 0 nd7976 DC 2.083333333333e-02
IPWR7977 0 nd7977 DC 2.083333333333e-02
IPWR7978 0 nd7978 DC 2.083333333333e-02
IPWR7979 0 nd7979 DC 2.083333333333e-02
IPWR7980 0 nd7980 DC 2.083333333333e-02
IPWR7981 0 nd7981 DC 2.083333333333e-02
IPWR7982 0 nd7982 DC 2.083333333333e-02
IPWR7983 0 nd7983 DC 1.041666666667e-02
IPWR7984 0 nd7984 DC 1.041666666667e-02
IPWR7986 0 nd7986 DC 1.182794147431e+00
IPWR8006 0 nd8006 DC 4.166666666667e-02
IPWR8007 0 nd8007 DC 2.083333333333e-02
IPWR8008 0 nd8008 DC 2.083333333333e-02
IPWR8009 0 nd8009 DC 2.083333333333e-02
IPWR8010 0 nd8010 DC 2.083333333333e-02
IPWR8011 0 nd8011 DC 2.083333333333e-02
IPWR8012 0 nd8012 DC 2.083333333333e-02
IPWR8013 0 nd8013 DC 2.083333333333e-02
IPWR8014 0 nd8014 DC 1.041666666667e-02
IPWR8015 0 nd8015 DC 1.041666666667e-02
IPWR8017 0 nd8017 DC 1.182794147431e+00
IPWR8037 0 nd8037 DC 4.166666666667e-02
IPWR8038 0 nd8038 DC 2.083333333333e-02
IPWR8039 0 nd8039 DC 2.083333333333e-02
IPWR8040 0 nd8040 DC 2.083333333333e-02
IPWR8041 0 nd8041 DC 2.083333333333e-02
IPWR8042 0 nd8042 DC 2.083333333333e-02
IPWR8043 0 nd8043 DC 2.083333333333e-02
IPWR8044 0 nd8044 DC 2.083333333333e-02
IPWR8045 0 nd8045 DC 1.041666666667e-02
IPWR8046 0 nd8046 DC 1.041666666667e-02
IPWR8048 0 nd8048 DC 1.182794147431e+00
IPWR8068 0 nd8068 DC 4.166666666667e-02
IPWR8069 0 nd8069 DC 2.083333333333e-02
IPWR8070 0 nd8070 DC 2.083333333333e-02
IPWR8071 0 nd8071 DC 2.083333333333e-02
IPWR8072 0 nd8072 DC 2.083333333333e-02
IPWR8073 0 nd8073 DC 2.083333333333e-02
IPWR8074 0 nd8074 DC 2.083333333333e-02
IPWR8075 0 nd8075 DC 2.083333333333e-02
IPWR8076 0 nd8076 DC 1.041666666667e-02
IPWR8077 0 nd8077 DC 1.041666666667e-02
IPWR8079 0 nd8079 DC 1.182794147431e+00
IPWR8099 0 nd8099 DC 4.166666666667e-02
IPWR8100 0 nd8100 DC 2.083333333333e-02
IPWR8101 0 nd8101 DC 2.083333333333e-02
IPWR8102 0 nd8102 DC 2.083333333333e-02
IPWR8103 0 nd8103 DC 2.083333333333e-02
IPWR8104 0 nd8104 DC 2.083333333333e-02
IPWR8105 0 nd8105 DC 2.083333333333e-02
IPWR8106 0 nd8106 DC 2.083333333333e-02
IPWR8107 0 nd8107 DC 1.041666666667e-02
IPWR8108 0 nd8108 DC 1.041666666667e-02
IPWR8110 0 nd8110 DC 1.182794147431e+00
IPWR8141 0 nd8141 DC 1.235328445513e-01
IPWR8161 0 nd8161 DC 4.166666666667e-02
IPWR8162 0 nd8162 DC 2.083333333333e-02
IPWR8163 0 nd8163 DC 2.083333333333e-02
IPWR8164 0 nd8164 DC 2.083333333333e-02
IPWR8165 0 nd8165 DC 2.083333333333e-02
IPWR8166 0 nd8166 DC 2.083333333333e-02
IPWR8167 0 nd8167 DC 2.083333333333e-02
IPWR8168 0 nd8168 DC 2.083333333333e-02
IPWR8169 0 nd8169 DC 1.041666666667e-02
IPWR8170 0 nd8170 DC 1.041666666667e-02
IPWR8172 0 nd8172 DC 1.182794147431e+00
IPWR8192 0 nd8192 DC 4.166666666667e-02
IPWR8193 0 nd8193 DC 2.083333333333e-02
IPWR8194 0 nd8194 DC 2.083333333333e-02
IPWR8195 0 nd8195 DC 2.083333333333e-02
IPWR8196 0 nd8196 DC 2.083333333333e-02
IPWR8197 0 nd8197 DC 2.083333333333e-02
IPWR8198 0 nd8198 DC 2.083333333333e-02
IPWR8199 0 nd8199 DC 2.083333333333e-02
IPWR8200 0 nd8200 DC 1.041666666667e-02
IPWR8201 0 nd8201 DC 1.041666666667e-02
IPWR8203 0 nd8203 DC 1.182794147431e+00
IPWR8223 0 nd8223 DC 4.166666666667e-02
IPWR8224 0 nd8224 DC 2.083333333333e-02
IPWR8225 0 nd8225 DC 2.083333333333e-02
IPWR8226 0 nd8226 DC 2.083333333333e-02
IPWR8227 0 nd8227 DC 2.083333333333e-02
IPWR8228 0 nd8228 DC 2.083333333333e-02
IPWR8229 0 nd8229 DC 2.083333333333e-02
IPWR8230 0 nd8230 DC 2.083333333333e-02
IPWR8231 0 nd8231 DC 1.041666666667e-02
IPWR8232 0 nd8232 DC 1.041666666667e-02
IPWR8234 0 nd8234 DC 1.182794147431e+00
IPWR8254 0 nd8254 DC 4.166666666667e-02
IPWR8255 0 nd8255 DC 2.083333333333e-02
IPWR8256 0 nd8256 DC 2.083333333333e-02
IPWR8257 0 nd8257 DC 2.083333333333e-02
IPWR8258 0 nd8258 DC 2.083333333333e-02
IPWR8259 0 nd8259 DC 2.083333333333e-02
IPWR8260 0 nd8260 DC 2.083333333333e-02
IPWR8261 0 nd8261 DC 2.083333333333e-02
IPWR8262 0 nd8262 DC 1.041666666667e-02
IPWR8263 0 nd8263 DC 1.041666666667e-02
IPWR8265 0 nd8265 DC 1.182794147431e+00
IPWR8285 0 nd8285 DC 4.166666666667e-02
IPWR8286 0 nd8286 DC 2.083333333333e-02
IPWR8287 0 nd8287 DC 2.083333333333e-02
IPWR8288 0 nd8288 DC 2.083333333333e-02
IPWR8289 0 nd8289 DC 2.083333333333e-02
IPWR8290 0 nd8290 DC 2.083333333333e-02
IPWR8291 0 nd8291 DC 2.083333333333e-02
IPWR8292 0 nd8292 DC 2.083333333333e-02
IPWR8293 0 nd8293 DC 1.041666666667e-02
IPWR8294 0 nd8294 DC 1.041666666667e-02
IPWR8296 0 nd8296 DC 1.182794147431e+00
IPWR8316 0 nd8316 DC 4.166666666667e-02
IPWR8317 0 nd8317 DC 2.083333333333e-02
IPWR8318 0 nd8318 DC 2.083333333333e-02
IPWR8319 0 nd8319 DC 2.083333333333e-02
IPWR8320 0 nd8320 DC 2.083333333333e-02
IPWR8321 0 nd8321 DC 2.083333333333e-02
IPWR8322 0 nd8322 DC 2.083333333333e-02
IPWR8323 0 nd8323 DC 2.083333333333e-02
IPWR8324 0 nd8324 DC 1.041666666667e-02
IPWR8325 0 nd8325 DC 1.041666666667e-02
IPWR8327 0 nd8327 DC 1.182794147431e+00
IPWR8358 0 nd8358 DC 1.235328445513e-01
IPWR8389 0 nd8389 DC 9.081105291039e-01
IPWR8420 0 nd8420 DC 9.081105291039e-01
IPWR8451 0 nd8451 DC 9.081105291039e-01
IPWR8482 0 nd8482 DC 9.081105291039e-01
IPWR8513 0 nd8513 DC 9.081105291039e-01
IPWR8544 0 nd8544 DC 9.081105291039e-01
IPWR8575 0 nd8575 DC 1.235328445513e-01
IPWR8595 0 nd8595 DC 4.166666666667e-02
IPWR8596 0 nd8596 DC 2.083333333333e-02
IPWR8597 0 nd8597 DC 2.083333333333e-02
IPWR8598 0 nd8598 DC 2.083333333333e-02
IPWR8599 0 nd8599 DC 2.083333333333e-02
IPWR8600 0 nd8600 DC 2.083333333333e-02
IPWR8601 0 nd8601 DC 2.083333333333e-02
IPWR8602 0 nd8602 DC 2.083333333333e-02
IPWR8603 0 nd8603 DC 1.041666666667e-02
IPWR8604 0 nd8604 DC 1.041666666667e-02
IPWR8606 0 nd8606 DC 1.182794147431e+00
IPWR8626 0 nd8626 DC 4.166666666667e-02
IPWR8627 0 nd8627 DC 2.083333333333e-02
IPWR8628 0 nd8628 DC 2.083333333333e-02
IPWR8629 0 nd8629 DC 2.083333333333e-02
IPWR8630 0 nd8630 DC 2.083333333333e-02
IPWR8631 0 nd8631 DC 2.083333333333e-02
IPWR8632 0 nd8632 DC 2.083333333333e-02
IPWR8633 0 nd8633 DC 2.083333333333e-02
IPWR8634 0 nd8634 DC 1.041666666667e-02
IPWR8635 0 nd8635 DC 1.041666666667e-02
IPWR8637 0 nd8637 DC 1.182794147431e+00
IPWR8657 0 nd8657 DC 4.166666666667e-02
IPWR8658 0 nd8658 DC 2.083333333333e-02
IPWR8659 0 nd8659 DC 2.083333333333e-02
IPWR8660 0 nd8660 DC 2.083333333333e-02
IPWR8661 0 nd8661 DC 2.083333333333e-02
IPWR8662 0 nd8662 DC 2.083333333333e-02
IPWR8663 0 nd8663 DC 2.083333333333e-02
IPWR8664 0 nd8664 DC 2.083333333333e-02
IPWR8665 0 nd8665 DC 1.041666666667e-02
IPWR8666 0 nd8666 DC 1.041666666667e-02
IPWR8668 0 nd8668 DC 1.182794147431e+00
IPWR8688 0 nd8688 DC 4.166666666667e-02
IPWR8689 0 nd8689 DC 2.083333333333e-02
IPWR8690 0 nd8690 DC 2.083333333333e-02
IPWR8691 0 nd8691 DC 2.083333333333e-02
IPWR8692 0 nd8692 DC 2.083333333333e-02
IPWR8693 0 nd8693 DC 2.083333333333e-02
IPWR8694 0 nd8694 DC 2.083333333333e-02
IPWR8695 0 nd8695 DC 2.083333333333e-02
IPWR8696 0 nd8696 DC 1.041666666667e-02
IPWR8697 0 nd8697 DC 1.041666666667e-02
IPWR8699 0 nd8699 DC 1.182794147431e+00
IPWR8719 0 nd8719 DC 4.166666666667e-02
IPWR8720 0 nd8720 DC 2.083333333333e-02
IPWR8721 0 nd8721 DC 2.083333333333e-02
IPWR8722 0 nd8722 DC 2.083333333333e-02
IPWR8723 0 nd8723 DC 2.083333333333e-02
IPWR8724 0 nd8724 DC 2.083333333333e-02
IPWR8725 0 nd8725 DC 2.083333333333e-02
IPWR8726 0 nd8726 DC 2.083333333333e-02
IPWR8727 0 nd8727 DC 1.041666666667e-02
IPWR8728 0 nd8728 DC 1.041666666667e-02
IPWR8730 0 nd8730 DC 1.182794147431e+00
IPWR8750 0 nd8750 DC 4.166666666667e-02
IPWR8751 0 nd8751 DC 2.083333333333e-02
IPWR8752 0 nd8752 DC 2.083333333333e-02
IPWR8753 0 nd8753 DC 2.083333333333e-02
IPWR8754 0 nd8754 DC 2.083333333333e-02
IPWR8755 0 nd8755 DC 2.083333333333e-02
IPWR8756 0 nd8756 DC 2.083333333333e-02
IPWR8757 0 nd8757 DC 2.083333333333e-02
IPWR8758 0 nd8758 DC 1.041666666667e-02
IPWR8759 0 nd8759 DC 1.041666666667e-02
IPWR8761 0 nd8761 DC 1.182794147431e+00
IPWR8792 0 nd8792 DC 1.235328445513e-01
IPWR8812 0 nd8812 DC 4.166666666667e-02
IPWR8813 0 nd8813 DC 2.083333333333e-02
IPWR8814 0 nd8814 DC 2.083333333333e-02
IPWR8815 0 nd8815 DC 2.083333333333e-02
IPWR8816 0 nd8816 DC 2.083333333333e-02
IPWR8817 0 nd8817 DC 2.083333333333e-02
IPWR8818 0 nd8818 DC 2.083333333333e-02
IPWR8819 0 nd8819 DC 2.083333333333e-02
IPWR8820 0 nd8820 DC 1.041666666667e-02
IPWR8821 0 nd8821 DC 1.041666666667e-02
IPWR8823 0 nd8823 DC 1.182794147431e+00
IPWR8843 0 nd8843 DC 4.166666666667e-02
IPWR8844 0 nd8844 DC 2.083333333333e-02
IPWR8845 0 nd8845 DC 2.083333333333e-02
IPWR8846 0 nd8846 DC 2.083333333333e-02
IPWR8847 0 nd8847 DC 2.083333333333e-02
IPWR8848 0 nd8848 DC 2.083333333333e-02
IPWR8849 0 nd8849 DC 2.083333333333e-02
IPWR8850 0 nd8850 DC 2.083333333333e-02
IPWR8851 0 nd8851 DC 1.041666666667e-02
IPWR8852 0 nd8852 DC 1.041666666667e-02
IPWR8854 0 nd8854 DC 1.182794147431e+00
IPWR8874 0 nd8874 DC 4.166666666667e-02
IPWR8875 0 nd8875 DC 2.083333333333e-02
IPWR8876 0 nd8876 DC 2.083333333333e-02
IPWR8877 0 nd8877 DC 2.083333333333e-02
IPWR8878 0 nd8878 DC 2.083333333333e-02
IPWR8879 0 nd8879 DC 2.083333333333e-02
IPWR8880 0 nd8880 DC 2.083333333333e-02
IPWR8881 0 nd8881 DC 2.083333333333e-02
IPWR8882 0 nd8882 DC 1.041666666667e-02
IPWR8883 0 nd8883 DC 1.041666666667e-02
IPWR8885 0 nd8885 DC 1.182794147431e+00
IPWR8905 0 nd8905 DC 4.166666666667e-02
IPWR8906 0 nd8906 DC 2.083333333333e-02
IPWR8907 0 nd8907 DC 2.083333333333e-02
IPWR8908 0 nd8908 DC 2.083333333333e-02
IPWR8909 0 nd8909 DC 2.083333333333e-02
IPWR8910 0 nd8910 DC 2.083333333333e-02
IPWR8911 0 nd8911 DC 2.083333333333e-02
IPWR8912 0 nd8912 DC 2.083333333333e-02
IPWR8913 0 nd8913 DC 1.041666666667e-02
IPWR8914 0 nd8914 DC 1.041666666667e-02
IPWR8916 0 nd8916 DC 1.182794147431e+00
IPWR8936 0 nd8936 DC 4.166666666667e-02
IPWR8937 0 nd8937 DC 2.083333333333e-02
IPWR8938 0 nd8938 DC 2.083333333333e-02
IPWR8939 0 nd8939 DC 2.083333333333e-02
IPWR8940 0 nd8940 DC 2.083333333333e-02
IPWR8941 0 nd8941 DC 2.083333333333e-02
IPWR8942 0 nd8942 DC 2.083333333333e-02
IPWR8943 0 nd8943 DC 2.083333333333e-02
IPWR8944 0 nd8944 DC 1.041666666667e-02
IPWR8945 0 nd8945 DC 1.041666666667e-02
IPWR8947 0 nd8947 DC 1.182794147431e+00
IPWR8967 0 nd8967 DC 4.166666666667e-02
IPWR8968 0 nd8968 DC 2.083333333333e-02
IPWR8969 0 nd8969 DC 2.083333333333e-02
IPWR8970 0 nd8970 DC 2.083333333333e-02
IPWR8971 0 nd8971 DC 2.083333333333e-02
IPWR8972 0 nd8972 DC 2.083333333333e-02
IPWR8973 0 nd8973 DC 2.083333333333e-02
IPWR8974 0 nd8974 DC 2.083333333333e-02
IPWR8975 0 nd8975 DC 1.041666666667e-02
IPWR8976 0 nd8976 DC 1.041666666667e-02
IPWR8978 0 nd8978 DC 1.182794147431e+00
IPWR9009 0 nd9009 DC 1.235328445513e-01
IPWR9040 0 nd9040 DC 9.081105291039e-01
IPWR9071 0 nd9071 DC 9.081105291039e-01
IPWR9102 0 nd9102 DC 9.081105291039e-01
IPWR9133 0 nd9133 DC 9.081105291040e-01
IPWR9164 0 nd9164 DC 9.081105291040e-01
IPWR9195 0 nd9195 DC 9.081105291040e-01
IPWR9226 0 nd9226 DC 1.235328445513e-01
IPWR9246 0 nd9246 DC 4.166666666667e-02
IPWR9247 0 nd9247 DC 2.083333333333e-02
IPWR9248 0 nd9248 DC 2.083333333333e-02
IPWR9249 0 nd9249 DC 2.083333333333e-02
IPWR9250 0 nd9250 DC 2.083333333333e-02
IPWR9251 0 nd9251 DC 2.083333333333e-02
IPWR9252 0 nd9252 DC 2.083333333333e-02
IPWR9253 0 nd9253 DC 2.083333333333e-02
IPWR9254 0 nd9254 DC 1.041666666667e-02
IPWR9255 0 nd9255 DC 1.041666666667e-02
IPWR9257 0 nd9257 DC 1.182794147431e+00
IPWR9277 0 nd9277 DC 4.166666666667e-02
IPWR9278 0 nd9278 DC 2.083333333333e-02
IPWR9279 0 nd9279 DC 2.083333333333e-02
IPWR9280 0 nd9280 DC 2.083333333333e-02
IPWR9281 0 nd9281 DC 2.083333333333e-02
IPWR9282 0 nd9282 DC 2.083333333333e-02
IPWR9283 0 nd9283 DC 2.083333333333e-02
IPWR9284 0 nd9284 DC 2.083333333333e-02
IPWR9285 0 nd9285 DC 1.041666666667e-02
IPWR9286 0 nd9286 DC 1.041666666667e-02
IPWR9288 0 nd9288 DC 1.182794147431e+00
IPWR9308 0 nd9308 DC 4.166666666667e-02
IPWR9309 0 nd9309 DC 2.083333333333e-02
IPWR9310 0 nd9310 DC 2.083333333333e-02
IPWR9311 0 nd9311 DC 2.083333333333e-02
IPWR9312 0 nd9312 DC 2.083333333333e-02
IPWR9313 0 nd9313 DC 2.083333333333e-02
IPWR9314 0 nd9314 DC 2.083333333333e-02
IPWR9315 0 nd9315 DC 2.083333333333e-02
IPWR9316 0 nd9316 DC 1.041666666667e-02
IPWR9317 0 nd9317 DC 1.041666666667e-02
IPWR9319 0 nd9319 DC 1.182794147431e+00
IPWR9339 0 nd9339 DC 4.166666666667e-02
IPWR9340 0 nd9340 DC 2.083333333333e-02
IPWR9341 0 nd9341 DC 2.083333333333e-02
IPWR9342 0 nd9342 DC 2.083333333333e-02
IPWR9343 0 nd9343 DC 2.083333333333e-02
IPWR9344 0 nd9344 DC 2.083333333333e-02
IPWR9345 0 nd9345 DC 2.083333333333e-02
IPWR9346 0 nd9346 DC 2.083333333333e-02
IPWR9347 0 nd9347 DC 1.041666666667e-02
IPWR9348 0 nd9348 DC 1.041666666667e-02
IPWR9350 0 nd9350 DC 1.182794147431e+00
IPWR9370 0 nd9370 DC 4.166666666667e-02
IPWR9371 0 nd9371 DC 2.083333333333e-02
IPWR9372 0 nd9372 DC 2.083333333333e-02
IPWR9373 0 nd9373 DC 2.083333333333e-02
IPWR9374 0 nd9374 DC 2.083333333333e-02
IPWR9375 0 nd9375 DC 2.083333333333e-02
IPWR9376 0 nd9376 DC 2.083333333333e-02
IPWR9377 0 nd9377 DC 2.083333333333e-02
IPWR9378 0 nd9378 DC 1.041666666667e-02
IPWR9379 0 nd9379 DC 1.041666666667e-02
IPWR9381 0 nd9381 DC 1.182794147431e+00
IPWR9401 0 nd9401 DC 4.166666666667e-02
IPWR9402 0 nd9402 DC 2.083333333333e-02
IPWR9403 0 nd9403 DC 2.083333333333e-02
IPWR9404 0 nd9404 DC 2.083333333333e-02
IPWR9405 0 nd9405 DC 2.083333333333e-02
IPWR9406 0 nd9406 DC 2.083333333333e-02
IPWR9407 0 nd9407 DC 2.083333333333e-02
IPWR9408 0 nd9408 DC 2.083333333333e-02
IPWR9409 0 nd9409 DC 1.041666666667e-02
IPWR9410 0 nd9410 DC 1.041666666667e-02
IPWR9412 0 nd9412 DC 1.182794147431e+00
IPWR9443 0 nd9443 DC 1.235328445513e-01
IPWR9463 0 nd9463 DC 4.166666666667e-02
IPWR9464 0 nd9464 DC 2.083333333333e-02
IPWR9465 0 nd9465 DC 2.083333333333e-02
IPWR9466 0 nd9466 DC 2.083333333333e-02
IPWR9467 0 nd9467 DC 2.083333333333e-02
IPWR9468 0 nd9468 DC 2.083333333333e-02
IPWR9469 0 nd9469 DC 2.083333333333e-02
IPWR9470 0 nd9470 DC 2.083333333333e-02
IPWR9471 0 nd9471 DC 1.041666666667e-02
IPWR9472 0 nd9472 DC 1.041666666667e-02
IPWR9474 0 nd9474 DC 1.182794147431e+00
IPWR9494 0 nd9494 DC 4.166666666667e-02
IPWR9495 0 nd9495 DC 2.083333333333e-02
IPWR9496 0 nd9496 DC 2.083333333333e-02
IPWR9497 0 nd9497 DC 2.083333333333e-02
IPWR9498 0 nd9498 DC 2.083333333333e-02
IPWR9499 0 nd9499 DC 2.083333333333e-02
IPWR9500 0 nd9500 DC 2.083333333333e-02
IPWR9501 0 nd9501 DC 2.083333333333e-02
IPWR9502 0 nd9502 DC 1.041666666667e-02
IPWR9503 0 nd9503 DC 1.041666666667e-02
IPWR9505 0 nd9505 DC 1.182794147431e+00
IPWR9525 0 nd9525 DC 4.166666666667e-02
IPWR9526 0 nd9526 DC 2.083333333333e-02
IPWR9527 0 nd9527 DC 2.083333333333e-02
IPWR9528 0 nd9528 DC 2.083333333333e-02
IPWR9529 0 nd9529 DC 2.083333333333e-02
IPWR9530 0 nd9530 DC 2.083333333333e-02
IPWR9531 0 nd9531 DC 2.083333333333e-02
IPWR9532 0 nd9532 DC 2.083333333333e-02
IPWR9533 0 nd9533 DC 1.041666666667e-02
IPWR9534 0 nd9534 DC 1.041666666667e-02
IPWR9536 0 nd9536 DC 1.182794147431e+00
IPWR9556 0 nd9556 DC 4.166666666667e-02
IPWR9557 0 nd9557 DC 2.083333333333e-02
IPWR9558 0 nd9558 DC 2.083333333333e-02
IPWR9559 0 nd9559 DC 2.083333333333e-02
IPWR9560 0 nd9560 DC 2.083333333333e-02
IPWR9561 0 nd9561 DC 2.083333333333e-02
IPWR9562 0 nd9562 DC 2.083333333333e-02
IPWR9563 0 nd9563 DC 2.083333333333e-02
IPWR9564 0 nd9564 DC 1.041666666667e-02
IPWR9565 0 nd9565 DC 1.041666666667e-02
IPWR9567 0 nd9567 DC 1.182794147431e+00
IPWR9587 0 nd9587 DC 4.166666666667e-02
IPWR9588 0 nd9588 DC 2.083333333333e-02
IPWR9589 0 nd9589 DC 2.083333333333e-02
IPWR9590 0 nd9590 DC 2.083333333333e-02
IPWR9591 0 nd9591 DC 2.083333333333e-02
IPWR9592 0 nd9592 DC 2.083333333333e-02
IPWR9593 0 nd9593 DC 2.083333333333e-02
IPWR9594 0 nd9594 DC 2.083333333333e-02
IPWR9595 0 nd9595 DC 1.041666666667e-02
IPWR9596 0 nd9596 DC 1.041666666667e-02
IPWR9598 0 nd9598 DC 1.182794147431e+00
IPWR9618 0 nd9618 DC 4.166666666667e-02
IPWR9619 0 nd9619 DC 2.083333333333e-02
IPWR9620 0 nd9620 DC 2.083333333333e-02
IPWR9621 0 nd9621 DC 2.083333333333e-02
IPWR9622 0 nd9622 DC 2.083333333333e-02
IPWR9623 0 nd9623 DC 2.083333333333e-02
IPWR9624 0 nd9624 DC 2.083333333333e-02
IPWR9625 0 nd9625 DC 2.083333333333e-02
IPWR9626 0 nd9626 DC 1.041666666667e-02
IPWR9627 0 nd9627 DC 1.041666666667e-02
IPWR9629 0 nd9629 DC 1.182794147431e+00
IPWR9660 0 nd9660 DC 1.235328445513e-01
IPWR9691 0 nd9691 DC 9.081105291040e-01
IPWR9722 0 nd9722 DC 9.081105291040e-01
IPWR9753 0 nd9753 DC 9.081105291040e-01
IPWR9784 0 nd9784 DC 9.081105291039e-01
IPWR9815 0 nd9815 DC 9.081105291039e-01
IPWR9846 0 nd9846 DC 9.081105291039e-01
IPWR9877 0 nd9877 DC 1.235328445513e-01
IPWR9897 0 nd9897 DC 4.166666666667e-02
IPWR9898 0 nd9898 DC 2.083333333333e-02
IPWR9899 0 nd9899 DC 2.083333333333e-02
IPWR9900 0 nd9900 DC 2.083333333333e-02
IPWR9901 0 nd9901 DC 2.083333333333e-02
IPWR9902 0 nd9902 DC 2.083333333333e-02
IPWR9903 0 nd9903 DC 2.083333333333e-02
IPWR9904 0 nd9904 DC 2.083333333333e-02
IPWR9905 0 nd9905 DC 1.041666666667e-02
IPWR9906 0 nd9906 DC 1.041666666667e-02
IPWR9908 0 nd9908 DC 1.182794147431e+00
IPWR9928 0 nd9928 DC 4.166666666667e-02
IPWR9929 0 nd9929 DC 2.083333333333e-02
IPWR9930 0 nd9930 DC 2.083333333333e-02
IPWR9931 0 nd9931 DC 2.083333333333e-02
IPWR9932 0 nd9932 DC 2.083333333333e-02
IPWR9933 0 nd9933 DC 2.083333333333e-02
IPWR9934 0 nd9934 DC 2.083333333333e-02
IPWR9935 0 nd9935 DC 2.083333333333e-02
IPWR9936 0 nd9936 DC 1.041666666667e-02
IPWR9937 0 nd9937 DC 1.041666666667e-02
IPWR9939 0 nd9939 DC 1.182794147431e+00
IPWR9959 0 nd9959 DC 4.166666666667e-02
IPWR9960 0 nd9960 DC 2.083333333333e-02
IPWR9961 0 nd9961 DC 2.083333333333e-02
IPWR9962 0 nd9962 DC 2.083333333333e-02
IPWR9963 0 nd9963 DC 2.083333333333e-02
IPWR9964 0 nd9964 DC 2.083333333333e-02
IPWR9965 0 nd9965 DC 2.083333333333e-02
IPWR9966 0 nd9966 DC 2.083333333333e-02
IPWR9967 0 nd9967 DC 1.041666666667e-02
IPWR9968 0 nd9968 DC 1.041666666667e-02
IPWR9970 0 nd9970 DC 1.182794147431e+00
IPWR9990 0 nd9990 DC 4.166666666667e-02
IPWR9991 0 nd9991 DC 2.083333333333e-02
IPWR9992 0 nd9992 DC 2.083333333333e-02
IPWR9993 0 nd9993 DC 2.083333333333e-02
IPWR9994 0 nd9994 DC 2.083333333333e-02
IPWR9995 0 nd9995 DC 2.083333333333e-02
IPWR9996 0 nd9996 DC 2.083333333333e-02
IPWR9997 0 nd9997 DC 2.083333333333e-02
IPWR9998 0 nd9998 DC 1.041666666667e-02
IPWR9999 0 nd9999 DC 1.041666666667e-02
IPWR10001 0 nd10001 DC 1.182794147431e+00
IPWR10021 0 nd10021 DC 4.166666666667e-02
IPWR10022 0 nd10022 DC 2.083333333333e-02
IPWR10023 0 nd10023 DC 2.083333333333e-02
IPWR10024 0 nd10024 DC 2.083333333333e-02
IPWR10025 0 nd10025 DC 2.083333333333e-02
IPWR10026 0 nd10026 DC 2.083333333333e-02
IPWR10027 0 nd10027 DC 2.083333333333e-02
IPWR10028 0 nd10028 DC 2.083333333333e-02
IPWR10029 0 nd10029 DC 1.041666666667e-02
IPWR10030 0 nd10030 DC 1.041666666667e-02
IPWR10032 0 nd10032 DC 1.182794147431e+00
IPWR10052 0 nd10052 DC 4.166666666667e-02
IPWR10053 0 nd10053 DC 2.083333333333e-02
IPWR10054 0 nd10054 DC 2.083333333333e-02
IPWR10055 0 nd10055 DC 2.083333333333e-02
IPWR10056 0 nd10056 DC 2.083333333333e-02
IPWR10057 0 nd10057 DC 2.083333333333e-02
IPWR10058 0 nd10058 DC 2.083333333333e-02
IPWR10059 0 nd10059 DC 2.083333333333e-02
IPWR10060 0 nd10060 DC 1.041666666667e-02
IPWR10061 0 nd10061 DC 1.041666666667e-02
IPWR10063 0 nd10063 DC 1.182794147431e+00
IPWR10094 0 nd10094 DC 1.235328445513e-01
IPWR10114 0 nd10114 DC 4.166666666667e-02
IPWR10115 0 nd10115 DC 2.083333333333e-02
IPWR10116 0 nd10116 DC 2.083333333333e-02
IPWR10117 0 nd10117 DC 2.083333333333e-02
IPWR10118 0 nd10118 DC 2.083333333333e-02
IPWR10119 0 nd10119 DC 2.083333333333e-02
IPWR10120 0 nd10120 DC 2.083333333333e-02
IPWR10121 0 nd10121 DC 2.083333333333e-02
IPWR10122 0 nd10122 DC 1.041666666667e-02
IPWR10123 0 nd10123 DC 1.041666666667e-02
IPWR10125 0 nd10125 DC 1.182794147431e+00
IPWR10145 0 nd10145 DC 4.166666666667e-02
IPWR10146 0 nd10146 DC 2.083333333333e-02
IPWR10147 0 nd10147 DC 2.083333333333e-02
IPWR10148 0 nd10148 DC 2.083333333333e-02
IPWR10149 0 nd10149 DC 2.083333333333e-02
IPWR10150 0 nd10150 DC 2.083333333333e-02
IPWR10151 0 nd10151 DC 2.083333333333e-02
IPWR10152 0 nd10152 DC 2.083333333333e-02
IPWR10153 0 nd10153 DC 1.041666666667e-02
IPWR10154 0 nd10154 DC 1.041666666667e-02
IPWR10156 0 nd10156 DC 1.182794147431e+00
IPWR10176 0 nd10176 DC 4.166666666667e-02
IPWR10177 0 nd10177 DC 2.083333333333e-02
IPWR10178 0 nd10178 DC 2.083333333333e-02
IPWR10179 0 nd10179 DC 2.083333333333e-02
IPWR10180 0 nd10180 DC 2.083333333333e-02
IPWR10181 0 nd10181 DC 2.083333333333e-02
IPWR10182 0 nd10182 DC 2.083333333333e-02
IPWR10183 0 nd10183 DC 2.083333333333e-02
IPWR10184 0 nd10184 DC 1.041666666667e-02
IPWR10185 0 nd10185 DC 1.041666666667e-02
IPWR10187 0 nd10187 DC 1.182794147431e+00
IPWR10207 0 nd10207 DC 4.166666666667e-02
IPWR10208 0 nd10208 DC 2.083333333333e-02
IPWR10209 0 nd10209 DC 2.083333333333e-02
IPWR10210 0 nd10210 DC 2.083333333333e-02
IPWR10211 0 nd10211 DC 2.083333333333e-02
IPWR10212 0 nd10212 DC 2.083333333333e-02
IPWR10213 0 nd10213 DC 2.083333333333e-02
IPWR10214 0 nd10214 DC 2.083333333333e-02
IPWR10215 0 nd10215 DC 1.041666666667e-02
IPWR10216 0 nd10216 DC 1.041666666667e-02
IPWR10218 0 nd10218 DC 1.182794147431e+00
IPWR10238 0 nd10238 DC 4.166666666667e-02
IPWR10239 0 nd10239 DC 2.083333333333e-02
IPWR10240 0 nd10240 DC 2.083333333333e-02
IPWR10241 0 nd10241 DC 2.083333333333e-02
IPWR10242 0 nd10242 DC 2.083333333333e-02
IPWR10243 0 nd10243 DC 2.083333333333e-02
IPWR10244 0 nd10244 DC 2.083333333333e-02
IPWR10245 0 nd10245 DC 2.083333333333e-02
IPWR10246 0 nd10246 DC 1.041666666667e-02
IPWR10247 0 nd10247 DC 1.041666666667e-02
IPWR10249 0 nd10249 DC 1.182794147431e+00
IPWR10269 0 nd10269 DC 4.166666666667e-02
IPWR10270 0 nd10270 DC 2.083333333333e-02
IPWR10271 0 nd10271 DC 2.083333333333e-02
IPWR10272 0 nd10272 DC 2.083333333333e-02
IPWR10273 0 nd10273 DC 2.083333333333e-02
IPWR10274 0 nd10274 DC 2.083333333333e-02
IPWR10275 0 nd10275 DC 2.083333333333e-02
IPWR10276 0 nd10276 DC 2.083333333333e-02
IPWR10277 0 nd10277 DC 1.041666666667e-02
IPWR10278 0 nd10278 DC 1.041666666667e-02
IPWR10280 0 nd10280 DC 1.182794147431e+00
IPWR10311 0 nd10311 DC 1.235328445513e-01
IPWR10342 0 nd10342 DC 9.081105291039e-01
IPWR10373 0 nd10373 DC 9.081105291039e-01
IPWR10404 0 nd10404 DC 9.081105291039e-01
IPWR10435 0 nd10435 DC 9.609368301716e-02
IPWR10466 0 nd10466 DC 9.609368301716e-02
IPWR10497 0 nd10497 DC 9.609368301716e-02
IPWR10528 0 nd10528 DC 1.307189557447e-02
IPWR10559 0 nd10559 DC 1.251599251799e-01
IPWR10590 0 nd10590 DC 1.251599251799e-01
IPWR10621 0 nd10621 DC 1.251599251799e-01
IPWR10652 0 nd10652 DC 1.251599251799e-01
IPWR10683 0 nd10683 DC 1.251599251799e-01
IPWR10714 0 nd10714 DC 1.251599251799e-01
IPWR10745 0 nd10745 DC 1.307189557447e-02
IPWR10776 0 nd10776 DC 1.251599251799e-01
IPWR10807 0 nd10807 DC 1.251599251799e-01
IPWR10838 0 nd10838 DC 1.251599251799e-01
IPWR10869 0 nd10869 DC 1.251599251799e-01
IPWR10900 0 nd10900 DC 1.251599251799e-01
IPWR10931 0 nd10931 DC 1.251599251799e-01
IPWR10962 0 nd10962 DC 1.307189557447e-02
IPWR10993 0 nd10993 DC 9.609368301716e-02
IPWR11024 0 nd11024 DC 9.609368301716e-02
IPWR11055 0 nd11055 DC 9.609368301716e-02
IPWR11086 0 nd11086 DC 4.849776111614e-01
IPWR11117 0 nd11117 DC 4.849776111614e-01
IPWR11148 0 nd11148 DC 4.849776111614e-01
IPWR11179 0 nd11179 DC 6.597287657216e-02
IPWR11210 0 nd11210 DC 6.316727553887e-01
IPWR11241 0 nd11241 DC 6.316727553887e-01
IPWR11272 0 nd11272 DC 6.316727553887e-01
IPWR11303 0 nd11303 DC 6.316727553887e-01
IPWR11334 0 nd11334 DC 6.316727553887e-01
IPWR11365 0 nd11365 DC 6.316727553887e-01
IPWR11396 0 nd11396 DC 6.597287657216e-02
IPWR11427 0 nd11427 DC 6.316727553887e-01
IPWR11458 0 nd11458 DC 6.316727553887e-01
IPWR11489 0 nd11489 DC 6.316727553887e-01
IPWR11520 0 nd11520 DC 6.316727553887e-01
IPWR11551 0 nd11551 DC 6.316727553887e-01
IPWR11582 0 nd11582 DC 6.316727553887e-01
IPWR11613 0 nd11613 DC 6.597287657216e-02
IPWR11644 0 nd11644 DC 4.849776111614e-01
IPWR11675 0 nd11675 DC 4.849776111614e-01
IPWR11706 0 nd11706 DC 4.849776111614e-01
.end
